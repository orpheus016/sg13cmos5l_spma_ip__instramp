** sch_path: /foss/designs/Chipalooza/Programmable-Instrumentation-Amplifier-IP/designs/libs/core_digital/dec2to4/tb_dec2to4.sch
**.subckt tb_dec2to4
CL3 Y3 0 10f
CL2 Y2 0 10f
CL1 Y1 0 10f
CL0 Y0 0 10f
VDD net1 0 1.2
VA1 A1 0 PULSE(0 1.2 20n 100p 100p 20n 40n)
VA0 A0 0 PULSE(0 1.2 10n 100p 100p 10n 20n)
x1 A0 A1 Y0 Y1 Y2 Y3 net1 0 dec2to4
**** begin user architecture code

.lib cornerMOSlv.lib mos_tt
.include /foss/pdks/ihp-sg13cmos5l/libs.ref/sg13cmos5l_stdcell/spice/sg13cmos5l_stdcell.spice

.control
  tran 10p 50n
  write tb_dec2to4.raw

  * Multi-trace offset plots for clean verification
  plot v(A0) v(A1)+1.5 title 'Decoder Inputs (A0, A1)' xlabel 'Time (s)' ylabel 'Voltage (V)'
  plot v(Y0) v(Y1)+1.5 v(Y2)+3.0 v(Y3)+4.5 title 'Decoded Outputs (Y0..Y3)' xlabel 'Time (s)' ylabel 'Voltage (V)'
.endc

**** end user architecture code
**.ends

* expanding   symbol:  dec2to4.sym # of pins=8
** sym_path: /foss/designs/Chipalooza/Programmable-Instrumentation-Amplifier-IP/designs/libs/core_digital/dec2to4/dec2to4.sym
** sch_path: /foss/designs/Chipalooza/Programmable-Instrumentation-Amplifier-IP/designs/libs/core_digital/dec2to4/dec2to4.sch
.subckt dec2to4 A0 A1 Y0 Y1 Y2 Y3 VDD VSS
*.ipin A0
*.ipin A1
*.opin Y0
*.opin Y1
*.opin Y2
*.opin Y3
*.iopin VDD
*.iopin VSS
x1 net2 A0 VDD VSS sg13cmos5l_inv_1
x2 net1 A1 VDD VSS sg13cmos5l_inv_1
x11 Y0 net2 net1 VDD VSS sg13cmos5l_and2_1
x3 Y1 A0 net1 VDD VSS sg13cmos5l_and2_1
x4 Y2 A1 net2 VDD VSS sg13cmos5l_and2_1
x5 Y3 A1 A0 VDD VSS sg13cmos5l_and2_1
.ends

.end
