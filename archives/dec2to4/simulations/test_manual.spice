** Testbench for dec2to4

x1 A0 A1 Y0 Y1 Y2 Y3 VDD 0 dec2to4
CL3 Y3 0 10f
CL2 Y2 0 10f
CL1 Y1 0 10f
CL0 Y0 0 10f
VDD VDD 0 1.2
VA1 A1 0 PULSE(0 1.2 0 100p 100p 20n 40n)
VA0 A0 0 PULSE(0 1.2 0 100p 100p 10n 20n)

.lib /foss/pdks/ihp-sg13cmos5l/libs.tech/ngspice/models/cornerMOSlv.lib mos_tt
.include /foss/pdks/ihp-sg13cmos5l/libs.ref/sg13cmos5l_stdcell/spice/sg13cmos5l_stdcell.spice

.subckt dec2to4 A0 A1 Y0 Y1 Y2 Y3 VDD VSS
xinv0 A0_b A0 VDD VSS sg13cmos5l_inv_1
xinv1 A1_b A1 VDD VSS sg13cmos5l_inv_1
xand0 Y0 A0_b A1_b VDD VSS sg13cmos5l_and2_1
xand1 Y1 A0 A1_b VDD VSS sg13cmos5l_and2_1
xand2 Y2 A0_b A1 VDD VSS sg13cmos5l_and2_1
xand3 Y3 A0 A1 VDD VSS sg13cmos5l_and2_1
.ends

.control
  tran 10p 50n
  run
  print v(Y0)[500] v(Y1)[1500] v(Y2)[2500] v(Y3)[3500]
.endc
.end
