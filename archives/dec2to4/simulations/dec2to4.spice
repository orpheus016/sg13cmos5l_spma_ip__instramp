.include "/foss/pdks/ihp-sg13cmos5l/libs.ref/sg13cmos5l_stdcell/cdl/sg13cmos5l_stdcell.cdl"
** sch_path: /foss/designs/Chipalooza/Programmable-Instrumentation-Amplifier-IP/designs/libs/core_digital/dec2to4/dec2to4.sch
.subckt dec2to4 A0 A1 Y0 Y1 Y2 Y3 VDD VSS
*.PININFO A0:I A1:I Y0:O Y1:O Y2:O Y3:O VDD:B VSS:B
xinv1 net2 A0 VDD VSS sg13cmos5l_inv_1
xinv2 net1 A1 VDD VSS sg13cmos5l_inv_1
xand1 Y0 net2 net1 VDD VSS sg13cmos5l_and2_1
xand2 Y1 A0 net1 VDD VSS sg13cmos5l_and2_1
xand3 Y2 A1 net2 VDD VSS sg13cmos5l_and2_1
xand4 Y3 A1 A0 VDD VSS sg13cmos5l_and2_1
.ends
