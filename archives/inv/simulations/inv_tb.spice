** sch_path: /foss/designs/Chipalooza/Programmable-Instrumentation-Amplifier-IP/designs/inv_tb.sch
**.subckt inv_tb
V1 VDD 0 1.2
VIN IN 0 1.2
xinv1 VDD IN OUT 0 inv
* noconn OUT
**** begin user architecture code

.lib cornerMOSlv.lib mos_tt

.param temp=27
.control
save all

** Define Input Signals
let fsig = 1k
let tper = 1 / fsig
let tfr = 0.01 * tper
let ton = 0.5 * tper - 2 * tfr

** Define Transient Parameters
let tstop = 2 * tper
let tstep = 0.001 * tper

** Set Sources
alter @VIN[DC] = 0.0
alter @VIN[PULSE] = [ 0 1.2 0 $&tfr $&tfr $&ton $&tper 0 ]

** Simulations
op
dc VIN 0 1.2 0.01
tran $&tstep $&tstop

** Plots
setplot dc1
let vout = v(out)
plot vout

setplot tran1
let vout = v(out)
let vin = v(in)
let ivdd = v1#branch * 1e4
plot vout vin ivdd

setplot op1
write inv_tb.raw
.endc

**** end user architecture code
**.ends

* expanding   symbol:  inv.sym # of pins=4
** sym_path: /foss/designs/Chipalooza/Programmable-Instrumentation-Amplifier-IP/designs/inv.sym
** sch_path: /foss/designs/Chipalooza/Programmable-Instrumentation-Amplifier-IP/designs/inv.sch
.subckt inv VDD VI VO VSS
*.iopin VDD
*.iopin VSS
*.ipin VI
*.opin VO
XM1 VO VI VSS VSS sg13_lv_nmos w=0.15u l=0.13u ng=1 m=1 mm_ok=1
XM2 VO VI VDD VDD sg13_lv_pmos w=0.3u l=0.13u ng=1 m=1 mm_ok=1
.ends

.GLOBAL VDD
.end
