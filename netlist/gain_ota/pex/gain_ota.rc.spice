** post-layout RC netlist of gain_ota: Magic extresist -> ngspice by scripts/pex_netlist.py --magic (source: /foss/designs/sg13cmos5l_spma_ip__instramp/runs/pex/gain_ota/magic/raw.spice)
.subckt gain_ota VDD V_inp V_inn V_out I_bias VSS
X0 pn15 V_inn_t0 pn10_t9 VDD_t47 sg13_lv_pmos ad=1.2616p pd=7.02u as=2.2576p ps=13.96u w=6.64u l=2u
X1 VSS_t1 pn1_t0 VSS_t0 rhigh l=15u w=0.5u ps=0 b=0 m=1
X2 pn8_t0 pn3_t3 pn15_t0 VSS_t4 sg13_lv_nmos ad=2.1794p pd=13.5u as=2.1794p ps=13.5u w=6.41u l=2u
X3 pn13_t2 pn7_t2 pn2_t0 VDD_t46 sg13_lv_pmos ad=0.748p pd=5.08u as=0.748p ps=5.08u w=2.2u l=0.5u
X4 pn3_t1 pn3 pn1 VSS_t3 sg13_lv_nmos ad=0.544p pd=3.88u as=0.544p ps=3.88u w=1.6u l=2u
X5 VDD_t7 pn9_t5 pn14 VDD_t6 sg13_lv_pmos ad=1.564p pd=9.88u as=1.564p ps=9.88u w=4.6u l=2u
X6 V_out_t0 pn13_t5 VDD_t16 VDD_t17 sg13_lv_pmos ad=1.0545p pd=5.93u as=1.0545p ps=5.93u w=5.55u l=0.5u
X7 pn12_t1 V_inp_t0 pn10_t11 VDD_t47 sg13_lv_pmos ad=1.2616p pd=7.02u as=1.2616p ps=7.02u w=6.64u l=2u
X8 VDD_t43 pn16_t18 pn10_t12 VDD_t40 sg13_lv_pmos ad=2.5364p pd=15.6u as=2.5364p ps=15.6u w=7.46u l=2u
X9 VDD_t37 pn16_t22 pn10_t1 VDD_t36 sg13_lv_pmos ad=2.5364p pd=15.6u as=2.5364p ps=15.6u w=7.46u l=2u
X10 pn4_t2 pn4 VSS_t10 VSS_t9 sg13_lv_nmos ad=3.1314p pd=19.1u as=3.1314p ps=19.1u w=9.21u l=2u
X11 VDD_t27 pn16_t13 pn16_t14 VDD_t26 sg13_lv_pmos ad=2.5364p pd=15.6u as=2.5364p ps=15.6u w=7.46u l=2u
X12 VDD_t45 pn16_t16 pn10_t3 VDD_t40 sg13_lv_pmos ad=2.5364p pd=15.6u as=2.5364p ps=15.6u w=7.46u l=2u
X13 VDD_t16 pn13_t5 V_out_t1 VDD_t15 sg13_lv_pmos ad=1.0545p pd=5.93u as=1.0545p ps=5.93u w=5.55u l=0.5u
X14 pn14_t1 pn14_t0 pn6_t0 VSS_t7 sg13_lv_nmos ad=0.2856p pd=2.36u as=0.2856p ps=2.36u w=0.84u l=0.5u
X15 pn12_t2 pn4_t3 VSS_t14 VSS_t13 sg13_lv_nmos ad=3.1314p pd=19.1u as=3.1314p ps=19.1u w=9.21u l=2u
X16 pn4_t0 pn9_t3 VDD_t10 VDD_t2 sg13_lv_pmos ad=1.0925p pd=6.13u as=1.0925p ps=6.13u w=5.75u l=2u
X17 pn6_t1 pn6 VSS_t6 VSS_t5 sg13_lv_nmos ad=0.714p pd=4.88u as=0.714p ps=4.88u w=2.1u l=0.5u
X18 pn15_t1 V_inn_t0 pn10_t8 VDD_t47 sg13_lv_pmos ad=1.2616p pd=7.02u as=1.2616p ps=7.02u w=6.64u l=2u
X19 VDD_t20 pn16_t23 pn10_t5 VDD_t15 sg13_lv_pmos ad=2.5364p pd=15.6u as=2.5364p ps=15.6u w=7.46u l=2u
X20 pn10_t11 V_inp_t0 pn12 VDD_t47 sg13_lv_pmos ad=1.2616p pd=7.02u as=1.2616p ps=7.02u w=6.64u l=2u
X21 pn13_t4 pn14_t2 pn2_t1 VSS_t8 sg13_lv_nmos ad=0.2856p pd=2.36u as=0.2856p ps=2.36u w=0.84u l=0.5u
X22 pn12_t0 pn3_t2 pn13_t0 VSS_t4 sg13_lv_nmos ad=2.1794p pd=13.5u as=2.1794p ps=13.5u w=6.41u l=2u
X23 VDD_t29 pn16_t10 pn16_t11 VDD_t28 sg13_lv_pmos ad=2.5364p pd=15.6u as=2.5364p ps=15.6u w=7.46u l=2u
X24 VDD_t39 pn16_t21 pn10_t0 VDD_t38 sg13_lv_pmos ad=2.5364p pd=15.6u as=2.5364p ps=15.6u w=7.46u l=2u
X25 VDD_t41 pn16_t20 pn10_t6 VDD_t40 sg13_lv_pmos ad=2.5364p pd=15.6u as=2.5364p ps=15.6u w=7.46u l=2u
X26 VDD_t49 pn11_t1 pn11_t2 VDD_t48 sg13_lv_pmos ad=1.887p pd=11.78u as=1.887p ps=11.78u w=5.55u l=0.5u
X27 VDD_t52 pn8_t1 pn8_t2 VDD_t50 sg13_lv_pmos ad=2.4922p pd=15.34u as=2.4922p ps=15.34u w=7.33u l=2u
X28 pn2 I_bias_t2 VSS_t26 VSS_t25 sg13_lv_nmos ad=1.088p pd=7.08u as=1.088p ps=7.08u w=3.2u l=2u
X29 V_out_t2 pn2_t2 VSS_t16 VSS_t15 sg13_lv_nmos ad=2.856p pd=17.48u as=2.856p ps=17.48u w=8.4u l=0.5u
X30 VDD_t1 pn9_t0 pn9_t1 VDD_t0 sg13_lv_pmos ad=0.782p pd=5.28u as=0.782p ps=5.28u w=2.3u l=2u
X31 pn11_t0 pn7 pn7_t0 VDD_t0 sg13_lv_pmos ad=0.748p pd=5.08u as=0.748p ps=5.08u w=2.2u l=0.5u
X32 VSS_t22 I_bias_t0 I_bias_t1 VSS_t21 sg13_lv_nmos ad=0.2958p pd=2.42u as=0.2958p ps=2.42u w=0.87u l=2u
X33 VDD_t10 pn9_t3 pn4_t1 VDD_t2 sg13_lv_pmos ad=1.0925p pd=6.13u as=1.0925p ps=6.13u w=5.75u l=2u
X34 pn10_t10 V_inp_t0 pn12_t1 VDD_t47 sg13_lv_pmos ad=2.2576p pd=13.96u as=1.2616p ps=7.02u w=6.64u l=2u
X35 pn16_t15 I_bias_t3 VSS_t20 VSS_t19 sg13_lv_nmos ad=2.04p pd=12.68u as=2.04p ps=12.68u w=6u l=2u
X36 VDD_t33 pn16_t2 pn16_t3 VDD_t32 sg13_lv_pmos ad=2.5364p pd=15.6u as=2.5364p ps=15.6u w=7.46u l=2u
X37 VDD_t35 pn16_t6 pn16_t7 VDD_t34 sg13_lv_pmos ad=2.5364p pd=15.6u as=2.5364p ps=15.6u w=7.46u l=2u
X38 VDD_t3 pn9_t4 pn3_t0 VDD_t2 sg13_lv_pmos ad=1.955p pd=12.18u as=1.0925p ps=6.13u w=5.75u l=2u
X39 V_out_t1 pn13_t5 VDD_t14 VDD_t13 sg13_lv_pmos ad=1.0545p pd=5.93u as=1.887p ps=11.78u w=5.55u l=0.5u
X40 pn12 V_inp_t0 pn10 VDD_t47 sg13_lv_pmos ad=1.2616p pd=7.02u as=2.2576p ps=13.96u w=6.64u l=2u
X41 pn10_t8 V_inn_t0 pn15 VDD_t47 sg13_lv_pmos ad=1.2616p pd=7.02u as=1.2616p ps=7.02u w=6.64u l=2u
X42 pn9_t2 I_bias_t5 VSS_t18 VSS_t17 sg13_lv_nmos ad=0.2958p pd=2.42u as=0.2958p ps=2.42u w=0.87u l=2u
X43 VSS_t12 pn4_t4 pn15_t2 VSS_t11 sg13_lv_nmos ad=3.1314p pd=19.1u as=3.1314p ps=19.1u w=9.21u l=2u
X44 VDD_t5 pn9 pn13 VDD_t4 sg13_lv_pmos ad=3.1314p pd=19.1u as=3.1314p ps=19.1u w=9.21u l=2u
X45 VDD_t9 pn9_t3 pn4_t0 VDD_t2 sg13_lv_pmos ad=1.955p pd=12.18u as=1.0925p ps=6.13u w=5.75u l=2u
X46 VDD_t22 pn16_t12 pn16 VDD_t21 sg13_lv_pmos ad=2.5364p pd=15.6u as=2.5364p ps=15.6u w=7.46u l=2u
X47 pn7_t1 I_bias_t4 VSS_t24 VSS_t23 sg13_lv_nmos ad=0.5916p pd=4.16u as=0.5916p ps=4.16u w=1.74u l=2u
X48 pn4_t1 pn9_t3 VDD_t12 VDD_t2 sg13_lv_pmos ad=1.0925p pd=6.13u as=1.955p ps=12.18u w=5.75u l=2u
X49 VDD_t51 pn8 pn13_t3 VDD_t50 sg13_lv_pmos ad=2.4922p pd=15.34u as=2.4922p ps=15.34u w=7.33u l=2u
X50 VDD_t31 pn16_t4 pn16_t5 VDD_t30 sg13_lv_pmos ad=2.5364p pd=15.6u as=2.5364p ps=15.6u w=7.46u l=2u
X51 pn10_t7 V_inn_t0 pn15_t1 VDD_t47 sg13_lv_pmos ad=2.2576p pd=13.96u as=1.2616p ps=7.02u w=6.64u l=2u
X52 VDD_t24 pn16_t8 pn16_t9 VDD_t23 sg13_lv_pmos ad=2.5364p pd=15.6u as=2.5364p ps=15.6u w=7.46u l=2u
X53 VDD_t25 pn16_t0 pn16_t1 VDD_t0 sg13_lv_pmos ad=2.5364p pd=15.6u as=2.5364p ps=15.6u w=7.46u l=2u
X54 pn3_t0 pn9_t4 VDD_t8 VDD_t2 sg13_lv_pmos ad=1.0925p pd=6.13u as=1.955p ps=12.18u w=5.75u l=2u
X55 VDD_t42 pn16_t19 pn10_t4 VDD_t40 sg13_lv_pmos ad=2.5364p pd=15.6u as=2.5364p ps=15.6u w=7.46u l=2u
X56 VDD_t44 pn16_t17 pn10_t2 VDD_t40 sg13_lv_pmos ad=2.5364p pd=15.6u as=2.5364p ps=15.6u w=7.46u l=2u
X57 VDD_t19 pn13_t5 V_out_t0 VDD_t18 sg13_lv_pmos ad=1.887p pd=11.78u as=1.0545p ps=5.93u w=5.55u l=0.5u
X58 pn13_t1 pn5 VSS_t2 rhigh l=4u w=0.5u ps=0 b=0 m=1
R0 pn1 pn1_t0 51.8954
R1 pn6_n0 pn6_t0 17.8873
R2 pn6 pn6_n0 15.3273
R3 pn6_n0 pn6_t1 2.94632
R4 I_bias_n0 I_bias_t3 25.7258
R5 I_bias I_bias_n4 19.5088
R6 I_bias_t5 I_bias_t4 16.8947
R7 I_bias_t0 I_bias_t5 16.8903
R8 I_bias_t0 I_bias_n2 15.0005
R9 I_bias_t3 I_bias_t2 14.0016
R10 I_bias_n4 I_bias_n3 9.07096
R11 I_bias_n1 I_bias_n0 9.0005
R12 I_bias_n2 I_bias_t1 8.81129
R13 I_bias_n3 I_bias_t0 7.49231
R14 I_bias_n3 I_bias_n1 0.108892
R15 I_bias_n4 I_bias_n0 0.0389734
R16 I_bias_n2 I_bias_n1 0.0152561
R17 pn8_n0 pn8_t0 23.0359
R18 pn8 pn8_n1 5.15561
R19 pn8_n1 pn8_t1 4.56061
R20 pn8_n0 pn8_t2 1.82304
R21 pn8_n1 pn8_n0 0.5912
R22 pn12_n1 pn12_n0 21.5278
R23 pn12_n0 pn12_t0 3.90438
R24 pn12_n1 pn12_t1 3.54244
R25 pn12 pn12_n1 2.48315
R26 pn12_n0 pn12_t2 1.1655
R27 V_inp V_inp_n5 13.2663
R28 V_inp_n2 V_inp_t0 12.7904
R29 V_inp_n3 V_inp_n0 9.0912
R30 V_inp_n2 V_inp_n1 9.05697
R31 V_inp_n1 V_inp_n0 9.0137
R32 V_inp_n5 V_inp_n4 9.0005
R33 V_inp_n3 V_inp_n2 4.52153
R34 V_inp_n4 V_inp_n1 0.0775
R35 V_inp_n4 V_inp_n3 0.0388129
R36 V_inp_n5 V_inp_n0 0.00123333
R37 pn11_n1 pn11_n0 18.0734
R38 pn11_n0 pn11_t1 16.339
R39 pn11_n0 pn11_t2 0.703057
R40 pn11 pn11_n1 0.00240162
R41 pn11_n1 pn11_t0 0.00159825
R42 pn4_n2 pn4_n0 22.354
R43 pn4_n2 pn4_n1 14.2797
R44 pn4_n0 pn4_t3 6.97267
R45 pn4_n0 pn4_t4 6.15134
R46 pn4 pn4_n3 5.64783
R47 pn4_n1 pn4_t0 3.66235
R48 pn4_n1 pn4_t1 3.54172
R49 pn4_n3 pn4_n2 2.93391
R50 pn4_n3 pn4_t2 0.193751
R51 pn2_n1 pn2_t0 37.3573
R52 pn2 pn2_n1 35.7213
R53 pn2_n0 pn2_t2 24.0005
R54 pn2_n0 pn2_t1 13.562
R55 pn2_n1 pn2_n0 4.80997
R56 pn7_n0 pn7_t2 95.3284
R57 pn7_n1 pn7_n0 20.1156
R58 pn7_n0 pn7_t1 16.1539
R59 pn7 pn7_n1 15.0005
R60 pn7_n1 pn7_t0 3.64157
R61 V_out V_out_n1 125.079
R62 V_out_n1 V_out_n0 21.3188
R63 V_out_n0 V_out_t0 2.71287
R64 V_out_n1 V_out_t2 2.66594
R65 V_out_n0 V_out_t1 2.3409
R66 pn13 pn13_n4 44.5178
R67 pn13_n1 pn13_t4 27.6562
R68 pn13_n0 pn13_t1 24.3167
R69 pn13_n0 pn13_t0 23.4576
R70 pn13_n2 pn13_t3 21.8367
R71 pn13_n3 pn13_n2 20.8686
R72 pn13_n4 pn13_n3 19.9402
R73 pn13_n4 pn13_t5 11.401
R74 pn13_n3 pn13_t2 4.69053
R75 pn13_n2 pn13_n1 0.523367
R76 pn13_n1 pn13_n0 0.391367
R77 pn15_n0 pn15_t0 25.8127
R78 pn15_n1 pn15_n0 23.557
R79 pn15_n1 pn15_t1 2.66066
R80 pn15 pn15_n1 1.61005
R81 pn15_n0 pn15_t2 1.17712
R82 V_inn V_inn_n10 13.2084
R83 V_inn_n4 V_inn_n3 9.05448
R84 V_inn_n7 V_inn_n6 9.0476
R85 V_inn_n1 V_inn_n0 9.0335
R86 V_inn_n8 V_inn_n0 9.03277
R87 V_inn_n10 V_inn_n9 9.0005
R88 V_inn_n9 V_inn_n2 9.0005
R89 V_inn_n8 V_inn_n7 9.0005
R90 V_inn_n3 V_inn_n1 9.0005
R91 V_inn_n5 V_inn_n2 9.0005
R92 V_inn_n4 V_inn_t0 7.4777
R93 V_inn_n6 V_inn_t0 7.4777
R94 V_inn_n6 V_inn_n5 0.0971047
R95 V_inn_n5 V_inn_n4 0.0916048
R96 V_inn_n9 V_inn_n1 0.0775
R97 V_inn_n3 V_inn_n2 0.0775
R98 V_inn_n9 V_inn_n8 0.0767667
R99 V_inn_n7 V_inn_n2 0.0767667
R100 V_inn_n10 V_inn_n0 0.00196667
R101 pn3_n1 pn3_t0 47.2301
R102 pn3_n1 pn3_n0 37.4277
R103 pn3_n0 pn3_t2 6.78973
R104 pn3_n0 pn3_t3 6.47445
R105 pn3_n2 pn3_t1 4.23839
R106 pn3 pn3_n2 4.22391
R107 pn3_n2 pn3_n1 1.85858
R108 pn14 pn14_n1 65.8331
R109 pn14_n1 pn14_t2 63.1062
R110 pn14_n1 pn14_n0 23.8719
R111 pn14_n0 pn14_t0 15.2505
R112 pn14_n0 pn14_t1 8.50305
R113 pn9_n4 pn9_t2 25.9904
R114 pn9_n5 pn9_t5 15.4267
R115 pn9_n4 pn9_n3 12.9235
R116 pn9_n6 pn9_n5 9.44417
R117 pn9_n1 pn9_n0 9.07539
R118 pn9_n8 pn9_n1 9.05326
R119 pn9_n7 pn9_n6 9.0005
R120 pn9_t5 pn9_n2 7.16221
R121 pn9_n2 pn9_t3 5.80793
R122 pn9 pn9_n8 5.0034
R123 pn9 pn9_n0 4.99428
R124 pn9_n3 pn9_t1 3.79089
R125 pn9_n3 pn9_t0 2.48849
R126 pn9_n2 pn9_t4 2.46963
R127 pn9_n5 pn9_n4 0.648767
R128 pn9_n7 pn9_n0 0.108864
R129 pn9_n8 pn9_n7 0.0942444
R130 pn9_n6 pn9_n1 0.00343333
R131 pn10_n9 pn10_n8 15.89
R132 pn10_n10 pn10_n9 11.3042
R133 pn10_n10 pn10_t10 5.49407
R134 pn10 pn10_n10 5.49195
R135 pn10_n0 pn10_t7 5.40879
R136 pn10_n0 pn10_t9 5.40826
R137 pn10_n2 pn10_t3 4.1219
R138 pn10_n8 pn10_t5 2.26698
R139 pn10_n2 pn10_t2 2.13592
R140 pn10_n3 pn10_t12 2.13583
R141 pn10_n6 pn10_t0 2.13503
R142 pn10_n5 pn10_t6 2.13491
R143 pn10_n7 pn10_t1 2.13459
R144 pn10_n4 pn10_t4 2.13432
R145 pn10_n7 pn10_n6 1.98738
R146 pn10_n6 pn10_n5 1.98738
R147 pn10_n5 pn10_n4 1.98738
R148 pn10_n4 pn10_n3 1.98738
R149 pn10_n3 pn10_n2 1.98738
R150 pn10_n10 pn10_t11 1.72378
R151 pn10_n9 pn10_n1 1.64651
R152 pn10_n8 pn10_n7 1.38512
R153 pn10_n1 pn10_t8 1.17104
R154 pn10_n1 pn10_n0 0.400145
R155 pn16_n6 pn16_t15 48.9991
R156 pn16_n22 pn16_t12 4.95984
R157 pn16_t12 pn16_n21 4.95984
R158 pn16_n0 pn16_t7 4.12055
R159 pn16_n23 pn16_n5 3.81591
R160 pn16_n14 pn16_n13 3.36038
R161 pn16_n7 pn16_t16 3.20148
R162 pn16_n14 pn16_t6 2.42277
R163 pn16_n13 pn16_t23 2.42272
R164 pn16_n20 pn16_t8 2.41279
R165 pn16_n19 pn16_t0 2.41279
R166 pn16_n18 pn16_t13 2.41279
R167 pn16_n17 pn16_t10 2.41279
R168 pn16_n16 pn16_t4 2.41279
R169 pn16_n15 pn16_t2 2.41279
R170 pn16_n12 pn16_t22 2.41279
R171 pn16_n11 pn16_t21 2.41279
R172 pn16_n10 pn16_t20 2.41279
R173 pn16_n9 pn16_t19 2.41279
R174 pn16_n8 pn16_t18 2.41279
R175 pn16_n7 pn16_t17 2.41279
R176 pn16_n23 pn16_n22 2.37189
R177 pn16_n1 pn16_t5 2.13616
R178 pn16_n5 pn16_t9 2.13573
R179 pn16_n4 pn16_t1 2.13528
R180 pn16_n3 pn16_t14 2.13471
R181 pn16_n2 pn16_t11 2.13361
R182 pn16_n0 pn16_t3 2.1336
R183 pn16_n5 pn16_n4 1.98738
R184 pn16_n4 pn16_n3 1.98738
R185 pn16_n3 pn16_n2 1.98738
R186 pn16_n2 pn16_n1 1.98738
R187 pn16_n1 pn16_n0 1.98738
R188 pn16_n20 pn16_n19 0.790191
R189 pn16_n19 pn16_n18 0.790191
R190 pn16_n18 pn16_n17 0.790191
R191 pn16_n17 pn16_n16 0.790191
R192 pn16_n16 pn16_n15 0.790191
R193 pn16_n12 pn16_n11 0.790191
R194 pn16_n11 pn16_n10 0.790191
R195 pn16_n10 pn16_n9 0.790191
R196 pn16_n9 pn16_n8 0.790191
R197 pn16_n8 pn16_n7 0.790191
R198 pn16_n13 pn16_n12 0.778958
R199 pn16_n15 pn16_n14 0.777179
R200 pn16_n21 pn16_n20 0.65392
R201 pn16 pn16_n23 0.307615
R202 pn16_n22 pn16_n6 0.188087
R203 pn16_n21 pn16_n6 0.0942483
R204 VDD_n351 VDD_n0 17.0199
R205 VDD_n317 VDD_n14 17.0005
R206 VDD_n315 VDD_n14 17.0005
R207 VDD_n104 VDD_n14 17.0005
R208 VDD_n106 VDD_n14 17.0005
R209 VDD_n108 VDD_n14 17.0005
R210 VDD_n110 VDD_n14 17.0005
R211 VDD_t34 VDD_n14 17.0005
R212 VDD_n113 VDD_n14 17.0005
R213 VDD_n115 VDD_n14 17.0005
R214 VDD_n117 VDD_n14 17.0005
R215 VDD_t2 VDD_n14 17.0005
R216 VDD_n120 VDD_n14 17.0005
R217 VDD_n122 VDD_n14 17.0005
R218 VDD_n125 VDD_n14 17.0005
R219 VDD_n127 VDD_n14 17.0005
R220 VDD_n130 VDD_n14 17.0005
R221 VDD_n132 VDD_n14 17.0005
R222 VDD_n129 VDD_n14 17.0005
R223 VDD_n68 VDD_n14 17.0005
R224 VDD_n59 VDD_n14 17.0005
R225 VDD_t48 VDD_n14 17.0005
R226 VDD_n62 VDD_n14 17.0005
R227 VDD_n65 VDD_n14 17.0005
R228 VDD_t6 VDD_n14 17.0005
R229 VDD_t26 VDD_n14 17.0005
R230 VDD_n52 VDD_n14 17.0005
R231 VDD_n50 VDD_n14 17.0005
R232 VDD_n49 VDD_n14 17.0005
R233 VDD_t4 VDD_n14 17.0005
R234 VDD_n48 VDD_n14 17.0005
R235 VDD_n47 VDD_n14 17.0005
R236 VDD_n45 VDD_n14 17.0005
R237 VDD_n83 VDD_n13 17.0005
R238 VDD_n85 VDD_n13 17.0005
R239 VDD_n86 VDD_n13 17.0005
R240 VDD_n88 VDD_n13 17.0005
R241 VDD_t46 VDD_n163 17.0005
R242 VDD_n228 VDD_n163 17.0005
R243 VDD_n227 VDD_n163 17.0005
R244 VDD_t38 VDD_n163 17.0005
R245 VDD_n244 VDD_n163 17.0005
R246 VDD_n178 VDD_n163 17.0005
R247 VDD_n224 VDD_n163 17.0005
R248 VDD_n222 VDD_n163 17.0005
R249 VDD_n218 VDD_n163 17.0005
R250 VDD_n192 VDD_n163 17.0005
R251 VDD_n197 VDD_n163 17.0005
R252 VDD_t36 VDD_n163 17.0005
R253 VDD_t50 VDD_n163 17.0005
R254 VDD_n204 VDD_n163 17.0005
R255 VDD_t18 VDD_n163 17.0005
R256 VDD_n205 VDD_n163 17.0005
R257 VDD_t17 VDD_n163 17.0005
R258 VDD_n188 VDD_n163 17.0005
R259 VDD_n186 VDD_n163 17.0005
R260 VDD_t15 VDD_n163 17.0005
R261 VDD_n184 VDD_n163 17.0005
R262 VDD_t13 VDD_n163 17.0005
R263 VDD_n211 VDD_n163 17.0005
R264 VDD_n182 VDD_n163 17.0005
R265 VDD_n212 VDD_n163 17.0005
R266 VDD_n260 VDD_n156 17.0005
R267 VDD VDD_n351 14.1639
R268 VDD_n249 VDD_n248 8.61936
R269 VDD_n313 VDD_n312 8.61464
R270 VDD_t21 VDD_n0 8.501
R271 VDD_t21 VDD_n35 8.501
R272 VDD_t21 VDD_n34 8.501
R273 VDD_t21 VDD_n33 8.501
R274 VDD_t21 VDD_n32 8.501
R275 VDD_t21 VDD_n31 8.501
R276 VDD_t21 VDD_n30 8.501
R277 VDD_t21 VDD_n29 8.501
R278 VDD_t21 VDD_n28 8.501
R279 VDD_t21 VDD_n27 8.501
R280 VDD_t21 VDD_n26 8.501
R281 VDD_n257 VDD_n153 8.501
R282 VDD_n290 VDD_n265 8.501
R283 VDD_n289 VDD_n266 8.501
R284 VDD_t47 VDD_n298 8.501
R285 VDD_n284 VDD_n272 8.501
R286 VDD_n283 VDD_n271 8.501
R287 VDD_n276 VDD_n139 8.501
R288 VDD_n269 VDD_n139 8.501
R289 VDD_t28 VDD_n14 8.5005
R290 VDD_n63 VDD_n14 8.5005
R291 VDD_n89 VDD_n13 8.5005
R292 VDD_t23 VDD_n13 8.5005
R293 VDD_n39 VDD_n13 8.5005
R294 VDD_n172 VDD_n163 8.5005
R295 VDD_n214 VDD_n163 8.5005
R296 VDD_n299 VDD_n265 8.5005
R297 VDD_n299 VDD_n266 8.5005
R298 VDD_n299 VDD_t47 8.5005
R299 VDD_n299 VDD_n272 8.5005
R300 VDD_n299 VDD_n271 8.5005
R301 VDD_n48 VDD_n22 8.5005
R302 VDD_n216 VDD_n204 8.5005
R303 VDD_n216 VDD_t15 8.5005
R304 VDD_n216 VDD_n211 8.5005
R305 VDD_n320 VDD_t48 8.5005
R306 VDD_n320 VDD_n50 8.5005
R307 VDD_n320 VDD_n49 8.5005
R308 VDD_n320 VDD_n48 8.5005
R309 VDD_n320 VDD_n47 8.5005
R310 VDD_n320 VDD_n45 8.5005
R311 VDD_n90 VDD_n49 8.5005
R312 VDD_n90 VDD_n47 8.5005
R313 VDD_n90 VDD_n45 8.5005
R314 VDD_n90 VDD_n83 8.5005
R315 VDD_n90 VDD_n85 8.5005
R316 VDD_n90 VDD_n86 8.5005
R317 VDD_n90 VDD_n88 8.5005
R318 VDD_n68 VDD_n67 8.5005
R319 VDD_n67 VDD_n59 8.5005
R320 VDD_n67 VDD_n62 8.5005
R321 VDD_n67 VDD_n65 8.5005
R322 VDD_t4 VDD_n76 8.5005
R323 VDD_n242 VDD_n227 8.5005
R324 VDD_n242 VDD_n192 8.5005
R325 VDD_n242 VDD_t50 8.5005
R326 VDD_n242 VDD_n188 8.5005
R327 VDD_n242 VDD_n184 8.5005
R328 VDD_n242 VDD_n182 8.5005
R329 VDD_t46 VDD_n179 8.5005
R330 VDD_n228 VDD_n179 8.5005
R331 VDD_n244 VDD_n179 8.5005
R332 VDD_n197 VDD_n179 8.5005
R333 VDD_t36 VDD_n179 8.5005
R334 VDD_t18 VDD_n179 8.5005
R335 VDD_n205 VDD_n179 8.5005
R336 VDD_t17 VDD_n179 8.5005
R337 VDD_t13 VDD_n179 8.5005
R338 VDD_n212 VDD_n179 8.5005
R339 VDD_n350 VDD_n1 8.48401
R340 VDD_n340 VDD_n11 8.46995
R341 VDD_n341 VDD_n10 8.46995
R342 VDD_n342 VDD_n9 8.46995
R343 VDD_n343 VDD_n8 8.46995
R344 VDD_n345 VDD_n6 8.46995
R345 VDD_n346 VDD_n5 8.46995
R346 VDD_n347 VDD_n4 8.46995
R347 VDD_n348 VDD_n3 8.46995
R348 VDD_n349 VDD_n2 8.46995
R349 VDD_n256 VDD_n255 8.46995
R350 VDD_n292 VDD_n154 8.46995
R351 VDD_n293 VDD_n291 8.46995
R352 VDD_n297 VDD_n288 8.46995
R353 VDD_n286 VDD_n285 8.46995
R354 VDD_n278 VDD_n277 8.46995
R355 VDD_n17 VDD_n16 8.46995
R356 VDD_n320 VDD_n25 8.46995
R357 VDD_n287 VDD_n273 8.45904
R358 VDD_n344 VDD_n7 8.45088
R359 VDD_n327 VDD_t8 5.85684
R360 VDD_t21 VDD_n36 5.66778
R361 VDD_n162 VDD_n153 5.66778
R362 VDD_n160 VDD_n153 5.66778
R363 VDD_n158 VDD_n153 5.66778
R364 VDD_n259 VDD_n153 5.66778
R365 VDD_n296 VDD_n267 5.66778
R366 VDD_n281 VDD_n270 5.66778
R367 VDD_n275 VDD_n268 5.66778
R368 VDD_t0 VDD_n82 5.66767
R369 VDD_t32 VDD_n14 5.66717
R370 VDD_n241 VDD_n163 5.66717
R371 VDD_n299 VDD_n267 5.66717
R372 VDD_n299 VDD_n270 5.66717
R373 VDD_n299 VDD_n268 5.66717
R374 VDD_n339 VDD_n12 5.61281
R375 VDD_n253 VDD_n161 5.61281
R376 VDD_n254 VDD_n159 5.61281
R377 VDD_n258 VDD_n157 5.61281
R378 VDD_n295 VDD_n294 5.61281
R379 VDD_n282 VDD_n274 5.61281
R380 VDD_n280 VDD_n279 5.61281
R381 VDD_n18 VDD_n17 5.61281
R382 VDD_n99 VDD_n67 5.61281
R383 VDD_n136 VDD_t9 5.44388
R384 VDD_n136 VDD_n135 4.58862
R385 VDD_n61 VDD_n22 4.251
R386 VDD_n51 VDD_n22 4.251
R387 VDD_n79 VDD_n22 4.251
R388 VDD_n316 VDD_n20 4.251
R389 VDD_n105 VDD_n20 4.251
R390 VDD_n109 VDD_n20 4.251
R391 VDD_n112 VDD_n20 4.251
R392 VDD_n116 VDD_n20 4.251
R393 VDD_n119 VDD_n20 4.251
R394 VDD_n126 VDD_n20 4.251
R395 VDD_n131 VDD_n20 4.251
R396 VDD_n216 VDD_n198 4.251
R397 VDD_n216 VDD_n202 4.251
R398 VDD_n216 VDD_n206 4.251
R399 VDD_n216 VDD_n207 4.251
R400 VDD_n216 VDD_n209 4.251
R401 VDD_n216 VDD_n213 4.251
R402 VDD_n320 VDD_n56 4.251
R403 VDD_n320 VDD_n53 4.251
R404 VDD_n320 VDD_n43 4.251
R405 VDD_n320 VDD_n42 4.251
R406 VDD_n320 VDD_n40 4.251
R407 VDD_n246 VDD_n175 4.251
R408 VDD_n246 VDD_n176 4.251
R409 VDD_n319 VDD_n103 4.251
R410 VDD_n319 VDD_n107 4.251
R411 VDD_n319 VDD_n111 4.251
R412 VDD_n319 VDD_n114 4.251
R413 VDD_n319 VDD_n118 4.251
R414 VDD_n319 VDD_n121 4.251
R415 VDD_n319 VDD_n128 4.251
R416 VDD_n319 VDD_n133 4.251
R417 VDD_n90 VDD_n80 4.251
R418 VDD_n76 VDD_n74 4.251
R419 VDD_n84 VDD_n76 4.251
R420 VDD_n87 VDD_n76 4.251
R421 VDD_n303 VDD_n142 4.251
R422 VDD_n303 VDD_n143 4.251
R423 VDD_n303 VDD_n145 4.251
R424 VDD_n303 VDD_n146 4.251
R425 VDD_n303 VDD_n147 4.251
R426 VDD_n242 VDD_n229 4.251
R427 VDD_n243 VDD_n242 4.251
R428 VDD_n242 VDD_n219 4.251
R429 VDD_n242 VDD_n191 4.251
R430 VDD_n242 VDD_n190 4.251
R431 VDD_n242 VDD_n189 4.251
R432 VDD_n242 VDD_n185 4.251
R433 VDD_n242 VDD_n183 4.251
R434 VDD_n226 VDD_n179 4.251
R435 VDD_n223 VDD_n179 4.251
R436 VDD_n217 VDD_n179 4.251
R437 VDD_n203 VDD_n179 4.251
R438 VDD_n187 VDD_n179 4.251
R439 VDD_n208 VDD_n179 4.251
R440 VDD_n210 VDD_n179 4.251
R441 VDD_n320 VDD_t28 4.2505
R442 VDD_n90 VDD_t0 4.2505
R443 VDD_n90 VDD_n89 4.2505
R444 VDD_n67 VDD_n63 4.2505
R445 VDD_n179 VDD_n178 4.2505
R446 VDD_n90 VDD_n77 4.18423
R447 VDD_n305 VDD_t22 4.13301
R448 VDD_n165 VDD_t20 4.13259
R449 VDD_n78 VDD_t1 3.99681
R450 VDD_n199 VDD_t14 3.52652
R451 VDD_n199 VDD_t19 3.52621
R452 VDD_n64 VDD_n22 2.83444
R453 VDD_n320 VDD_n55 2.83444
R454 VDD_n320 VDD_n44 2.83444
R455 VDD_n67 VDD_n60 2.83444
R456 VDD_n81 VDD_n76 2.83444
R457 VDD_n303 VDD_n141 2.83444
R458 VDD_n303 VDD_n144 2.83444
R459 VDD_n303 VDD_n148 2.83444
R460 VDD_n303 VDD_n149 2.83444
R461 VDD_n242 VDD_n225 2.83444
R462 VDD_n58 VDD_n22 2.83433
R463 VDD_n320 VDD_n41 2.83433
R464 VDD_n246 VDD_n177 2.83433
R465 VDD_n301 VDD_n300 2.83428
R466 VDD_n98 VDD_t49 2.79945
R467 VDD_n329 VDD_n20 2.72834
R468 VDD_n216 VDD_n196 2.72387
R469 VDD_n338 VDD_n337 2.68983
R470 VDD_n23 VDD_t7 2.53453
R471 VDD_n199 VDD_t16 2.31631
R472 VDD_n97 VDD_n67 2.29499
R473 VDD_n136 VDD_t10 2.28129
R474 VDD_n308 VDD_t29 2.14672
R475 VDD_n171 VDD_t45 2.14664
R476 VDD_n167 VDD_t41 2.14657
R477 VDD_n166 VDD_t39 2.14656
R478 VDD_n305 VDD_t24 2.14618
R479 VDD_n311 VDD_t35 2.14615
R480 VDD_n309 VDD_t31 2.14593
R481 VDD_n306 VDD_t25 2.14592
R482 VDD_n310 VDD_t33 2.14583
R483 VDD_n168 VDD_t42 2.14565
R484 VDD_n165 VDD_t37 2.14558
R485 VDD_n170 VDD_t44 2.14558
R486 VDD_n307 VDD_t27 2.14556
R487 VDD_n169 VDD_t43 2.14554
R488 VDD_n319 VDD_n124 2.12619
R489 VDD_n66 VDD_n22 2.126
R490 VDD_n123 VDD_n20 2.126
R491 VDD_n320 VDD_n54 2.126
R492 VDD_t30 VDD_n14 2.1255
R493 VDD_n166 VDD_n165 1.98738
R494 VDD_n167 VDD_n166 1.98738
R495 VDD_n168 VDD_n167 1.98738
R496 VDD_n169 VDD_n168 1.98738
R497 VDD_n170 VDD_n169 1.98738
R498 VDD_n171 VDD_n170 1.98738
R499 VDD_n306 VDD_n305 1.98738
R500 VDD_n307 VDD_n306 1.98738
R501 VDD_n308 VDD_n307 1.98738
R502 VDD_n309 VDD_n308 1.98738
R503 VDD_n310 VDD_n309 1.98738
R504 VDD_n311 VDD_n310 1.98738
R505 VDD_n242 VDD_n221 1.97072
R506 VDD_n327 VDD_t3 1.96534
R507 VDD_n220 VDD_t52 1.94036
R508 VDD_n234 VDD_t51 1.94032
R509 VDD_n239 VDD_n238 1.93283
R510 VDD_n321 VDD_t5 1.8368
R511 VDD_n216 VDD_n201 1.71723
R512 VDD_n76 VDD_n73 1.7149
R513 VDD_n262 VDD_n261 1.60752
R514 VDD_n251 VDD_n250 1.53209
R515 VDD_n322 VDD_n321 1.52027
R516 VDD_n200 VDD_n193 1.51694
R517 VDD_n92 VDD_n91 1.51383
R518 VDD_n138 VDD_n137 1.50512
R519 VDD_n237 VDD_n180 1.50486
R520 VDD_n250 VDD_n249 1.46989
R521 VDD_n332 VDD_n331 1.45558
R522 VDD_n292 VDD_n155 1.43885
R523 VDD_n337 VDD_n336 1.43858
R524 VDD_n96 VDD_n72 1.43841
R525 VDD_n91 VDD_n78 1.42233
R526 VDD_n94 VDD_n93 1.41968
R527 VDD_n323 VDD_n322 1.41878
R528 VDD_n236 VDD_n230 1.41345
R529 VDD_n220 VDD_n180 1.40923
R530 VDD_n331 VDD_n330 1.38007
R531 VDD_n263 VDD_n155 1.37996
R532 VDD_n152 VDD_n151 1.36727
R533 VDD_n95 VDD_n94 1.36581
R534 VDD_n238 VDD_n173 1.36249
R535 VDD_n231 VDD_n152 1.35935
R536 VDD_n194 VDD_n173 1.35905
R537 VDD_n150 VDD_n138 1.35367
R538 VDD_n15 VDD_n14 1.34122
R539 VDD_n319 VDD_n70 1.34122
R540 VDD_n232 VDD_n230 1.33979
R541 VDD_n100 VDD_n72 1.3318
R542 VDD_n339 VDD_n338 1.32358
R543 VDD_n195 VDD_n193 1.31255
R544 VDD_n328 VDD_n19 1.31055
R545 VDD_n76 VDD_n75 1.30869
R546 VDD_n89 VDD_n76 1.30819
R547 VDD_n332 VDD_n19 1.30149
R548 VDD_n325 VDD_n324 1.29653
R549 VDD_n334 VDD_n333 1.28673
R550 VDD_n264 VDD_n16 1.27756
R551 VDD_n233 VDD_n232 1.25679
R552 VDD_n326 VDD_n325 1.24686
R553 VDD_n151 VDD_n140 1.23239
R554 VDD_n231 VDD_n140 1.22679
R555 VDD_n335 VDD_n334 1.22198
R556 VDD_n261 VDD_n153 1.21912
R557 VDD_n90 VDD_n50 1.21479
R558 VDD_n90 VDD_t23 1.21479
R559 VDD_n135 VDD_n134 1.20326
R560 VDD_n319 VDD_n71 1.19727
R561 VDD_n234 VDD_n233 1.18054
R562 VDD_n253 VDD_n252 1.16481
R563 VDD_t21 VDD_n37 1.13433
R564 VDD_n320 VDD_t30 1.13383
R565 VDD_n242 VDD_n241 1.13383
R566 VDD_n241 VDD_n179 1.13383
R567 VDD_n264 VDD_n263 1.07475
R568 VDD_n240 VDD_n239 1.07012
R569 VDD_n24 VDD_n23 1.06654
R570 VDD_n247 VDD_n246 1.0635
R571 VDD_n246 VDD_n245 1.0635
R572 VDD_n333 VDD_n332 1.02487
R573 VDD_n69 VDD_n22 1.001
R574 VDD_n46 VDD_n22 1.001
R575 VDD_n320 VDD_n38 1.001
R576 VDD_n214 VDD_n179 1.0005
R577 VDD_n324 VDD_n24 0.986331
R578 VDD_n235 VDD_n179 0.967806
R579 VDD_n246 VDD_n174 0.966768
R580 VDD_n252 VDD_n251 0.958261
R581 VDD_n137 VDD_n102 0.955165
R582 VDD_n330 VDD_n326 0.942375
R583 VDD_n326 VDD_n21 0.938845
R584 VDD_n240 VDD_n237 0.934976
R585 VDD_n102 VDD_n101 0.921589
R586 VDD_n242 VDD_n181 0.895676
R587 VDD_n23 VDD_n21 0.877505
R588 VDD_n235 VDD_n234 0.875268
R589 VDD_n135 VDD_t12 0.853083
R590 VDD_n96 VDD_n95 0.804875
R591 VDD_n249 VDD_n171 0.798
R592 VDD_n312 VDD_n311 0.798
R593 VDD_n324 VDD_n323 0.791125
R594 VDD_n314 VDD_n20 0.773227
R595 VDD_n232 VDD_n231 0.752167
R596 VDD_n263 VDD_n262 0.744833
R597 VDD_n251 VDD_n164 0.743
R598 VDD_n328 VDD_n327 0.743
R599 VDD_n134 VDD_n71 0.739166
R600 VDD_n236 VDD_n235 0.724239
R601 VDD_n319 VDD_n102 0.719769
R602 VDD_n22 VDD_n21 0.718395
R603 VDD_n218 VDD_n216 0.708833
R604 VDD_t30 VDD_n67 0.708833
R605 VDD_n67 VDD_t6 0.708833
R606 VDD_n150 VDD_n70 0.705804
R607 VDD_n134 VDD_n70 0.691425
R608 VDD_n238 VDD_n174 0.688891
R609 VDD_n194 VDD_n174 0.687
R610 VDD_n151 VDD_n150 0.656833
R611 VDD_n336 VDD_n335 0.656833
R612 VDD_n57 VDD_n20 0.654793
R613 VDD_n312 VDD_n15 0.643471
R614 VDD_n101 VDD_n71 0.632917
R615 VDD_n101 VDD_n100 0.6165
R616 VDD_n314 VDD_n313 0.61023
R617 VDD_n216 VDD_n215 0.608541
R618 VDD_n336 VDD_n15 0.607092
R619 VDD_n201 VDD_n164 0.600916
R620 VDD_n221 VDD_n220 0.570737
R621 VDD_n195 VDD_n194 0.554167
R622 VDD_n252 VDD_n163 0.548275
R623 VDD_n242 VDD_n240 0.541445
R624 VDD_n24 VDD_n22 0.541111
R625 VDD_n93 VDD_n92 0.529875
R626 VDD_n95 VDD_n73 0.493967
R627 VDD_n137 VDD_n136 0.48175
R628 VDD_n201 VDD_n200 0.481483
R629 VDD_n299 VDD_n153 0.472722
R630 VDD_n319 VDD_n318 0.448368
R631 VDD_n303 VDD_n302 0.448368
R632 VDD_n314 VDD_n17 0.447868
R633 VDD_t30 VDD_n319 0.447868
R634 VDD_n93 VDD_n73 0.440173
R635 VDD_n304 VDD_n303 0.42596
R636 VDD_n239 VDD_n221 0.421413
R637 VDD_n196 VDD_n195 0.409822
R638 VDD_n98 VDD_n97 0.405803
R639 VDD_n237 VDD_n236 0.403833
R640 VDD_n330 VDD_n329 0.396912
R641 VDD_n329 VDD_n328 0.395585
R642 VDD_n97 VDD_n96 0.394531
R643 VDD_n299 VDD_n264 0.378894
R644 VDD_n200 VDD_n199 0.378625
R645 VDD_n279 VDD_n274 0.374678
R646 VDD_n254 VDD_n253 0.374678
R647 VDD_n303 VDD_n140 0.344981
R648 VDD_n338 VDD_n13 0.320988
R649 VDD_n340 VDD_n339 0.312698
R650 VDD_n279 VDD_n278 0.312698
R651 VDD_n294 VDD_n288 0.312698
R652 VDD_n255 VDD_n254 0.312698
R653 VDD_n278 VDD_n18 0.312358
R654 VDD_n286 VDD_n274 0.312358
R655 VDD_n294 VDD_n293 0.312358
R656 VDD_n255 VDD_n157 0.312358
R657 VDD_n344 VDD_n343 0.288511
R658 VDD_n345 VDD_n344 0.288511
R659 VDD_n78 VDD_n77 0.279676
R660 VDD_n287 VDD_n286 0.272189
R661 VDD_n288 VDD_n287 0.272189
R662 VDD_n233 VDD_n179 0.267068
R663 VDD_n196 VDD_n164 0.262443
R664 VDD_n341 VDD_n340 0.250378
R665 VDD_n342 VDD_n341 0.250378
R666 VDD_n343 VDD_n342 0.250378
R667 VDD_n346 VDD_n345 0.250378
R668 VDD_n347 VDD_n346 0.250378
R669 VDD_n348 VDD_n347 0.250378
R670 VDD_n349 VDD_n348 0.250378
R671 VDD_n293 VDD_n292 0.250378
R672 VDD_n157 VDD_n156 0.250092
R673 VDD_n100 VDD_n99 0.250092
R674 VDD_n248 VDD_t40 0.249701
R675 VDD_n99 VDD_n98 0.231419
R676 VDD_n350 VDD_n349 0.222252
R677 VDD_n325 VDD_n22 0.205691
R678 VDD_n262 VDD_n156 0.193
R679 VDD_n246 VDD_n173 0.191084
R680 VDD_n323 VDD_n25 0.187772
R681 VDD_n335 VDD_n16 0.187772
R682 VDD_n333 VDD_n18 0.187759
R683 VDD_n321 VDD_n25 0.182272
R684 VDD_n92 VDD_n77 0.146176
R685 VDD_n334 VDD_n17 0.144596
R686 VDD_n20 VDD_n19 0.143444
R687 VDD_n94 VDD_n76 0.125664
R688 VDD_n299 VDD_n155 0.125147
R689 VDD_n230 VDD_n179 0.0810905
R690 VDD_n351 VDD_n350 0.069551
R691 VDD_n331 VDD_n20 0.0534423
R692 VDD_n91 VDD_n90 0.0416869
R693 VDD_n242 VDD_n180 0.0270412
R694 VDD_n72 VDD_n67 0.0260595
R695 VDD_n337 VDD_n14 0.0157345
R696 VDD_n216 VDD_n193 0.0112527
R697 VDD_n313 VDD_n14 0.00772326
R698 VDD_n319 VDD_n138 0.00674758
R699 VDD_n261 VDD_n260 0.00606123
R700 VDD_n250 VDD_n163 0.00402211
R701 VDD_n248 VDD_n163 0.00394628
R702 VDD_n322 VDD_n320 0.0027407
R703 VDD_n303 VDD_n152 0.00205444
R704 VDD_n304 VDD_n139 0.00194996
R705 VDD_n129 VDD_n57 0.00192304
R706 VDD_n212 VDD_n181 0.00189471
R707 VDD_n300 VDD_n154 0.00183333
R708 VDD_n123 VDD_n122 0.00175
R709 VDD_n83 VDD_n44 0.00166667
R710 VDD_n225 VDD_n224 0.00166667
R711 VDD_n81 VDD_n45 0.00166667
R712 VDD_n65 VDD_n64 0.00166667
R713 VDD_n62 VDD_n55 0.00166667
R714 VDD_n60 VDD_t48 0.00166667
R715 VDD_n149 VDD_n139 0.00166667
R716 VDD_n268 VDD_n148 0.00166667
R717 VDD_t47 VDD_n144 0.00166667
R718 VDD_n265 VDD_n141 0.00166667
R719 VDD_n36 VDD_n11 0.00166667
R720 VDD_n162 VDD_n161 0.00166667
R721 VDD_n277 VDD_n275 0.00166667
R722 VDD_n281 VDD_n280 0.00166667
R723 VDD_n297 VDD_n296 0.00166667
R724 VDD_n160 VDD_n159 0.00166667
R725 VDD_n256 VDD_n158 0.00166667
R726 VDD_n260 VDD_n259 0.00166667
R727 VDD_n125 VDD_n124 0.00162501
R728 VDD_n215 VDD_n153 0.00153574
R729 VDD_n215 VDD_n214 0.00146423
R730 VDD_n124 VDD_t32 0.00137497
R731 VDD_n36 VDD_n12 0.00133332
R732 VDD_n161 VDD_n160 0.00133332
R733 VDD_n159 VDD_n158 0.00133332
R734 VDD_n259 VDD_n258 0.00133332
R735 VDD_n296 VDD_n295 0.00133332
R736 VDD_n282 VDD_n281 0.00133332
R737 VDD_n280 VDD_n275 0.00133332
R738 VDD_n163 VDD_n162 0.00133332
R739 VDD_n64 VDD_n63 0.00133331
R740 VDD_n63 VDD_n55 0.00133331
R741 VDD_n60 VDD_t28 0.00133331
R742 VDD_t0 VDD_n81 0.00133331
R743 VDD_n301 VDD_n141 0.00133331
R744 VDD_n267 VDD_n144 0.00133331
R745 VDD_n270 VDD_n148 0.00133331
R746 VDD_n268 VDD_n149 0.00133331
R747 VDD_t0 VDD_n44 0.00133331
R748 VDD_n225 VDD_n178 0.00133331
R749 VDD_t32 VDD_n123 0.00124997
R750 VDD_n300 VDD_n299 0.00116665
R751 VDD_n214 VDD_n181 0.00110524
R752 VDD_t30 VDD_n57 0.00107691
R753 VDD_n314 VDD_n304 0.00104999
R754 VDD_n1 VDD_n0 0.001
R755 VDD_n37 VDD_n12 0.001
R756 VDD_n35 VDD_n10 0.001
R757 VDD_n34 VDD_n9 0.001
R758 VDD_n33 VDD_n8 0.001
R759 VDD_n32 VDD_n7 0.001
R760 VDD_n31 VDD_n6 0.001
R761 VDD_n30 VDD_n5 0.001
R762 VDD_n29 VDD_n4 0.001
R763 VDD_n28 VDD_n3 0.001
R764 VDD_n27 VDD_n2 0.001
R765 VDD_n26 VDD_n2 0.001
R766 VDD_n82 VDD_n14 0.001
R767 VDD_n82 VDD_n13 0.001
R768 VDD_n37 VDD_n13 0.001
R769 VDD_n35 VDD_n11 0.001
R770 VDD_n34 VDD_n10 0.001
R771 VDD_n33 VDD_n9 0.001
R772 VDD_n32 VDD_n8 0.001
R773 VDD_n31 VDD_n7 0.001
R774 VDD_n30 VDD_n6 0.001
R775 VDD_n29 VDD_n5 0.001
R776 VDD_n28 VDD_n4 0.001
R777 VDD_n27 VDD_n3 0.001
R778 VDD_n26 VDD_n1 0.001
R779 VDD_n258 VDD_n257 0.001
R780 VDD_n290 VDD_n154 0.001
R781 VDD_n291 VDD_n289 0.001
R782 VDD_n298 VDD_n297 0.001
R783 VDD_n284 VDD_n273 0.001
R784 VDD_n285 VDD_n283 0.001
R785 VDD_n277 VDD_n276 0.001
R786 VDD_n299 VDD_n269 0.001
R787 VDD_t30 VDD_n69 0.001
R788 VDD_n59 VDD_n58 0.001
R789 VDD_n61 VDD_t48 0.001
R790 VDD_n66 VDD_t26 0.001
R791 VDD_n51 VDD_n50 0.001
R792 VDD_n79 VDD_n49 0.001
R793 VDD_n47 VDD_n46 0.001
R794 VDD_n316 VDD_n315 0.001
R795 VDD_n105 VDD_n104 0.001
R796 VDD_n110 VDD_n109 0.001
R797 VDD_n112 VDD_t34 0.001
R798 VDD_n117 VDD_n116 0.001
R799 VDD_n119 VDD_t2 0.001
R800 VDD_n127 VDD_n126 0.001
R801 VDD_n132 VDD_n131 0.001
R802 VDD_n198 VDD_n197 0.001
R803 VDD_n202 VDD_t50 0.001
R804 VDD_n206 VDD_n205 0.001
R805 VDD_n207 VDD_n188 0.001
R806 VDD_n209 VDD_n184 0.001
R807 VDD_n213 VDD_n182 0.001
R808 VDD_n59 VDD_n56 0.001
R809 VDD_t6 VDD_n54 0.001
R810 VDD_t26 VDD_n53 0.001
R811 VDD_n85 VDD_n43 0.001
R812 VDD_n89 VDD_n42 0.001
R813 VDD_t23 VDD_n41 0.001
R814 VDD_n40 VDD_n39 0.001
R815 VDD_n39 VDD_n38 0.001
R816 VDD_n247 VDD_n172 0.001
R817 VDD_n175 VDD_n172 0.001
R818 VDD_t46 VDD_n176 0.001
R819 VDD_n228 VDD_n177 0.001
R820 VDD_n245 VDD_n244 0.001
R821 VDD_n318 VDD_n317 0.001
R822 VDD_n104 VDD_n103 0.001
R823 VDD_n107 VDD_n106 0.001
R824 VDD_t34 VDD_n111 0.001
R825 VDD_n115 VDD_n114 0.001
R826 VDD_n118 VDD_n117 0.001
R827 VDD_n121 VDD_n120 0.001
R828 VDD_n130 VDD_n128 0.001
R829 VDD_n133 VDD_n132 0.001
R830 VDD_n80 VDD_n48 0.001
R831 VDD_n75 VDD_n49 0.001
R832 VDD_n74 VDD_n48 0.001
R833 VDD_n84 VDD_n83 0.001
R834 VDD_n88 VDD_n87 0.001
R835 VDD_n302 VDD_n301 0.001
R836 VDD_n265 VDD_n142 0.001
R837 VDD_n267 VDD_n143 0.001
R838 VDD_n272 VDD_n145 0.001
R839 VDD_n272 VDD_n146 0.001
R840 VDD_n271 VDD_n147 0.001
R841 VDD_n229 VDD_n228 0.001
R842 VDD_n244 VDD_n243 0.001
R843 VDD_n219 VDD_n218 0.001
R844 VDD_t36 VDD_n191 0.001
R845 VDD_n204 VDD_n190 0.001
R846 VDD_t17 VDD_n189 0.001
R847 VDD_t15 VDD_n185 0.001
R848 VDD_n211 VDD_n183 0.001
R849 VDD_n226 VDD_t38 0.001
R850 VDD_n224 VDD_n223 0.001
R851 VDD_n218 VDD_n217 0.001
R852 VDD_n204 VDD_n203 0.001
R853 VDD_n188 VDD_n187 0.001
R854 VDD_n208 VDD_n184 0.001
R855 VDD_n210 VDD_n182 0.001
R856 VDD_n38 VDD_t21 0.001
R857 VDD_t23 VDD_n40 0.001
R858 VDD_n89 VDD_n41 0.001
R859 VDD_n88 VDD_n42 0.001
R860 VDD_n87 VDD_n86 0.001
R861 VDD_n86 VDD_n43 0.001
R862 VDD_n85 VDD_n84 0.001
R863 VDD_n46 VDD_n45 0.001
R864 VDD_n74 VDD_n47 0.001
R865 VDD_n80 VDD_t4 0.001
R866 VDD_t4 VDD_n79 0.001
R867 VDD_n75 VDD_n50 0.001
R868 VDD_n52 VDD_n51 0.001
R869 VDD_n53 VDD_n52 0.001
R870 VDD_t6 VDD_n66 0.001
R871 VDD_n65 VDD_n54 0.001
R872 VDD_n62 VDD_n61 0.001
R873 VDD_n58 VDD_t28 0.001
R874 VDD_n68 VDD_n56 0.001
R875 VDD_n69 VDD_n68 0.001
R876 VDD_n133 VDD_n129 0.001
R877 VDD_n131 VDD_n130 0.001
R878 VDD_n128 VDD_n127 0.001
R879 VDD_n126 VDD_n125 0.001
R880 VDD_n122 VDD_n121 0.001
R881 VDD_n120 VDD_n119 0.001
R882 VDD_t2 VDD_n118 0.001
R883 VDD_n116 VDD_n115 0.001
R884 VDD_n114 VDD_n113 0.001
R885 VDD_n113 VDD_n112 0.001
R886 VDD_n111 VDD_n110 0.001
R887 VDD_n109 VDD_n108 0.001
R888 VDD_n108 VDD_n107 0.001
R889 VDD_n106 VDD_n105 0.001
R890 VDD_n315 VDD_n103 0.001
R891 VDD_n317 VDD_n316 0.001
R892 VDD_n318 VDD_n314 0.001
R893 VDD_n270 VDD_n147 0.001
R894 VDD_n271 VDD_n146 0.001
R895 VDD_t47 VDD_n145 0.001
R896 VDD_n266 VDD_n143 0.001
R897 VDD_n266 VDD_n142 0.001
R898 VDD_n302 VDD_n153 0.001
R899 VDD_n213 VDD_n212 0.001
R900 VDD_n211 VDD_n210 0.001
R901 VDD_t13 VDD_n183 0.001
R902 VDD_n209 VDD_t13 0.001
R903 VDD_t15 VDD_n208 0.001
R904 VDD_n186 VDD_n185 0.001
R905 VDD_n187 VDD_n186 0.001
R906 VDD_n207 VDD_t17 0.001
R907 VDD_n205 VDD_n189 0.001
R908 VDD_n206 VDD_t18 0.001
R909 VDD_t18 VDD_n190 0.001
R910 VDD_n203 VDD_t50 0.001
R911 VDD_n202 VDD_t36 0.001
R912 VDD_n197 VDD_n191 0.001
R913 VDD_n198 VDD_n192 0.001
R914 VDD_n217 VDD_n192 0.001
R915 VDD_n222 VDD_n219 0.001
R916 VDD_n223 VDD_n222 0.001
R917 VDD_n245 VDD_n178 0.001
R918 VDD_n243 VDD_t38 0.001
R919 VDD_n227 VDD_n226 0.001
R920 VDD_n227 VDD_n177 0.001
R921 VDD_n229 VDD_t46 0.001
R922 VDD_n241 VDD_n176 0.001
R923 VDD_n241 VDD_n175 0.001
R924 VDD_t40 VDD_n247 0.001
R925 VDD_n269 VDD_n17 0.001
R926 VDD_n276 VDD_n17 0.001
R927 VDD_n283 VDD_n282 0.001
R928 VDD_n285 VDD_n284 0.001
R929 VDD_n298 VDD_n273 0.001
R930 VDD_n295 VDD_n289 0.001
R931 VDD_n291 VDD_n290 0.001
R932 VDD_n257 VDD_n256 0.001
R933 VSS_n539 VSS_t2 181876
R934 VSS_n663 VSS_t2 444.932
R935 VSS_n631 VSS_t0 230.394
R936 VSS_t0 VSS_n623 219.423
R937 VSS_n273 VSS_n70 67.0464
R938 VSS_n104 VSS_t4 60.3418
R939 VSS_t15 VSS_n215 39.009
R940 VSS_n148 VSS_n70 39.009
R941 VSS_n119 VSS_n71 39.009
R942 VSS_n118 VSS_n72 39.009
R943 VSS_n117 VSS_n73 39.009
R944 VSS_n116 VSS_n74 39.009
R945 VSS_n497 VSS_n403 36.571
R946 VSS_n463 VSS_n402 36.571
R947 VSS_n462 VSS_n401 36.571
R948 VSS_n461 VSS_n400 36.571
R949 VSS_n632 VSS_n240 35.352
R950 VSS_n236 VSS_n235 35.352
R951 VSS_n234 VSS_n233 35.352
R952 VSS_n232 VSS_n231 35.352
R953 VSS_n260 VSS_n230 35.352
R954 VSS_n76 VSS_t8 32.9139
R955 VSS_n415 VSS_n406 31.6949
R956 VSS_n414 VSS_n405 31.6949
R957 VSS_n228 VSS_n227 30.4759
R958 VSS_n226 VSS_n225 30.4759
R959 VSS_n224 VSS_n223 30.4759
R960 VSS_n222 VSS_n221 30.4759
R961 VSS_n220 VSS_n219 30.4759
R962 VSS_n258 VSS_n218 30.4759
R963 VSS_n546 VSS_n420 26.8189
R964 VSS_n533 VSS_n532 26.8189
R965 VSS_n510 VSS_n509 26.8189
R966 VSS_n508 VSS_n507 26.8189
R967 VSS_t3 VSS_n409 25.5998
R968 VSS_n350 VSS_n349 24.3808
R969 VSS_n348 VSS_n339 24.3808
R970 VSS_t17 VSS_n399 23.7713
R971 VSS_t9 VSS_n352 23.7713
R972 VSS_n395 VSS_n361 23.1618
R973 VSS_n581 VSS_n580 23.1618
R974 VSS_n359 VSS_n358 23.1618
R975 VSS_n394 VSS_n393 23.1618
R976 VSS_n392 VSS_n391 23.1618
R977 VSS_n390 VSS_n389 23.1618
R978 VSS_n388 VSS_n387 23.1618
R979 VSS_t23 VSS_n365 23.1618
R980 VSS_n596 VSS_n351 23.1618
R981 VSS_n175 VSS_n174 23.1618
R982 VSS_n173 VSS_n172 23.1618
R983 VSS_n171 VSS_n170 23.1618
R984 VSS_n169 VSS_n168 23.1618
R985 VSS_n241 VSS_n167 23.1618
R986 VSS_n265 VSS_n165 23.1618
R987 VSS_n164 VSS_n163 23.1618
R988 VSS_n162 VSS_n161 23.1618
R989 VSS_n160 VSS_n159 23.1618
R990 VSS_n158 VSS_n157 23.1618
R991 VSS_n156 VSS_n48 23.1618
R992 VSS_n683 VSS_n40 23.1618
R993 VSS_n443 VSS_n442 21.9428
R994 VSS_n441 VSS_n440 21.9428
R995 VSS_n480 VSS_n472 21.9428
R996 VSS_n607 VSS_n606 21.9428
R997 VSS_n609 VSS_n608 21.9428
R998 VSS_n327 VSS_n326 21.9428
R999 VSS_n310 VSS_n309 21.9428
R1000 VSS_n308 VSS_n301 21.9428
R1001 VSS_n318 VSS_n290 21.9428
R1002 VSS_n115 VSS_n77 21.9428
R1003 VSS_n114 VSS_n78 21.9428
R1004 VSS_n113 VSS_n79 21.9428
R1005 VSS_n645 VSS_n644 21.9428
R1006 VSS_n434 VSS_n433 20.7238
R1007 VSS_n432 VSS_n431 20.7238
R1008 VSS_n518 VSS_n517 20.7238
R1009 VSS_n446 VSS_n445 19.5048
R1010 VSS_n374 VSS_n331 19.5048
R1011 VSS_n606 VSS_n605 19.5048
R1012 VSS_n608 VSS_n607 19.5048
R1013 VSS_n621 VSS_n620 19.5048
R1014 VSS_n314 VSS_n289 19.5048
R1015 VSS_n316 VSS_n290 19.5048
R1016 VSS_n318 VSS_n291 19.5048
R1017 VSS_n115 VSS_n76 19.5048
R1018 VSS_n114 VSS_n77 19.5048
R1019 VSS_n113 VSS_n78 19.5048
R1020 VSS_n644 VSS_n79 19.5048
R1021 VSS_t4 VSS_n81 18.8953
R1022 VSS_n264 VSS_n217 18.6794
R1023 VSS_n444 VSS_n398 18.2857
R1024 VSS_n442 VSS_n397 18.2857
R1025 VSS_n440 VSS_n396 18.2857
R1026 VSS_n472 VSS_n395 18.2857
R1027 VSS_n580 VSS_n361 18.2857
R1028 VSS_n561 VSS_t23 18.2857
R1029 VSS_n351 VSS_n338 18.2857
R1030 VSS_n604 VSS_n331 18.2857
R1031 VSS_t11 VSS_n262 18.2857
R1032 VSS_n215 VSS_n175 18.2857
R1033 VSS_n174 VSS_n173 18.2857
R1034 VSS_n172 VSS_n171 18.2857
R1035 VSS_n170 VSS_n169 18.2857
R1036 VSS_n168 VSS_n167 18.2857
R1037 VSS_n242 VSS_n241 18.2857
R1038 VSS_t13 VSS_n265 18.2857
R1039 VSS_n165 VSS_n164 18.2857
R1040 VSS_n163 VSS_n162 18.2857
R1041 VSS_n161 VSS_n160 18.2857
R1042 VSS_n159 VSS_n158 18.2857
R1043 VSS_n157 VSS_n156 18.2857
R1044 VSS_n683 VSS_n48 18.2857
R1045 VSS_t19 VSS_n444 17.0667
R1046 VSS_n582 VSS_n581 17.0667
R1047 VSS_n358 VSS_n344 17.0667
R1048 VSS_n393 VSS_n342 17.0667
R1049 VSS_n391 VSS_n345 17.0667
R1050 VSS_n389 VSS_n341 17.0667
R1051 VSS_n387 VSS_n347 17.0667
R1052 VSS_n349 VSS_n340 17.0667
R1053 VSS_n350 VSS_n348 17.0667
R1054 VSS_n352 VSS_n339 17.0667
R1055 VSS_n532 VSS_n1 17.0005
R1056 VSS_n517 VSS_n417 17.0005
R1057 VSS_n431 VSS_n417 17.0005
R1058 VSS_n433 VSS_n417 17.0005
R1059 VSS_n417 VSS_n410 17.0005
R1060 VSS_n506 VSS_n417 17.0005
R1061 VSS_n508 VSS_n417 17.0005
R1062 VSS_n510 VSS_n417 17.0005
R1063 VSS_n532 VSS_n417 17.0005
R1064 VSS_n517 VSS_n1 17.0005
R1065 VSS_n431 VSS_n1 17.0005
R1066 VSS_n433 VSS_n1 17.0005
R1067 VSS_n508 VSS_n1 17.0005
R1068 VSS_n510 VSS_n1 17.0005
R1069 VSS_n295 VSS_n4 17.0005
R1070 VSS_n293 VSS_n4 17.0005
R1071 VSS_n292 VSS_n4 17.0005
R1072 VSS_n320 VSS_n4 17.0005
R1073 VSS_n318 VSS_n4 17.0005
R1074 VSS_n316 VSS_n4 17.0005
R1075 VSS_n314 VSS_n4 17.0005
R1076 VSS_n312 VSS_n4 17.0005
R1077 VSS_n620 VSS_n4 17.0005
R1078 VSS_n308 VSS_n4 17.0005
R1079 VSS_n309 VSS_n4 17.0005
R1080 VSS_n327 VSS_n4 17.0005
R1081 VSS_n608 VSS_n4 17.0005
R1082 VSS_n606 VSS_n4 17.0005
R1083 VSS_n331 VSS_n4 17.0005
R1084 VSS_n351 VSS_n4 17.0005
R1085 VSS_n352 VSS_n4 17.0005
R1086 VSS_n348 VSS_n4 17.0005
R1087 VSS_n349 VSS_n4 17.0005
R1088 VSS_t23 VSS_n4 17.0005
R1089 VSS_n387 VSS_n4 17.0005
R1090 VSS_n389 VSS_n4 17.0005
R1091 VSS_n391 VSS_n4 17.0005
R1092 VSS_n393 VSS_n4 17.0005
R1093 VSS_n358 VSS_n4 17.0005
R1094 VSS_n581 VSS_n4 17.0005
R1095 VSS_n361 VSS_n4 17.0005
R1096 VSS_n472 VSS_n4 17.0005
R1097 VSS_n440 VSS_n4 17.0005
R1098 VSS_n442 VSS_n4 17.0005
R1099 VSS_n444 VSS_n4 17.0005
R1100 VSS_n445 VSS_n4 17.0005
R1101 VSS_n295 VSS_n5 17.0005
R1102 VSS_n293 VSS_n5 17.0005
R1103 VSS_n292 VSS_n5 17.0005
R1104 VSS_n320 VSS_n5 17.0005
R1105 VSS_n318 VSS_n5 17.0005
R1106 VSS_n316 VSS_n5 17.0005
R1107 VSS_n314 VSS_n5 17.0005
R1108 VSS_n312 VSS_n5 17.0005
R1109 VSS_n620 VSS_n5 17.0005
R1110 VSS_n308 VSS_n5 17.0005
R1111 VSS_n309 VSS_n5 17.0005
R1112 VSS_n327 VSS_n5 17.0005
R1113 VSS_n608 VSS_n5 17.0005
R1114 VSS_n606 VSS_n5 17.0005
R1115 VSS_n331 VSS_n5 17.0005
R1116 VSS_n351 VSS_n5 17.0005
R1117 VSS_n352 VSS_n5 17.0005
R1118 VSS_n348 VSS_n5 17.0005
R1119 VSS_n349 VSS_n5 17.0005
R1120 VSS_t23 VSS_n5 17.0005
R1121 VSS_n387 VSS_n5 17.0005
R1122 VSS_n389 VSS_n5 17.0005
R1123 VSS_n391 VSS_n5 17.0005
R1124 VSS_n393 VSS_n5 17.0005
R1125 VSS_n358 VSS_n5 17.0005
R1126 VSS_n581 VSS_n5 17.0005
R1127 VSS_n361 VSS_n5 17.0005
R1128 VSS_n472 VSS_n5 17.0005
R1129 VSS_n440 VSS_n5 17.0005
R1130 VSS_n442 VSS_n5 17.0005
R1131 VSS_n444 VSS_n5 17.0005
R1132 VSS_n445 VSS_n5 17.0005
R1133 VSS_n275 VSS_n40 17.0005
R1134 VSS_n275 VSS_n48 17.0005
R1135 VSS_n275 VSS_n157 17.0005
R1136 VSS_n275 VSS_n159 17.0005
R1137 VSS_n275 VSS_n161 17.0005
R1138 VSS_n275 VSS_n163 17.0005
R1139 VSS_n275 VSS_n165 17.0005
R1140 VSS_n275 VSS_t13 17.0005
R1141 VSS_n275 VSS_n242 17.0005
R1142 VSS_n275 VSS_n167 17.0005
R1143 VSS_n275 VSS_n169 17.0005
R1144 VSS_n275 VSS_n171 17.0005
R1145 VSS_n275 VSS_n173 17.0005
R1146 VSS_n275 VSS_n175 17.0005
R1147 VSS_n275 VSS_n259 17.0005
R1148 VSS_n275 VSS_n218 17.0005
R1149 VSS_n275 VSS_n220 17.0005
R1150 VSS_n275 VSS_n222 17.0005
R1151 VSS_n275 VSS_n224 17.0005
R1152 VSS_n275 VSS_n226 17.0005
R1153 VSS_n275 VSS_n228 17.0005
R1154 VSS_n275 VSS_n263 17.0005
R1155 VSS_n275 VSS_n261 17.0005
R1156 VSS_n275 VSS_n230 17.0005
R1157 VSS_n275 VSS_n232 17.0005
R1158 VSS_n275 VSS_n234 17.0005
R1159 VSS_n275 VSS_n236 17.0005
R1160 VSS_n637 VSS_n48 17.0005
R1161 VSS_n637 VSS_n157 17.0005
R1162 VSS_n637 VSS_n159 17.0005
R1163 VSS_n637 VSS_n161 17.0005
R1164 VSS_n637 VSS_n163 17.0005
R1165 VSS_n637 VSS_n165 17.0005
R1166 VSS_n637 VSS_n167 17.0005
R1167 VSS_n637 VSS_n169 17.0005
R1168 VSS_n637 VSS_n171 17.0005
R1169 VSS_n637 VSS_n173 17.0005
R1170 VSS_n637 VSS_n175 17.0005
R1171 VSS_n637 VSS_n216 17.0005
R1172 VSS_n637 VSS_n218 17.0005
R1173 VSS_n637 VSS_n220 17.0005
R1174 VSS_n637 VSS_n222 17.0005
R1175 VSS_n637 VSS_n224 17.0005
R1176 VSS_n637 VSS_n226 17.0005
R1177 VSS_n637 VSS_n228 17.0005
R1178 VSS_n637 VSS_n230 17.0005
R1179 VSS_n637 VSS_n232 17.0005
R1180 VSS_n637 VSS_n234 17.0005
R1181 VSS_n637 VSS_n236 17.0005
R1182 VSS_n531 VSS_n432 17.0005
R1183 VSS_n531 VSS_n434 17.0005
R1184 VSS_n531 VSS_n504 17.0005
R1185 VSS_n531 VSS_n507 17.0005
R1186 VSS_n531 VSS_n509 17.0005
R1187 VSS_n533 VSS_n531 17.0005
R1188 VSS_n531 VSS_n420 17.0005
R1189 VSS_n534 VSS_n429 17.0005
R1190 VSS_n534 VSS_n432 17.0005
R1191 VSS_n534 VSS_n434 17.0005
R1192 VSS_n534 VSS_n504 17.0005
R1193 VSS_n534 VSS_n507 17.0005
R1194 VSS_n534 VSS_n509 17.0005
R1195 VSS_n534 VSS_n533 17.0005
R1196 VSS_n534 VSS_n420 17.0005
R1197 VSS_n469 VSS_n441 17.0005
R1198 VSS_n469 VSS_n443 17.0005
R1199 VSS_n469 VSS_n446 17.0005
R1200 VSS_n469 VSS_n460 17.0005
R1201 VSS_n469 VSS_n461 17.0005
R1202 VSS_n469 VSS_n462 17.0005
R1203 VSS_n469 VSS_n463 17.0005
R1204 VSS_n499 VSS_n438 17.0005
R1205 VSS_n499 VSS_n441 17.0005
R1206 VSS_n499 VSS_n443 17.0005
R1207 VSS_n499 VSS_n446 17.0005
R1208 VSS_n499 VSS_n460 17.0005
R1209 VSS_n499 VSS_n461 17.0005
R1210 VSS_n499 VSS_n462 17.0005
R1211 VSS_n499 VSS_n463 17.0005
R1212 VSS_n597 VSS_n338 17.0005
R1213 VSS_n597 VSS_n596 17.0005
R1214 VSS_n597 VSS_n339 17.0005
R1215 VSS_n597 VSS_n350 17.0005
R1216 VSS_n597 VSS_n340 17.0005
R1217 VSS_n597 VSS_n347 17.0005
R1218 VSS_n597 VSS_n341 17.0005
R1219 VSS_n597 VSS_n345 17.0005
R1220 VSS_n597 VSS_n342 17.0005
R1221 VSS_n597 VSS_n344 17.0005
R1222 VSS_n595 VSS_n338 17.0005
R1223 VSS_n596 VSS_n595 17.0005
R1224 VSS_n595 VSS_n339 17.0005
R1225 VSS_n595 VSS_n350 17.0005
R1226 VSS_n595 VSS_n340 17.0005
R1227 VSS_n595 VSS_n347 17.0005
R1228 VSS_n595 VSS_n341 17.0005
R1229 VSS_n595 VSS_n345 17.0005
R1230 VSS_n595 VSS_n342 17.0005
R1231 VSS_n595 VSS_n344 17.0005
R1232 VSS_n365 VSS_n360 17.0005
R1233 VSS_n388 VSS_n360 17.0005
R1234 VSS_n390 VSS_n360 17.0005
R1235 VSS_n392 VSS_n360 17.0005
R1236 VSS_n394 VSS_n360 17.0005
R1237 VSS_n360 VSS_n359 17.0005
R1238 VSS_n580 VSS_n360 17.0005
R1239 VSS_n395 VSS_n360 17.0005
R1240 VSS_n396 VSS_n360 17.0005
R1241 VSS_n397 VSS_n360 17.0005
R1242 VSS_n398 VSS_n360 17.0005
R1243 VSS_n399 VSS_n360 17.0005
R1244 VSS_n400 VSS_n360 17.0005
R1245 VSS_n401 VSS_n360 17.0005
R1246 VSS_n402 VSS_n360 17.0005
R1247 VSS_n403 VSS_n360 17.0005
R1248 VSS_n404 VSS_n360 17.0005
R1249 VSS_n405 VSS_n360 17.0005
R1250 VSS_n406 VSS_n360 17.0005
R1251 VSS_n407 VSS_n360 17.0005
R1252 VSS_n408 VSS_n360 17.0005
R1253 VSS_n409 VSS_n360 17.0005
R1254 VSS_n579 VSS_n365 17.0005
R1255 VSS_n579 VSS_n388 17.0005
R1256 VSS_n579 VSS_n390 17.0005
R1257 VSS_n579 VSS_n392 17.0005
R1258 VSS_n579 VSS_n394 17.0005
R1259 VSS_n579 VSS_n359 17.0005
R1260 VSS_n580 VSS_n579 17.0005
R1261 VSS_n579 VSS_n395 17.0005
R1262 VSS_n579 VSS_n396 17.0005
R1263 VSS_n579 VSS_n397 17.0005
R1264 VSS_n579 VSS_n398 17.0005
R1265 VSS_n579 VSS_n399 17.0005
R1266 VSS_n579 VSS_n400 17.0005
R1267 VSS_n579 VSS_n401 17.0005
R1268 VSS_n579 VSS_n402 17.0005
R1269 VSS_n579 VSS_n403 17.0005
R1270 VSS_n579 VSS_n404 17.0005
R1271 VSS_n579 VSS_n405 17.0005
R1272 VSS_n579 VSS_n406 17.0005
R1273 VSS_n579 VSS_n407 17.0005
R1274 VSS_n579 VSS_n408 17.0005
R1275 VSS_n579 VSS_n409 17.0005
R1276 VSS_n146 VSS_n113 17.0005
R1277 VSS_n146 VSS_n114 17.0005
R1278 VSS_n146 VSS_n115 17.0005
R1279 VSS_n146 VSS_n116 17.0005
R1280 VSS_n146 VSS_n117 17.0005
R1281 VSS_n146 VSS_n118 17.0005
R1282 VSS_n146 VSS_n119 17.0005
R1283 VSS_n642 VSS_n113 17.0005
R1284 VSS_n642 VSS_n114 17.0005
R1285 VSS_n642 VSS_n115 17.0005
R1286 VSS_n642 VSS_n116 17.0005
R1287 VSS_n642 VSS_n117 17.0005
R1288 VSS_n642 VSS_n118 17.0005
R1289 VSS_n642 VSS_n119 17.0005
R1290 VSS_n219 VSS_n8 17.0005
R1291 VSS_n221 VSS_n8 17.0005
R1292 VSS_n223 VSS_n8 17.0005
R1293 VSS_n225 VSS_n8 17.0005
R1294 VSS_n227 VSS_n8 17.0005
R1295 VSS_n262 VSS_n8 17.0005
R1296 VSS_n260 VSS_n8 17.0005
R1297 VSS_n231 VSS_n8 17.0005
R1298 VSS_n233 VSS_n8 17.0005
R1299 VSS_n235 VSS_n8 17.0005
R1300 VSS_n240 VSS_n8 17.0005
R1301 VSS_n219 VSS_n22 17.0005
R1302 VSS_n221 VSS_n22 17.0005
R1303 VSS_n223 VSS_n22 17.0005
R1304 VSS_n225 VSS_n22 17.0005
R1305 VSS_n227 VSS_n22 17.0005
R1306 VSS_n262 VSS_n22 17.0005
R1307 VSS_n260 VSS_n22 17.0005
R1308 VSS_n231 VSS_n22 17.0005
R1309 VSS_n233 VSS_n22 17.0005
R1310 VSS_n235 VSS_n22 17.0005
R1311 VSS_n240 VSS_n22 17.0005
R1312 VSS_n156 VSS_n37 17.0005
R1313 VSS_n158 VSS_n37 17.0005
R1314 VSS_n160 VSS_n37 17.0005
R1315 VSS_n162 VSS_n37 17.0005
R1316 VSS_n164 VSS_n37 17.0005
R1317 VSS_n265 VSS_n37 17.0005
R1318 VSS_n241 VSS_n37 17.0005
R1319 VSS_n168 VSS_n37 17.0005
R1320 VSS_n170 VSS_n37 17.0005
R1321 VSS_n172 VSS_n37 17.0005
R1322 VSS_n174 VSS_n37 17.0005
R1323 VSS_n156 VSS_n55 17.0005
R1324 VSS_n158 VSS_n55 17.0005
R1325 VSS_n160 VSS_n55 17.0005
R1326 VSS_n162 VSS_n55 17.0005
R1327 VSS_n164 VSS_n55 17.0005
R1328 VSS_n265 VSS_n55 17.0005
R1329 VSS_n241 VSS_n55 17.0005
R1330 VSS_n168 VSS_n55 17.0005
R1331 VSS_n170 VSS_n55 17.0005
R1332 VSS_n172 VSS_n55 17.0005
R1333 VSS_n174 VSS_n55 17.0005
R1334 VSS_n654 VSS_n101 17.0005
R1335 VSS_n654 VSS_n653 17.0005
R1336 VSS_n654 VSS_n102 17.0005
R1337 VSS_n654 VSS_n651 17.0005
R1338 VSS_n654 VSS_n103 17.0005
R1339 VSS_n654 VSS_n649 17.0005
R1340 VSS_n654 VSS_n104 17.0005
R1341 VSS_n654 VSS_n81 17.0005
R1342 VSS_n654 VSS_n106 17.0005
R1343 VSS_n654 VSS_n645 17.0005
R1344 VSS_n654 VSS_n79 17.0005
R1345 VSS_n654 VSS_n78 17.0005
R1346 VSS_n654 VSS_n77 17.0005
R1347 VSS_n654 VSS_n76 17.0005
R1348 VSS_n654 VSS_n75 17.0005
R1349 VSS_n654 VSS_n74 17.0005
R1350 VSS_n654 VSS_n73 17.0005
R1351 VSS_n654 VSS_n72 17.0005
R1352 VSS_n654 VSS_n71 17.0005
R1353 VSS_n93 VSS_n88 17.0005
R1354 VSS_n646 VSS_n93 17.0005
R1355 VSS_n104 VSS_n93 17.0005
R1356 VSS_n645 VSS_n93 17.0005
R1357 VSS_n93 VSS_n79 17.0005
R1358 VSS_n93 VSS_n78 17.0005
R1359 VSS_n93 VSS_n77 17.0005
R1360 VSS_n93 VSS_n76 17.0005
R1361 VSS_n93 VSS_n75 17.0005
R1362 VSS_n93 VSS_n74 17.0005
R1363 VSS_n93 VSS_n73 17.0005
R1364 VSS_n93 VSS_n72 17.0005
R1365 VSS_n93 VSS_n71 17.0005
R1366 VSS_n216 VSS_t15 15.8477
R1367 VSS_n296 VSS_t1 15.182
R1368 VSS_n546 VSS_n539 14.6287
R1369 VSS_n532 VSS_n420 14.6287
R1370 VSS_n533 VSS_n510 14.6287
R1371 VSS_n509 VSS_n508 14.6287
R1372 VSS_n0 VSS 14.2227
R1373 VSS_n507 VSS_t21 12.8002
R1374 VSS_n315 VSS_n287 12.1907
R1375 VSS_n317 VSS_n289 12.1907
R1376 VSS_n263 VSS_t11 12.1907
R1377 VSS_n155 VSS_n40 10.9922
R1378 VSS_n504 VSS_n410 10.9717
R1379 VSS_n434 VSS_n409 10.9717
R1380 VSS_n432 VSS_n408 10.9717
R1381 VSS_n518 VSS_n407 10.9717
R1382 VSS_n445 VSS_n399 10.9717
R1383 VSS_n312 VSS_t25 10.9717
R1384 VSS_t7 VSS_n291 10.9717
R1385 VSS_n320 VSS_t7 10.9717
R1386 VSS_n262 VSS_n228 10.9717
R1387 VSS_n227 VSS_n226 10.9717
R1388 VSS_n225 VSS_n224 10.9717
R1389 VSS_n223 VSS_n222 10.9717
R1390 VSS_n221 VSS_n220 10.9717
R1391 VSS_n219 VSS_n218 10.9717
R1392 VSS_n259 VSS_n258 10.9717
R1393 VSS_n433 VSS_n408 9.75263
R1394 VSS_n431 VSS_n407 9.75263
R1395 VSS_n517 VSS_n406 9.75263
R1396 VSS_n415 VSS_n405 9.75263
R1397 VSS_n414 VSS_n404 9.75263
R1398 VSS_n613 VSS_n609 9.75263
R1399 VSS_n613 VSS_n327 9.75263
R1400 VSS_n326 VSS_n307 9.75263
R1401 VSS_n309 VSS_n307 9.75263
R1402 VSS_n311 VSS_n310 9.75263
R1403 VSS_n311 VSS_n308 9.75263
R1404 VSS_n619 VSS_n301 9.75263
R1405 VSS_n620 VSS_n619 9.75263
R1406 VSS_n313 VSS_n300 9.75263
R1407 VSS_n313 VSS_n312 9.75263
R1408 VSS_n315 VSS_n314 9.75263
R1409 VSS_n505 VSS_n410 9.33995
R1410 VSS_n264 VSS_n216 9.33995
R1411 VSS_t13 VSS_n166 9.33995
R1412 VSS_n263 VSS_n229 9.33995
R1413 VSS_n99 VSS_n87 9.33995
R1414 VSS_n647 VSS_n83 9.33995
R1415 VSS_n100 VSS_n87 9.33995
R1416 VSS_n653 VSS_n652 9.33995
R1417 VSS_n651 VSS_n650 9.33995
R1418 VSS_n649 VSS_n648 9.33995
R1419 VSS_n105 VSS_n81 9.33995
R1420 VSS_n506 VSS_n505 9.33995
R1421 VSS_n261 VSS_n229 9.33995
R1422 VSS_n259 VSS_n217 9.33995
R1423 VSS_n242 VSS_n166 9.33995
R1424 VSS_n106 VSS_n105 9.33995
R1425 VSS_n647 VSS_n646 9.33995
R1426 VSS_n648 VSS_n83 9.33995
R1427 VSS_n650 VSS_n103 9.33995
R1428 VSS_n652 VSS_n102 9.33995
R1429 VSS_n101 VSS_n100 9.33995
R1430 VSS_n99 VSS_n88 9.33995
R1431 VSS_n428 VSS_t22 9.12784
R1432 VSS_n485 VSS_t18 9.12784
R1433 VSS_t25 VSS_n287 8.53362
R1434 VSS_t8 VSS_n75 8.53362
R1435 VSS_n546 VSS_n540 8.501
R1436 VSS_n546 VSS_n419 8.501
R1437 VSS_n416 VSS_n415 8.501
R1438 VSS_n459 VSS_n448 8.501
R1439 VSS_n459 VSS_n450 8.501
R1440 VSS_n633 VSS_n632 8.501
R1441 VSS_n274 VSS_n273 8.501
R1442 VSS_n273 VSS_n272 8.501
R1443 VSS_n273 VSS_n154 8.501
R1444 VSS_n525 VSS_n518 8.501
R1445 VSS_n523 VSS_n518 8.501
R1446 VSS_n497 VSS_n496 8.501
R1447 VSS_n497 VSS_n468 8.501
R1448 VSS_n497 VSS_n465 8.501
R1449 VSS_n497 VSS_n467 8.501
R1450 VSS_n497 VSS_n466 8.501
R1451 VSS_n480 VSS_n471 8.501
R1452 VSS_n480 VSS_n479 8.501
R1453 VSS_n583 VSS_n582 8.501
R1454 VSS_n589 VSS_n582 8.501
R1455 VSS_n582 VSS_n343 8.501
R1456 VSS_n604 VSS_n330 8.501
R1457 VSS_n604 VSS_n332 8.501
R1458 VSS_n604 VSS_n603 8.501
R1459 VSS_n614 VSS_n613 8.501
R1460 VSS_n613 VSS_n612 8.501
R1461 VSS_n613 VSS_n303 8.501
R1462 VSS_n562 VSS_n561 8.501
R1463 VSS_n411 VSS_n410 8.501
R1464 VSS_n571 VSS_n410 8.501
R1465 VSS_n413 VSS_n410 8.501
R1466 VSS_n561 VSS_n560 8.501
R1467 VSS_n561 VSS_n554 8.501
R1468 VSS_n375 VSS_n374 8.501
R1469 VSS_n374 VSS_n370 8.501
R1470 VSS_n374 VSS_n371 8.501
R1471 VSS_n149 VSS_n148 8.501
R1472 VSS_n148 VSS_n123 8.501
R1473 VSS_n148 VSS_n147 8.501
R1474 VSS_n644 VSS_n109 8.501
R1475 VSS_n644 VSS_n110 8.501
R1476 VSS_n644 VSS_n108 8.501
R1477 VSS_n258 VSS_n250 8.501
R1478 VSS_n631 VSS_n629 8.501
R1479 VSS_n631 VSS_n279 8.501
R1480 VSS_n631 VSS_n627 8.501
R1481 VSS_n631 VSS_n280 8.501
R1482 VSS_n631 VSS_n281 8.501
R1483 VSS_n631 VSS_n626 8.501
R1484 VSS_n631 VSS_n282 8.501
R1485 VSS_n631 VSS_n625 8.501
R1486 VSS_n631 VSS_n283 8.501
R1487 VSS_n258 VSS_n251 8.501
R1488 VSS_n258 VSS_n249 8.501
R1489 VSS_n258 VSS_n252 8.501
R1490 VSS_n258 VSS_n254 8.501
R1491 VSS_n258 VSS_n255 8.501
R1492 VSS_n258 VSS_n245 8.501
R1493 VSS_n258 VSS_n256 8.501
R1494 VSS_n258 VSS_n244 8.501
R1495 VSS_n684 VSS_n683 8.501
R1496 VSS_n215 VSS_n182 8.501
R1497 VSS_n215 VSS_n189 8.501
R1498 VSS_n215 VSS_n176 8.501
R1499 VSS_n215 VSS_n188 8.501
R1500 VSS_n215 VSS_n186 8.501
R1501 VSS_n215 VSS_n178 8.501
R1502 VSS_n215 VSS_n185 8.501
R1503 VSS_n215 VSS_n179 8.501
R1504 VSS_n215 VSS_n184 8.501
R1505 VSS_n683 VSS_n39 8.501
R1506 VSS_n683 VSS_n47 8.501
R1507 VSS_n683 VSS_n45 8.501
R1508 VSS_n683 VSS_n49 8.501
R1509 VSS_n683 VSS_n44 8.501
R1510 VSS_n683 VSS_n43 8.501
R1511 VSS_n683 VSS_n42 8.501
R1512 VSS_n683 VSS_n51 8.501
R1513 VSS_n683 VSS_n53 8.501
R1514 VSS_n683 VSS_n54 8.501
R1515 VSS_n663 VSS_n90 8.501
R1516 VSS_n137 VSS_n70 8.501
R1517 VSS_n135 VSS_n70 8.501
R1518 VSS_n132 VSS_n70 8.501
R1519 VSS_n663 VSS_n92 8.501
R1520 VSS_n622 VSS_n287 8.5005
R1521 VSS_n622 VSS_n289 8.5005
R1522 VSS_n622 VSS_n290 8.5005
R1523 VSS_n622 VSS_n291 8.5005
R1524 VSS_n622 VSS_n292 8.5005
R1525 VSS_n622 VSS_n293 8.5005
R1526 VSS_n622 VSS_n295 8.5005
R1527 VSS_n618 VSS_n320 8.5005
R1528 VSS_n618 VSS_n318 8.5005
R1529 VSS_n618 VSS_n317 8.5005
R1530 VSS_n618 VSS_n315 8.5005
R1531 VSS_n618 VSS_n313 8.5005
R1532 VSS_n619 VSS_n618 8.5005
R1533 VSS_n618 VSS_n311 8.5005
R1534 VSS_n618 VSS_n307 8.5005
R1535 VSS_n318 VSS_n286 8.5005
R1536 VSS_n316 VSS_n286 8.5005
R1537 VSS_n314 VSS_n286 8.5005
R1538 VSS_n300 VSS_n286 8.5005
R1539 VSS_n301 VSS_n286 8.5005
R1540 VSS_n310 VSS_n286 8.5005
R1541 VSS_n326 VSS_n286 8.5005
R1542 VSS_n609 VSS_n286 8.5005
R1543 VSS_n607 VSS_n286 8.5005
R1544 VSS_n605 VSS_n286 8.5005
R1545 VSS_n665 VSS_n87 8.5005
R1546 VSS_n665 VSS_n83 8.5005
R1547 VSS_n665 VSS_n81 8.5005
R1548 VSS_n665 VSS_n79 8.5005
R1549 VSS_n665 VSS_n78 8.5005
R1550 VSS_n665 VSS_n77 8.5005
R1551 VSS_n665 VSS_n76 8.5005
R1552 VSS_n665 VSS_n75 8.5005
R1553 VSS_n665 VSS_n74 8.5005
R1554 VSS_n665 VSS_n73 8.5005
R1555 VSS_n665 VSS_n72 8.5005
R1556 VSS_n665 VSS_n71 8.5005
R1557 VSS_n542 VSS_n541 8.48766
R1558 VSS_n637 VSS_n636 8.48362
R1559 VSS_n499 VSS_n435 8.48362
R1560 VSS_n579 VSS_n363 8.48362
R1561 VSS_n642 VSS_n641 8.48362
R1562 VSS_n721 VSS_n8 8.48362
R1563 VSS_n549 VSS_n548 8.46995
R1564 VSS_n453 VSS_n452 8.46995
R1565 VSS_n449 VSS_n3 8.46995
R1566 VSS_n635 VSS_n634 8.46995
R1567 VSS_n269 VSS_n268 8.46995
R1568 VSS_n513 VSS_n512 8.46995
R1569 VSS_n524 VSS_n520 8.46995
R1570 VSS_n522 VSS_n521 8.46995
R1571 VSS_n493 VSS_n464 8.46995
R1572 VSS_n495 VSS_n494 8.46995
R1573 VSS_n490 VSS_n489 8.46995
R1574 VSS_n488 VSS_n487 8.46995
R1575 VSS_n483 VSS_n482 8.46995
R1576 VSS_n476 VSS_n475 8.46995
R1577 VSS_n478 VSS_n477 8.46995
R1578 VSS_n593 VSS_n592 8.46995
R1579 VSS_n591 VSS_n590 8.46995
R1580 VSS_n586 VSS_n585 8.46995
R1581 VSS_n599 VSS_n336 8.46995
R1582 VSS_n600 VSS_n333 8.46995
R1583 VSS_n335 VSS_n334 8.46995
R1584 VSS_n616 VSS_n615 8.46995
R1585 VSS_n611 VSS_n610 8.46995
R1586 VSS_n577 VSS_n576 8.46995
R1587 VSS_n572 VSS_n412 8.46995
R1588 VSS_n570 VSS_n569 8.46995
R1589 VSS_n559 VSS_n552 8.46995
R1590 VSS_n558 VSS_n557 8.46995
R1591 VSS_n377 VSS_n376 8.46995
R1592 VSS_n379 VSS_n368 8.46995
R1593 VSS_n380 VSS_n367 8.46995
R1594 VSS_n151 VSS_n150 8.46995
R1595 VSS_n144 VSS_n124 8.46995
R1596 VSS_n129 VSS_n128 8.46995
R1597 VSS_n125 VSS_n111 8.46995
R1598 VSS_n708 VSS_n21 8.46995
R1599 VSS_n712 VSS_n17 8.46995
R1600 VSS_n713 VSS_n16 8.46995
R1601 VSS_n714 VSS_n15 8.46995
R1602 VSS_n715 VSS_n14 8.46995
R1603 VSS_n716 VSS_n13 8.46995
R1604 VSS_n717 VSS_n12 8.46995
R1605 VSS_n718 VSS_n11 8.46995
R1606 VSS_n719 VSS_n10 8.46995
R1607 VSS_n694 VSS_n35 8.46995
R1608 VSS_n695 VSS_n34 8.46995
R1609 VSS_n697 VSS_n32 8.46995
R1610 VSS_n702 VSS_n27 8.46995
R1611 VSS_n703 VSS_n26 8.46995
R1612 VSS_n704 VSS_n25 8.46995
R1613 VSS_n705 VSS_n24 8.46995
R1614 VSS_n213 VSS_n212 8.46995
R1615 VSS_n211 VSS_n210 8.46995
R1616 VSS_n209 VSS_n208 8.46995
R1617 VSS_n203 VSS_n202 8.46995
R1618 VSS_n201 VSS_n200 8.46995
R1619 VSS_n199 VSS_n198 8.46995
R1620 VSS_n197 VSS_n196 8.46995
R1621 VSS_n195 VSS_n194 8.46995
R1622 VSS_n181 VSS_n36 8.46995
R1623 VSS_n686 VSS_n685 8.46995
R1624 VSS_n46 VSS_n38 8.46995
R1625 VSS_n669 VSS_n67 8.46995
R1626 VSS_n670 VSS_n66 8.46995
R1627 VSS_n671 VSS_n65 8.46995
R1628 VSS_n672 VSS_n64 8.46995
R1629 VSS_n675 VSS_n61 8.46995
R1630 VSS_n678 VSS_n58 8.46995
R1631 VSS_n679 VSS_n57 8.46995
R1632 VSS_n681 VSS_n680 8.46995
R1633 VSS_n140 VSS_n139 8.46995
R1634 VSS_n136 VSS_n130 8.46995
R1635 VSS_n134 VSS_n133 8.46995
R1636 VSS_n131 VSS_n98 8.46995
R1637 VSS_n659 VSS_n95 8.46995
R1638 VSS_n661 VSS_n660 8.46995
R1639 VSS_n700 VSS_n29 8.4654
R1640 VSS_n674 VSS_n62 8.4654
R1641 VSS_n271 VSS_n270 8.45541
R1642 VSS_n325 VSS_n324 8.45541
R1643 VSS_n122 VSS_n121 8.45541
R1644 VSS_n127 VSS_n126 8.45541
R1645 VSS_n527 VSS_n526 8.44274
R1646 VSS_n492 VSS_n491 8.44274
R1647 VSS_n664 VSS_n88 6.87449
R1648 VSS_n295 VSS_n285 6.79743
R1649 VSS_n459 VSS_t17 6.70509
R1650 VSS_n460 VSS_n459 6.09558
R1651 VSS_n561 VSS_n340 6.09558
R1652 VSS_n632 VSS_n631 6.09558
R1653 VSS_n240 VSS_n236 6.09558
R1654 VSS_n235 VSS_n234 6.09558
R1655 VSS_n233 VSS_n232 6.09558
R1656 VSS_n231 VSS_n230 6.09558
R1657 VSS_n261 VSS_n260 6.09558
R1658 VSS_n321 VSS_n292 6.02866
R1659 VSS_n295 VSS_n294 6.02866
R1660 VSS_n319 VSS_n292 6.02866
R1661 VSS_n101 VSS_n86 6.02866
R1662 VSS_n102 VSS_n85 6.02866
R1663 VSS_n649 VSS_n84 6.02866
R1664 VSS_n646 VSS_n82 6.02866
R1665 VSS_n106 VSS_n80 6.02866
R1666 VSS_n320 VSS_n319 6.02866
R1667 VSS_n321 VSS_n293 6.02866
R1668 VSS_n294 VSS_n293 6.02866
R1669 VSS_n645 VSS_n80 6.02866
R1670 VSS_n104 VSS_n82 6.02866
R1671 VSS_n103 VSS_n84 6.02866
R1672 VSS_n651 VSS_n85 6.02866
R1673 VSS_n653 VSS_n86 6.02866
R1674 VSS_n546 VSS_n545 5.66778
R1675 VSS_n546 VSS_n422 5.66778
R1676 VSS_n459 VSS_n447 5.66778
R1677 VSS_n459 VSS_n451 5.66778
R1678 VSS_n539 VSS_n538 5.66778
R1679 VSS_n539 VSS_n424 5.66778
R1680 VSS_n539 VSS_n425 5.66778
R1681 VSS_n530 VSS_n518 5.66778
R1682 VSS_n519 VSS_n518 5.66778
R1683 VSS_n481 VSS_n480 5.66778
R1684 VSS_n480 VSS_n474 5.66778
R1685 VSS_n587 VSS_n582 5.66778
R1686 VSS_n604 VSS_n329 5.66778
R1687 VSS_n573 VSS_n410 5.66778
R1688 VSS_n561 VSS_n553 5.66778
R1689 VSS_n374 VSS_n372 5.66778
R1690 VSS_n631 VSS_n277 5.66778
R1691 VSS_n631 VSS_n628 5.66778
R1692 VSS_n631 VSS_n278 5.66778
R1693 VSS_n258 VSS_n248 5.66778
R1694 VSS_n258 VSS_n247 5.66778
R1695 VSS_n258 VSS_n253 5.66778
R1696 VSS_n258 VSS_n246 5.66778
R1697 VSS_n215 VSS_n187 5.66778
R1698 VSS_n215 VSS_n177 5.66778
R1699 VSS_n215 VSS_n183 5.66778
R1700 VSS_n215 VSS_n180 5.66778
R1701 VSS_n683 VSS_n50 5.66778
R1702 VSS_n683 VSS_n41 5.66778
R1703 VSS_n683 VSS_n52 5.66778
R1704 VSS_n107 VSS_n70 5.66778
R1705 VSS_n663 VSS_n89 5.66778
R1706 VSS_n663 VSS_n91 5.66778
R1707 VSS_n547 VSS_n546 5.66767
R1708 VSS_n459 VSS_n458 5.66767
R1709 VSS_n632 VSS_n237 5.66767
R1710 VSS_n518 VSS_n430 5.66767
R1711 VSS_n498 VSS_n497 5.66767
R1712 VSS_n480 VSS_n439 5.66767
R1713 VSS_n613 VSS_n306 5.66767
R1714 VSS_n148 VSS_n120 5.66767
R1715 VSS_n644 VSS_n643 5.66767
R1716 VSS_n631 VSS_n630 5.66767
R1717 VSS_n683 VSS_n682 5.66767
R1718 VSS_n663 VSS_n662 5.66767
R1719 VSS_n595 VSS_n353 5.62486
R1720 VSS_n595 VSS_n354 5.62486
R1721 VSS_n579 VSS_n362 5.62486
R1722 VSS_n366 VSS_n286 5.62486
R1723 VSS_n421 VSS_n418 5.61281
R1724 VSS_n544 VSS_n543 5.61281
R1725 VSS_n457 VSS_n456 5.61281
R1726 VSS_n637 VSS_n152 5.61281
R1727 VSS_n537 VSS_n536 5.61281
R1728 VSS_n529 VSS_n528 5.61281
R1729 VSS_n588 VSS_n584 5.61281
R1730 VSS_n564 VSS_n563 5.61281
R1731 VSS_n556 VSS_n555 5.61281
R1732 VSS_n692 VSS_n8 5.61281
R1733 VSS_n709 VSS_n20 5.61281
R1734 VSS_n710 VSS_n19 5.61281
R1735 VSS_n711 VSS_n18 5.61281
R1736 VSS_n720 VSS_n9 5.61281
R1737 VSS_n696 VSS_n33 5.61281
R1738 VSS_n698 VSS_n31 5.61281
R1739 VSS_n699 VSS_n30 5.61281
R1740 VSS_n701 VSS_n28 5.61281
R1741 VSS_n706 VSS_n23 5.61281
R1742 VSS_n689 VSS_n37 5.61281
R1743 VSS_n207 VSS_n206 5.61281
R1744 VSS_n205 VSS_n204 5.61281
R1745 VSS_n193 VSS_n192 5.61281
R1746 VSS_n191 VSS_n190 5.61281
R1747 VSS_n673 VSS_n63 5.61281
R1748 VSS_n676 VSS_n60 5.61281
R1749 VSS_n677 VSS_n59 5.61281
R1750 VSS_n657 VSS_n97 5.61281
R1751 VSS_n239 VSS_n238 5.60001
R1752 VSS_n455 VSS_n454 5.58885
R1753 VSS_n427 VSS_n426 5.58885
R1754 VSS_n473 VSS_n470 5.58885
R1755 VSS_n602 VSS_n601 5.58885
R1756 VSS_n575 VSS_n574 5.58885
R1757 VSS_n378 VSS_n369 5.58885
R1758 VSS_n658 VSS_n96 5.58885
R1759 VSS_n504 VSS_t3 4.87657
R1760 VSS_n497 VSS_n404 4.87657
R1761 VSS_n463 VSS_n403 4.87657
R1762 VSS_n462 VSS_n402 4.87657
R1763 VSS_n461 VSS_n401 4.87657
R1764 VSS_n460 VSS_n400 4.87657
R1765 VSS_n446 VSS_t19 4.87657
R1766 VSS_n317 VSS_t5 4.87657
R1767 VSS_t5 VSS_n316 4.87657
R1768 VSS_n561 VSS_n364 4.25119
R1769 VSS_n258 VSS_n257 4.25119
R1770 VSS_n632 VSS_n276 4.25113
R1771 VSS_n631 VSS_n624 4.25113
R1772 VSS_n539 VSS_n423 4.251
R1773 VSS_n594 VSS_n582 4.251
R1774 VSS_n604 VSS_n328 4.251
R1775 VSS_n578 VSS_n410 4.251
R1776 VSS_n374 VSS_n373 4.251
R1777 VSS_n215 VSS_n214 4.251
R1778 VSS_n138 VSS_n70 4.251
R1779 VSS_n534 VSS_n503 4.17416
R1780 VSS_n337 VSS_t24 4.02854
R1781 VSS_n505 VSS_n1 3.83153
R1782 VSS_n275 VSS_n264 3.83153
R1783 VSS_n637 VSS_n166 3.83153
R1784 VSS_n637 VSS_n217 3.83153
R1785 VSS_n637 VSS_n229 3.83153
R1786 VSS_n654 VSS_n99 3.83153
R1787 VSS_n654 VSS_n647 3.83153
R1788 VSS_n100 VSS_n93 3.83153
R1789 VSS_n652 VSS_n93 3.83153
R1790 VSS_n650 VSS_n93 3.83153
R1791 VSS_n648 VSS_n93 3.83153
R1792 VSS_n105 VSS_n93 3.83153
R1793 VSS_n273 VSS_n155 3.66449
R1794 VSS_n374 VSS_n338 3.65755
R1795 VSS_n605 VSS_n604 3.65755
R1796 VSS_n304 VSS_t6 3.49206
R1797 VSS_n531 VSS_n511 3.31185
R1798 VSS_n484 VSS_n469 3.31185
R1799 VSS_n486 VSS_n469 3.30365
R1800 VSS_n724 VSS_n5 3.30348
R1801 VSS_n531 VSS_n516 2.72439
R1802 VSS_n550 VSS_n417 2.7239
R1803 VSS_n598 VSS_n597 2.71714
R1804 VSS_n597 VSS_n346 2.71714
R1805 VSS_n688 VSS_t14 2.60517
R1806 VSS_n691 VSS_t12 2.60472
R1807 VSS_n382 VSS_t26 2.60106
R1808 VSS_n621 VSS_n300 2.43853
R1809 VSS_n148 VSS_n71 2.43853
R1810 VSS_n119 VSS_n72 2.43853
R1811 VSS_n118 VSS_n73 2.43853
R1812 VSS_n117 VSS_n74 2.43853
R1813 VSS_n116 VSS_n75 2.43853
R1814 VSS_n723 VSS_n722 2.38612
R1815 VSS_n535 VSS_n534 2.30307
R1816 VSS_n618 VSS_n305 2.29333
R1817 VSS_n381 VSS_n286 1.97148
R1818 VSS_n622 VSS_n298 1.96473
R1819 VSS_n500 VSS_n499 1.95372
R1820 VSS_n622 VSS_n621 1.88939
R1821 VSS_n623 VSS_n622 1.88939
R1822 VSS_n566 VSS_t20 1.85825
R1823 VSS_t21 VSS_n506 1.82903
R1824 VSS_n642 VSS_n112 1.70774
R1825 VSS_n146 VSS_n145 1.70393
R1826 VSS_n8 VSS_n7 1.69473
R1827 VSS_n726 VSS_t10 1.6261
R1828 VSS_n456 VSS_n6 1.52781
R1829 VSS_n623 VSS_n285 1.51132
R1830 VSS_n595 VSS_n357 1.50681
R1831 VSS_n637 VSS_n155 1.50396
R1832 VSS_n730 VSS_n1 1.50314
R1833 VSS_n687 VSS_n37 1.49316
R1834 VSS_n384 VSS_n383 1.39582
R1835 VSS_n667 VSS_n666 1.38998
R1836 VSS_n69 VSS_n68 1.37908
R1837 VSS_n266 VSS_t16 1.3604
R1838 VSS_n383 VSS_n382 1.34601
R1839 VSS_n638 VSS_n153 1.33808
R1840 VSS_n622 VSS_n299 1.33552
R1841 VSS_n723 VSS_n6 1.32108
R1842 VSS_n623 VSS_n284 1.30869
R1843 VSS_n417 VSS_n414 1.30819
R1844 VSS_n623 VSS_n286 1.30819
R1845 VSS_n665 VSS_n70 1.30819
R1846 VSS_n667 VSS_n68 1.29917
R1847 VSS_n666 VSS_n69 1.29188
R1848 VSS_n655 VSS_n98 1.28661
R1849 VSS_n356 VSS_n355 1.25862
R1850 VSS_n618 VSS_n321 1.23717
R1851 VSS_n294 VSS_n286 1.23717
R1852 VSS_n319 VSS_n286 1.23717
R1853 VSS_n665 VSS_n86 1.23717
R1854 VSS_n665 VSS_n85 1.23717
R1855 VSS_n665 VSS_n84 1.23717
R1856 VSS_n665 VSS_n82 1.23717
R1857 VSS_n665 VSS_n80 1.23717
R1858 VSS_n443 VSS_n398 1.21952
R1859 VSS_n441 VSS_n397 1.21952
R1860 VSS_n480 VSS_n396 1.21952
R1861 VSS_n582 VSS_n359 1.21952
R1862 VSS_n394 VSS_n344 1.21952
R1863 VSS_n392 VSS_n342 1.21952
R1864 VSS_n390 VSS_n345 1.21952
R1865 VSS_n388 VSS_n341 1.21952
R1866 VSS_n365 VSS_n347 1.21952
R1867 VSS_n639 VSS_n638 1.20474
R1868 VSS_n141 VSS_n93 1.20367
R1869 VSS_n725 VSS_n724 1.20154
R1870 VSS_n565 VSS_n360 1.19852
R1871 VSS_n567 VSS_n360 1.19852
R1872 VSS_n514 VSS_n386 1.16524
R1873 VSS_n386 VSS_n385 1.15986
R1874 VSS_n656 VSS_n655 1.1344
R1875 VSS_n243 VSS_n238 1.07631
R1876 VSS_n618 VSS_n302 1.07523
R1877 VSS_n622 VSS_n288 1.07131
R1878 VSS_n664 VSS_n663 1.05846
R1879 VSS_n266 VSS_n243 1.01327
R1880 VSS_n707 VSS_n706 1.00126
R1881 VSS_n212 VSS_n56 0.989816
R1882 VSS_n680 VSS_n56 0.98015
R1883 VSS_n551 VSS_n2 0.965587
R1884 VSS_n618 VSS_n617 0.96552
R1885 VSS_n660 VSS_n94 0.963138
R1886 VSS_n726 VSS_n725 0.962068
R1887 VSS_n142 VSS_n94 0.94822
R1888 VSS_n708 VSS_n707 0.946957
R1889 VSS_n269 VSS_n267 0.893699
R1890 VSS_n275 VSS_n267 0.880723
R1891 VSS_n727 VSS_n726 0.879004
R1892 VSS_n729 VSS_n2 0.878191
R1893 VSS_n617 VSS_n616 0.875293
R1894 VSS_n707 VSS_n22 0.86135
R1895 VSS_n297 VSS_n288 0.834133
R1896 VSS_n565 VSS_n564 0.823879
R1897 VSS_n355 VSS_n288 0.821673
R1898 VSS_n728 VSS_n727 0.815143
R1899 VSS_n727 VSS_n4 0.794361
R1900 VSS_n94 VSS_n93 0.783195
R1901 VSS_n56 VSS_n55 0.781759
R1902 VSS_n141 VSS_n140 0.779095
R1903 VSS_n323 VSS_n302 0.761552
R1904 VSS_n304 VSS_n302 0.745448
R1905 VSS_n566 VSS_n565 0.74287
R1906 VSS_n567 VSS_n566 0.734127
R1907 VSS_n617 VSS_n323 0.733365
R1908 VSS_n275 VSS_n243 0.723821
R1909 VSS_n730 VSS_n729 0.6911
R1910 VSS_n267 VSS_n266 0.690398
R1911 VSS_n687 VSS_n686 0.688074
R1912 VSS_n142 VSS_n141 0.6825
R1913 VSS_n436 VSS_n357 0.665037
R1914 VSS_n357 VSS_n356 0.663686
R1915 VSS_n725 VSS_n4 0.656278
R1916 VSS_n417 VSS_n2 0.646639
R1917 VSS_n722 VSS_n7 0.644985
R1918 VSS_n125 VSS_n112 0.642496
R1919 VSS_n145 VSS_n144 0.63611
R1920 VSS_n568 VSS_n567 0.634703
R1921 VSS_n640 VSS_n112 0.628252
R1922 VSS_n596 VSS_t9 0.610008
R1923 VSS_n322 VSS_n299 0.60783
R1924 VSS_n688 VSS_n687 0.606355
R1925 VSS_n296 VSS_n153 0.601833
R1926 VSS_n568 VSS_n551 0.598625
R1927 VSS_n668 VSS_n667 0.59175
R1928 VSS_n501 VSS_n500 0.580907
R1929 VSS_n355 VSS_n299 0.580046
R1930 VSS_n536 VSS_n535 0.577317
R1931 VSS_n729 VSS_n728 0.5615
R1932 VSS_n381 VSS_n380 0.555543
R1933 VSS_n297 VSS_n296 0.5505
R1934 VSS_n691 VSS_n7 0.535243
R1935 VSS_n143 VSS_n142 0.529875
R1936 VSS_n385 VSS_n384 0.5285
R1937 VSS_n322 VSS_n298 0.516908
R1938 VSS_n382 VSS_n381 0.512155
R1939 VSS_n145 VSS_n143 0.507096
R1940 VSS_n610 VSS_n305 0.498465
R1941 VSS_n515 VSS_n514 0.4955
R1942 VSS_n543 VSS_n418 0.484678
R1943 VSS_n516 VSS_n515 0.465976
R1944 VSS_n724 VSS_n723 0.456001
R1945 VSS_n500 VSS_n437 0.455409
R1946 VSS_n528 VSS_n511 0.453357
R1947 VSS_n516 VSS_n513 0.450427
R1948 VSS_n731 VSS_n730 0.449895
R1949 VSS_n550 VSS_n549 0.449467
R1950 VSS_n693 VSS_n690 0.447833
R1951 VSS_n536 VSS_n427 0.446722
R1952 VSS_n579 VSS_n386 0.445055
R1953 VSS_n305 VSS_n304 0.44461
R1954 VSS_n585 VSS_n346 0.439966
R1955 VSS_n599 VSS_n598 0.438231
R1956 VSS_n551 VSS_n550 0.422886
R1957 VSS_n591 VSS_n584 0.422358
R1958 VSS_n456 VSS_n455 0.410569
R1959 VSS_n658 VSS_n657 0.410569
R1960 VSS_n485 VSS_n484 0.400134
R1961 VSS_n298 VSS_n297 0.396502
R1962 VSS_n484 VSS_n483 0.391377
R1963 VSS_n535 VSS_n428 0.389086
R1964 VSS_n455 VSS_n453 0.384746
R1965 VSS_n659 VSS_n658 0.384746
R1966 VSS_n379 VSS_n378 0.384746
R1967 VSS_n575 VSS_n412 0.384746
R1968 VSS_n476 VSS_n470 0.384746
R1969 VSS_n601 VSS_n600 0.384402
R1970 VSS_n598 VSS_n337 0.381027
R1971 VSS_n488 VSS_n486 0.380211
R1972 VSS_n346 VSS_n337 0.379293
R1973 VSS_n677 VSS_n676 0.374678
R1974 VSS_n193 VSS_n191 0.374678
R1975 VSS_n207 VSS_n205 0.374678
R1976 VSS_n711 VSS_n710 0.374678
R1977 VSS_n710 VSS_n709 0.374678
R1978 VSS_n699 VSS_n698 0.374678
R1979 VSS_n437 VSS_n436 0.367167
R1980 VSS_n528 VSS_n527 0.367121
R1981 VSS_n133 VSS_n130 0.360378
R1982 VSS_n557 VSS_n552 0.360378
R1983 VSS_n502 VSS_n501 0.356167
R1984 VSS_n635 VSS_n238 0.350858
R1985 VSS_n503 VSS_n428 0.349895
R1986 VSS_n601 VSS_n335 0.34859
R1987 VSS_n513 VSS_n427 0.34859
R1988 VSS_n378 VSS_n377 0.348249
R1989 VSS_n576 VSS_n575 0.348249
R1990 VSS_n483 VSS_n470 0.348249
R1991 VSS_n270 VSS_n152 0.341767
R1992 VSS_n674 VSS_n673 0.321793
R1993 VSS_n700 VSS_n699 0.321793
R1994 VSS_n701 VSS_n700 0.321453
R1995 VSS_n640 VSS_n639 0.3195
R1996 VSS_n655 VSS_n654 0.313484
R1997 VSS_n678 VSS_n677 0.312698
R1998 VSS_n191 VSS_n36 0.312698
R1999 VSS_n205 VSS_n203 0.312698
R2000 VSS_n712 VSS_n711 0.312698
R2001 VSS_n697 VSS_n696 0.312698
R2002 VSS_n702 VSS_n701 0.312698
R2003 VSS_n564 VSS_n552 0.312698
R2004 VSS_n585 VSS_n584 0.312698
R2005 VSS_n549 VSS_n418 0.312358
R2006 VSS_n673 VSS_n672 0.312358
R2007 VSS_n676 VSS_n675 0.312358
R2008 VSS_n195 VSS_n193 0.312358
R2009 VSS_n209 VSS_n207 0.312358
R2010 VSS_n720 VSS_n719 0.312358
R2011 VSS_n709 VSS_n708 0.312358
R2012 VSS_n696 VSS_n695 0.312358
R2013 VSS_n698 VSS_n697 0.312358
R2014 VSS_n706 VSS_n705 0.312358
R2015 VSS_n557 VSS_n556 0.312358
R2016 VSS_n618 VSS_n285 0.310741
R2017 VSS_n494 VSS_n492 0.304801
R2018 VSS_n492 VSS_n490 0.304801
R2019 VSS_n527 VSS_n520 0.304801
R2020 VSS_n377 VSS_n366 0.294297
R2021 VSS_n576 VSS_n362 0.294297
R2022 VSS_n592 VSS_n353 0.294297
R2023 VSS_n354 VSS_n335 0.294297
R2024 VSS_n556 VSS_n363 0.285354
R2025 VSS_n721 VSS_n720 0.285354
R2026 VSS_n486 VSS_n485 0.2852
R2027 VSS_n129 VSS_n127 0.279447
R2028 VSS_n127 VSS_n125 0.279447
R2029 VSS_n144 VSS_n121 0.279447
R2030 VSS_n151 VSS_n121 0.279447
R2031 VSS_n610 VSS_n324 0.279447
R2032 VSS_n616 VSS_n324 0.279447
R2033 VSS_n270 VSS_n269 0.279447
R2034 VSS_n543 VSS_n542 0.270979
R2035 VSS_n515 VSS_n511 0.269968
R2036 VSS_n203 VSS_n201 0.268711
R2037 VSS_n714 VSS_n713 0.268711
R2038 VSS_n656 VSS_n69 0.2645
R2039 VSS_n675 VSS_n674 0.259473
R2040 VSS_n453 VSS_n3 0.250378
R2041 VSS_n686 VSS_n38 0.250378
R2042 VSS_n670 VSS_n669 0.250378
R2043 VSS_n671 VSS_n670 0.250378
R2044 VSS_n672 VSS_n671 0.250378
R2045 VSS_n679 VSS_n678 0.250378
R2046 VSS_n680 VSS_n679 0.250378
R2047 VSS_n660 VSS_n659 0.250378
R2048 VSS_n133 VSS_n98 0.250378
R2049 VSS_n140 VSS_n130 0.250378
R2050 VSS_n197 VSS_n195 0.250378
R2051 VSS_n199 VSS_n197 0.250378
R2052 VSS_n201 VSS_n199 0.250378
R2053 VSS_n211 VSS_n209 0.250378
R2054 VSS_n212 VSS_n211 0.250378
R2055 VSS_n719 VSS_n718 0.250378
R2056 VSS_n718 VSS_n717 0.250378
R2057 VSS_n717 VSS_n716 0.250378
R2058 VSS_n716 VSS_n715 0.250378
R2059 VSS_n715 VSS_n714 0.250378
R2060 VSS_n713 VSS_n712 0.250378
R2061 VSS_n695 VSS_n694 0.250378
R2062 VSS_n703 VSS_n702 0.250378
R2063 VSS_n704 VSS_n703 0.250378
R2064 VSS_n705 VSS_n704 0.250378
R2065 VSS_n380 VSS_n379 0.250378
R2066 VSS_n569 VSS_n412 0.250378
R2067 VSS_n592 VSS_n591 0.250378
R2068 VSS_n600 VSS_n599 0.250378
R2069 VSS_n490 VSS_n488 0.250378
R2070 VSS_n494 VSS_n493 0.250378
R2071 VSS_n477 VSS_n476 0.250378
R2072 VSS_n521 VSS_n520 0.250378
R2073 VSS_n692 VSS_n691 0.242759
R2074 VSS_n689 VSS_n688 0.242419
R2075 VSS_n641 VSS_n151 0.223034
R2076 VSS_n493 VSS_n435 0.223034
R2077 VSS_n636 VSS_n635 0.223034
R2078 VSS_n638 VSS_n637 0.220511
R2079 VSS_n665 VSS_n664 0.217868
R2080 VSS_n657 VSS_n656 0.194752
R2081 VSS_n639 VSS_n152 0.194752
R2082 VSS_n477 VSS_n438 0.187772
R2083 VSS_n521 VSS_n429 0.187772
R2084 VSS_n503 VSS_n502 0.186728
R2085 VSS_n383 VSS_n286 0.157398
R2086 VSS_n323 VSS_n322 0.1545
R2087 VSS_n669 VSS_n668 0.143772
R2088 VSS_n728 VSS_n3 0.132772
R2089 VSS_n143 VSS_n129 0.132772
R2090 VSS_n690 VSS_n36 0.132772
R2091 VSS_n694 VSS_n693 0.132772
R2092 VSS_n569 VSS_n568 0.132772
R2093 VSS_n665 VSS_n68 0.130662
R2094 VSS_n666 VSS_n665 0.130001
R2095 VSS_n690 VSS_n689 0.125425
R2096 VSS_n693 VSS_n692 0.125086
R2097 VSS_n668 VSS_n38 0.107106
R2098 VSS_n6 VSS_n5 0.0897938
R2099 VSS_n356 VSS_n354 0.089169
R2100 VSS_n436 VSS_n353 0.089169
R2101 VSS_n514 VSS_n362 0.089169
R2102 VSS_n384 VSS_n366 0.089169
R2103 VSS_n438 VSS_n437 0.0701667
R2104 VSS_n502 VSS_n429 0.0701667
R2105 VSS_n542 VSS_n0 0.0496724
R2106 VSS_n385 VSS_n363 0.0357621
R2107 VSS_n722 VSS_n721 0.0357621
R2108 VSS_n641 VSS_n640 0.0357621
R2109 VSS_n501 VSS_n435 0.0357621
R2110 VSS_n636 VSS_n153 0.0357621
R2111 VSS_n731 VSS_n0 0.0319286
R2112 VSS VSS_n731 0.0122857
R2113 VSS_n624 VSS_n9 0.002125
R2114 VSS_n276 VSS_n239 0.002125
R2115 VSS_n276 VSS_n275 0.00187493
R2116 VSS_n624 VSS_n8 0.00187493
R2117 VSS_n373 VSS_n367 0.00175
R2118 VSS_n139 VSS_n138 0.00175
R2119 VSS_n214 VSS_n213 0.00175
R2120 VSS_n578 VSS_n577 0.00175
R2121 VSS_n594 VSS_n593 0.00175
R2122 VSS_n334 VSS_n328 0.00175
R2123 VSS_n537 VSS_n423 0.00175
R2124 VSS_n545 VSS_n541 0.00166667
R2125 VSS_n544 VSS_n422 0.00166667
R2126 VSS_n452 VSS_n451 0.00166667
R2127 VSS_n454 VSS_n447 0.00166667
R2128 VSS_n131 VSS_n107 0.00166667
R2129 VSS_n96 VSS_n89 0.00166667
R2130 VSS_n95 VSS_n91 0.00166667
R2131 VSS_n181 VSS_n180 0.00166667
R2132 VSS_n190 VSS_n183 0.00166667
R2133 VSS_n202 VSS_n177 0.00166667
R2134 VSS_n204 VSS_n187 0.00166667
R2135 VSS_n62 VSS_n50 0.00166667
R2136 VSS_n59 VSS_n41 0.00166667
R2137 VSS_n58 VSS_n52 0.00166667
R2138 VSS_n278 VSS_n17 0.00166667
R2139 VSS_n628 VSS_n18 0.00166667
R2140 VSS_n277 VSS_n19 0.00166667
R2141 VSS_n248 VSS_n32 0.00166667
R2142 VSS_n247 VSS_n30 0.00166667
R2143 VSS_n253 VSS_n29 0.00166667
R2144 VSS_n246 VSS_n27 0.00166667
R2145 VSS_n372 VSS_n368 0.00166667
R2146 VSS_n573 VSS_n572 0.00166667
R2147 VSS_n559 VSS_n553 0.00166667
R2148 VSS_n587 VSS_n586 0.00166667
R2149 VSS_n334 VSS_n329 0.00166667
R2150 VSS_n482 VSS_n481 0.00166667
R2151 VSS_n475 VSS_n474 0.00166667
R2152 VSS_n512 VSS_n425 0.00166667
R2153 VSS_n512 VSS_n424 0.00166667
R2154 VSS_n538 VSS_n426 0.00166667
R2155 VSS_n530 VSS_n529 0.00166667
R2156 VSS_n526 VSS_n519 0.00166667
R2157 VSS_n257 VSS_n22 0.00162501
R2158 VSS_n579 VSS_n364 0.00162501
R2159 VSS_n555 VSS_n364 0.00137498
R2160 VSS_n257 VSS_n23 0.00137498
R2161 VSS_n422 VSS_n421 0.00133332
R2162 VSS_n545 VSS_n544 0.00133332
R2163 VSS_n457 VSS_n447 0.00133332
R2164 VSS_n454 VSS_n451 0.00133332
R2165 VSS_n531 VSS_n530 0.00133332
R2166 VSS_n531 VSS_n425 0.00133332
R2167 VSS_n538 VSS_n537 0.00133332
R2168 VSS_n426 VSS_n424 0.00133332
R2169 VSS_n529 VSS_n519 0.00133332
R2170 VSS_n481 VSS_n469 0.00133332
R2171 VSS_n474 VSS_n473 0.00133332
R2172 VSS_n588 VSS_n587 0.00133332
R2173 VSS_n602 VSS_n329 0.00133332
R2174 VSS_n574 VSS_n573 0.00133332
R2175 VSS_n563 VSS_n553 0.00133332
R2176 VSS_n372 VSS_n369 0.00133332
R2177 VSS_n277 VSS_n20 0.00133332
R2178 VSS_n628 VSS_n19 0.00133332
R2179 VSS_n278 VSS_n18 0.00133332
R2180 VSS_n248 VSS_n33 0.00133332
R2181 VSS_n247 VSS_n31 0.00133332
R2182 VSS_n253 VSS_n30 0.00133332
R2183 VSS_n246 VSS_n28 0.00133332
R2184 VSS_n206 VSS_n187 0.00133332
R2185 VSS_n204 VSS_n177 0.00133332
R2186 VSS_n192 VSS_n183 0.00133332
R2187 VSS_n190 VSS_n180 0.00133332
R2188 VSS_n63 VSS_n50 0.00133332
R2189 VSS_n60 VSS_n41 0.00133332
R2190 VSS_n59 VSS_n52 0.00133332
R2191 VSS_n654 VSS_n107 0.00133332
R2192 VSS_n97 VSS_n89 0.00133332
R2193 VSS_n96 VSS_n91 0.00133332
R2194 VSS_n534 VSS_n423 0.00124998
R2195 VSS_n595 VSS_n328 0.00124998
R2196 VSS_n595 VSS_n594 0.00124998
R2197 VSS_n579 VSS_n578 0.00124998
R2198 VSS_n214 VSS_n55 0.00124998
R2199 VSS_n138 VSS_n93 0.00124998
R2200 VSS_n373 VSS_n286 0.00124998
R2201 VSS_n541 VSS_n540 0.001
R2202 VSS_n548 VSS_n547 0.001
R2203 VSS_n548 VSS_n419 0.001
R2204 VSS_n417 VSS_n416 0.001
R2205 VSS_n540 VSS_n1 0.001
R2206 VSS_n421 VSS_n419 0.001
R2207 VSS_n547 VSS_n417 0.001
R2208 VSS_n416 VSS_n1 0.001
R2209 VSS_n458 VSS_n457 0.001
R2210 VSS_n452 VSS_n450 0.001
R2211 VSS_n449 VSS_n448 0.001
R2212 VSS_n448 VSS_n4 0.001
R2213 VSS_n450 VSS_n449 0.001
R2214 VSS_n458 VSS_n5 0.001
R2215 VSS_n275 VSS_n274 0.001
R2216 VSS_n633 VSS_n239 0.001
R2217 VSS_n272 VSS_n268 0.001
R2218 VSS_n271 VSS_n154 0.001
R2219 VSS_n637 VSS_n237 0.001
R2220 VSS_n525 VSS_n524 0.001
R2221 VSS_n524 VSS_n523 0.001
R2222 VSS_n522 VSS_n430 0.001
R2223 VSS_n469 VSS_n466 0.001
R2224 VSS_n496 VSS_n464 0.001
R2225 VSS_n495 VSS_n468 0.001
R2226 VSS_n489 VSS_n465 0.001
R2227 VSS_n489 VSS_n467 0.001
R2228 VSS_n473 VSS_n471 0.001
R2229 VSS_n479 VSS_n478 0.001
R2230 VSS_n478 VSS_n439 0.001
R2231 VSS_n499 VSS_n498 0.001
R2232 VSS_n597 VSS_n330 0.001
R2233 VSS_n597 VSS_n343 0.001
R2234 VSS_n593 VSS_n583 0.001
R2235 VSS_n589 VSS_n588 0.001
R2236 VSS_n333 VSS_n332 0.001
R2237 VSS_n603 VSS_n602 0.001
R2238 VSS_n618 VSS_n303 0.001
R2239 VSS_n614 VSS_n325 0.001
R2240 VSS_n612 VSS_n325 0.001
R2241 VSS_n618 VSS_n306 0.001
R2242 VSS_n413 VSS_n360 0.001
R2243 VSS_n577 VSS_n411 0.001
R2244 VSS_n572 VSS_n571 0.001
R2245 VSS_n563 VSS_n562 0.001
R2246 VSS_n560 VSS_n559 0.001
R2247 VSS_n555 VSS_n554 0.001
R2248 VSS_n375 VSS_n286 0.001
R2249 VSS_n376 VSS_n370 0.001
R2250 VSS_n371 VSS_n367 0.001
R2251 VSS_n284 VSS_n5 0.001
R2252 VSS_n146 VSS_n109 0.001
R2253 VSS_n147 VSS_n146 0.001
R2254 VSS_n150 VSS_n149 0.001
R2255 VSS_n124 VSS_n123 0.001
R2256 VSS_n126 VSS_n110 0.001
R2257 VSS_n126 VSS_n108 0.001
R2258 VSS_n643 VSS_n642 0.001
R2259 VSS_n642 VSS_n120 0.001
R2260 VSS_n630 VSS_n21 0.001
R2261 VSS_n629 VSS_n21 0.001
R2262 VSS_n279 VSS_n17 0.001
R2263 VSS_n627 VSS_n15 0.001
R2264 VSS_n280 VSS_n15 0.001
R2265 VSS_n281 VSS_n14 0.001
R2266 VSS_n626 VSS_n12 0.001
R2267 VSS_n282 VSS_n12 0.001
R2268 VSS_n625 VSS_n10 0.001
R2269 VSS_n283 VSS_n10 0.001
R2270 VSS_n250 VSS_n35 0.001
R2271 VSS_n251 VSS_n35 0.001
R2272 VSS_n249 VSS_n33 0.001
R2273 VSS_n252 VSS_n31 0.001
R2274 VSS_n254 VSS_n28 0.001
R2275 VSS_n255 VSS_n27 0.001
R2276 VSS_n245 VSS_n25 0.001
R2277 VSS_n256 VSS_n25 0.001
R2278 VSS_n244 VSS_n23 0.001
R2279 VSS_n210 VSS_n189 0.001
R2280 VSS_n210 VSS_n176 0.001
R2281 VSS_n206 VSS_n188 0.001
R2282 VSS_n200 VSS_n186 0.001
R2283 VSS_n200 VSS_n178 0.001
R2284 VSS_n196 VSS_n185 0.001
R2285 VSS_n196 VSS_n179 0.001
R2286 VSS_n192 VSS_n184 0.001
R2287 VSS_n182 VSS_n181 0.001
R2288 VSS_n685 VSS_n684 0.001
R2289 VSS_n46 VSS_n39 0.001
R2290 VSS_n67 VSS_n47 0.001
R2291 VSS_n66 VSS_n45 0.001
R2292 VSS_n66 VSS_n49 0.001
R2293 VSS_n64 VSS_n44 0.001
R2294 VSS_n63 VSS_n43 0.001
R2295 VSS_n62 VSS_n42 0.001
R2296 VSS_n60 VSS_n51 0.001
R2297 VSS_n57 VSS_n53 0.001
R2298 VSS_n681 VSS_n54 0.001
R2299 VSS_n682 VSS_n681 0.001
R2300 VSS_n139 VSS_n137 0.001
R2301 VSS_n136 VSS_n135 0.001
R2302 VSS_n132 VSS_n131 0.001
R2303 VSS_n97 VSS_n90 0.001
R2304 VSS_n661 VSS_n92 0.001
R2305 VSS_n662 VSS_n661 0.001
R2306 VSS_n134 VSS_n132 0.001
R2307 VSS_n135 VSS_n134 0.001
R2308 VSS_n137 VSS_n136 0.001
R2309 VSS_n654 VSS_n90 0.001
R2310 VSS_n95 VSS_n92 0.001
R2311 VSS_n662 VSS_n93 0.001
R2312 VSS_n182 VSS_n37 0.001
R2313 VSS_n194 VSS_n184 0.001
R2314 VSS_n194 VSS_n179 0.001
R2315 VSS_n198 VSS_n185 0.001
R2316 VSS_n198 VSS_n178 0.001
R2317 VSS_n202 VSS_n186 0.001
R2318 VSS_n208 VSS_n188 0.001
R2319 VSS_n208 VSS_n176 0.001
R2320 VSS_n213 VSS_n189 0.001
R2321 VSS_n684 VSS_n37 0.001
R2322 VSS_n685 VSS_n39 0.001
R2323 VSS_n47 VSS_n46 0.001
R2324 VSS_n67 VSS_n45 0.001
R2325 VSS_n65 VSS_n49 0.001
R2326 VSS_n65 VSS_n44 0.001
R2327 VSS_n64 VSS_n43 0.001
R2328 VSS_n61 VSS_n42 0.001
R2329 VSS_n61 VSS_n51 0.001
R2330 VSS_n58 VSS_n53 0.001
R2331 VSS_n57 VSS_n54 0.001
R2332 VSS_n682 VSS_n55 0.001
R2333 VSS_n283 VSS_n9 0.001
R2334 VSS_n625 VSS_n11 0.001
R2335 VSS_n282 VSS_n11 0.001
R2336 VSS_n626 VSS_n13 0.001
R2337 VSS_n281 VSS_n13 0.001
R2338 VSS_n280 VSS_n14 0.001
R2339 VSS_n627 VSS_n16 0.001
R2340 VSS_n279 VSS_n16 0.001
R2341 VSS_n629 VSS_n20 0.001
R2342 VSS_n630 VSS_n22 0.001
R2343 VSS_n250 VSS_n8 0.001
R2344 VSS_n251 VSS_n34 0.001
R2345 VSS_n249 VSS_n34 0.001
R2346 VSS_n252 VSS_n32 0.001
R2347 VSS_n254 VSS_n29 0.001
R2348 VSS_n255 VSS_n26 0.001
R2349 VSS_n245 VSS_n26 0.001
R2350 VSS_n256 VSS_n24 0.001
R2351 VSS_n244 VSS_n24 0.001
R2352 VSS_n147 VSS_n124 0.001
R2353 VSS_n123 VSS_n122 0.001
R2354 VSS_n149 VSS_n122 0.001
R2355 VSS_n150 VSS_n120 0.001
R2356 VSS_n128 VSS_n109 0.001
R2357 VSS_n128 VSS_n110 0.001
R2358 VSS_n111 VSS_n108 0.001
R2359 VSS_n643 VSS_n111 0.001
R2360 VSS_n284 VSS_n4 0.001
R2361 VSS_n371 VSS_n368 0.001
R2362 VSS_n370 VSS_n369 0.001
R2363 VSS_n376 VSS_n375 0.001
R2364 VSS_n570 VSS_n413 0.001
R2365 VSS_n571 VSS_n570 0.001
R2366 VSS_n574 VSS_n411 0.001
R2367 VSS_n562 VSS_n360 0.001
R2368 VSS_n560 VSS_n558 0.001
R2369 VSS_n558 VSS_n554 0.001
R2370 VSS_n611 VSS_n303 0.001
R2371 VSS_n612 VSS_n611 0.001
R2372 VSS_n615 VSS_n614 0.001
R2373 VSS_n615 VSS_n306 0.001
R2374 VSS_n586 VSS_n343 0.001
R2375 VSS_n590 VSS_n589 0.001
R2376 VSS_n590 VSS_n583 0.001
R2377 VSS_n336 VSS_n330 0.001
R2378 VSS_n336 VSS_n332 0.001
R2379 VSS_n603 VSS_n333 0.001
R2380 VSS_n487 VSS_n466 0.001
R2381 VSS_n487 VSS_n467 0.001
R2382 VSS_n491 VSS_n465 0.001
R2383 VSS_n491 VSS_n468 0.001
R2384 VSS_n496 VSS_n495 0.001
R2385 VSS_n498 VSS_n464 0.001
R2386 VSS_n482 VSS_n471 0.001
R2387 VSS_n479 VSS_n475 0.001
R2388 VSS_n499 VSS_n439 0.001
R2389 VSS_n526 VSS_n525 0.001
R2390 VSS_n523 VSS_n522 0.001
R2391 VSS_n534 VSS_n430 0.001
R2392 VSS_n634 VSS_n633 0.001
R2393 VSS_n634 VSS_n237 0.001
R2394 VSS_n274 VSS_n268 0.001
R2395 VSS_n272 VSS_n271 0.001
R2396 VSS_n637 VSS_n154 0.001
C0 pn16 VDD 46.8428f
C1 pn3 pn15 0.54154f
C2 pn16 pn7 0.03181f
C3 pn10 V_out 0.29706f
C4 pn3 pn5 0.10851f
C5 pn3 V_inn 0.01973f
C6 pn3 pn1 0.67514f
C7 pn3 I_bias 0.18368f
C8 pn15 pn13 0.20728f
C9 pn13 pn5 0.16069f
C10 V_inn pn13 0.03986f
C11 V_inn pn15 1.99073f
C12 pn4 pn3 0.19451f
C13 pn3 VDD 2.04699f
C14 pn7 pn3 0.01743f
C15 V_out pn3 0.02167f
C16 pn11 pn9 0.02718f
C17 I_bias pn6 0.01526f
C18 pn11 pn16 0.02269f
C19 pn2 pn13 1.4573f
C20 pn4 pn15 1.06048f
C21 pn13 VDD 6.27803f
C22 pn2 pn15 0.20503f
C23 pn7 pn13 0.57012f
C24 pn8 pn14 0.10314f
C25 pn15 VDD 0.70879f
C26 pn4 pn1 0.01807f
C27 V_out pn13 1.35215f
C28 pn7 pn15 0.27056f
C29 pn12 pn14 1.1511f
C30 V_inn VDD 7.33772f
C31 pn4 pn6 0.01521f
C32 V_inp pn14 0.3573f
C33 pn8 pn10 0.02725f
C34 pn2 pn6 0.09267f
C35 V_out pn5 0.97386f
C36 pn4 I_bias 0.3157f
C37 V_out V_inn 0.01327f
C38 pn12 pn10 0.52777f
C39 V_inp pn9 0.56665f
C40 pn2 I_bias 0.14684f
C41 pn7 pn6 0.01014f
C42 V_inp pn10 1.39878f
C43 I_bias VDD 0.02179f
C44 pn7 I_bias 0.10035f
C45 V_inp pn16 0.10604f
C46 pn2 pn4 0.13716f
C47 pn11 pn3 0.0148f
C48 pn4 VDD 0.81214f
C49 pn7 pn4 0.18634f
C50 pn2 VDD 1.18142f
C51 V_out pn4 0.02504f
C52 pn7 pn2 0.30114f
C53 pn7 VDD 5.28473f
C54 V_out pn2 0.89516f
C55 V_out VDD 2.30237f
C56 V_out pn7 0.12863f
C57 pn15 a_n9794_n1458_ 0.036f
C58 pn8 pn3 0.39181f
C59 pn1 a_n9794_n1458_ 0.0275f
C60 pn12 pn3 0.34986f
C61 V_inp pn3 0.13481f
C62 I_bias a_n9794_n1458_ 0.01527f
C63 pn8 pn13 0.73924f
C64 pn8 pn15 0.11326f
C65 pn12 pn13 0.52945f
C66 pn4 a_n9794_n1458_ 0.13861f
C67 V_inp pn13 0.29697f
C68 pn12 pn15 0.31876f
C69 pn2 a_n9794_n1458_ 0.0609f
C70 V_inp pn15 0.45405f
C71 pn11 VDD 1.80953f
C72 pn11 pn7 0.17186f
C73 pn12 pn4 1.07882f
C74 pn8 pn2 0.42393f
C75 pn8 VDD 6.00111f
C76 pn9 pn14 0.57521f
C77 pn12 pn2 0.3585f
C78 V_inp pn4 0.04431f
C79 pn8 pn7 0.01193f
C80 pn12 VDD 0.83763f
C81 pn10 pn14 0.19957f
C82 V_inp pn2 0.02242f
C83 pn12 pn7 0.01692f
C84 pn8 V_out 0.22442f
C85 V_inp VDD 7.25158f
C86 pn16 pn14 0.0288f
C87 pn12 V_out 1.44764f
C88 V_inp pn7 0.14897f
C89 pn16 pn9 2.40691f
C90 V_inp V_out 0.123f
C91 pn16 pn10 2.92399f
C92 pn3 a_n5020_223_ 0.01072f
C93 pn14 pn3 0.06846f
C94 pn9 pn3 1.33154f
C95 pn13 a_n5020_223_ 0.0438f
C96 pn16 pn3 0.44685f
C97 pn11 V_inp 0.01565f
C98 pn5 a_n5020_223_ 0.06289f
C99 pn14 pn13 0.16354f
C100 pn9 pn13 0.52315f
C101 pn14 pn15 1.06987f
C102 pn10 pn13 0.11688f
C103 pn14 V_inn 0.28864f
C104 pn12 pn8 0.20624f
C105 pn9 V_inn 0.1856f
C106 pn10 pn15 0.82491f
C107 pn16 pn13 0.04374f
C108 V_inp pn8 0.01993f
C109 pn14 pn6 0.1093f
C110 pn10 V_inn 1.7346f
C111 V_inp pn12 1.68139f
C112 pn16 V_inn 0.41191f
C113 pn9 I_bias 0.3852f
C114 pn16 I_bias 0.63956f
C115 pn14 pn4 0.04234f
C116 pn9 pn4 1.59468f
C117 pn14 pn2 0.59982f
C118 pn14 VDD 5.10986f
C119 pn14 pn7 0.46747f
C120 pn9 VDD 19.1691f
C121 pn14 V_out 0.07765f
C122 pn16 pn4 0.03972f
C123 pn9 pn7 0.3042f
C124 pn10 VDD 11.0694f
C125 pn3 pn13 0.81654f
C126 pn10 pn7 0.1344f
C127 pn5 VSS 6.70652f
C128 pn1 VSS 8.74284f
C129 I_bias VSS 9.21747f
C130 pn12 VSS 5.32268f
C131 V_inp VSS 1.46527f
C132 pn11 VSS 0.11377f
C133 pn2 VSS 3.96022f
C134 V_out VSS 16.26639f
C135 pn13 VSS 9.24853f
C136 pn15 VSS 9.09885f
C137 V_inn VSS 1.5799f
C138 pn14 VSS 5.90228f
C139 pn10 VSS 1.07126f
C140 pn16 VSS 7.30791f
C141 VDD VSS 4.33395f
C142 VSS_t10 VSS 6.04481f
C143 VSS_t14 VSS 0.53044f
C144 VSS_t16 VSS 0.28779f
C145 VSS_t1 VSS 1.08502f
C146 VSS_t6 VSS 0.49258f
C147 VSS_t24 VSS 0.09833f
C148 VSS_t26 VSS 0.14165f
C149 VSS_t22 VSS 0.08535f
C150 VSS_t18 VSS 0.11439f
C151 VSS_t20 VSS 0.26871f
C152 VSS_t12 VSS 0.52099f
C153 VDD_n1 VSS 0.01106f
C154 VDD_n2 VSS 0.01106f
C155 VDD_n3 VSS 0.01106f
C156 VDD_n4 VSS 0.01106f
C157 VDD_n5 VSS 0.01106f
C158 VDD_n6 VSS 0.01106f
C159 VDD_n7 VSS 0.01448f
C160 VDD_n8 VSS 0.01106f
C161 VDD_n9 VSS 0.01106f
C162 VDD_n10 VSS 0.01106f
C163 VDD_n11 VSS 0.01106f
C164 VDD_n12 VSS 0.01659f
C165 VDD_n13 VSS 0.14379f
C166 VDD_n14 VSS 0.42485f
C167 VDD_n15 VSS 0.02027f
C168 VDD_n16 VSS 0.04454f
C169 VDD_n17 VSS 0.22511f
C170 VDD_n18 VSS 0.01019f
C171 VDD_n19 VSS 0.09459f
C172 VDD_n20 VSS 0.5026f
C173 VDD_n21 VSS 0.03585f
C174 VDD_n22 VSS 0.38777f
C175 VDD_t7 VSS 1.45739f
C176 VDD_n23 VSS 0.09315f
C177 VDD_n24 VSS 0.04519f
C178 VDD_t21 VSS 8.25282f
C179 VDD_n39 VSS 1.22531f
C180 VDD_n45 VSS 0.61265f
C181 VDD_n47 VSS 0.61265f
C182 VDD_n48 VSS 0.61265f
C183 VDD_n49 VSS 0.61265f
C184 VDD_n50 VSS 0.61265f
C185 VDD_n52 VSS 0.61265f
C186 VDD_t48 VSS 0.61265f
C187 VDD_t28 VSS 1.22531f
C188 VDD_n59 VSS 0.61265f
C189 VDD_n62 VSS 0.61265f
C190 VDD_n63 VSS 1.22531f
C191 VDD_n65 VSS 0.61265f
C192 VDD_t26 VSS 0.61265f
C193 VDD_t6 VSS 1.70282f
C194 VDD_n67 VSS 0.36987f
C195 VDD_n68 VSS 0.61265f
C196 VDD_n70 VSS 0.0247f
C197 VDD_n71 VSS 0.02308f
C198 VDD_n72 VSS 0.18576f
C199 VDD_t49 VSS 0.40774f
C200 VDD_n73 VSS 0.0125f
C201 VDD_n76 VSS 0.2609f
C202 VDD_t1 VSS 0.52304f
C203 VDD_n78 VSS 0.09125f
C204 VDD_t4 VSS 0.61265f
C205 VDD_t0 VSS 1.39649f
C206 VDD_n83 VSS 0.61265f
C207 VDD_n85 VSS 0.61265f
C208 VDD_n86 VSS 0.61265f
C209 VDD_n88 VSS 0.61265f
C210 VDD_n89 VSS 1.22531f
C211 VDD_t23 VSS 1.53164f
C212 VDD_n90 VSS 0.31295f
C213 VDD_n91 VSS 0.1697f
C214 VDD_n92 VSS 0.07197f
C215 VDD_n93 VSS 0.07379f
C216 VDD_n94 VSS 0.10796f
C217 VDD_n95 VSS 0.07506f
C218 VDD_n96 VSS 0.07998f
C219 VDD_n97 VSS 0.01222f
C220 VDD_n98 VSS 0.04444f
C221 VDD_n100 VSS 0.081f
C222 VDD_n101 VSS 0.06356f
C223 VDD_n102 VSS 0.03711f
C224 VDD_n104 VSS 0.61265f
C225 VDD_n106 VSS 0.61265f
C226 VDD_n108 VSS 0.61265f
C227 VDD_n110 VSS 0.61265f
C228 VDD_t34 VSS 0.72077f
C229 VDD_n113 VSS 0.50454f
C230 VDD_n115 VSS 0.61265f
C231 VDD_n117 VSS 0.61265f
C232 VDD_t2 VSS 0.87844f
C233 VDD_n120 VSS 0.57211f
C234 VDD_n122 VSS 0.61265f
C235 VDD_t32 VSS 1.83796f
C236 VDD_n125 VSS 0.61265f
C237 VDD_n127 VSS 0.61265f
C238 VDD_n129 VSS 0.61265f
C239 VDD_n130 VSS 0.61265f
C240 VDD_n132 VSS 0.61265f
C241 VDD_t9 VSS 0.1603f
C242 VDD_t10 VSS 4.4909f
C243 VDD_n134 VSS 0.05921f
C244 VDD_t12 VSS 0.11188f
C245 VDD_n135 VSS 0.04993f
C246 VDD_n136 VSS 0.09623f
C247 VDD_n137 VSS 0.09769f
C248 VDD_n138 VSS 0.2951f
C249 VDD_n139 VSS 1.22531f
C250 VDD_n140 VSS 0.06319f
C251 VDD_n150 VSS 0.10024f
C252 VDD_n151 VSS 0.12116f
C253 VDD_n152 VSS 0.40398f
C254 VDD_n153 VSS 3.98248f
C255 VDD_n154 VSS 0.01106f
C256 VDD_n155 VSS 0.10755f
C257 VDD_n156 VSS 0.01072f
C258 VDD_n157 VSS 0.01107f
C259 VDD_n159 VSS 0.01659f
C260 VDD_n161 VSS 0.01659f
C261 VDD_n163 VSS 0.56864f
C262 VDD_n164 VSS 0.03348f
C263 VDD_t45 VSS 1.43158f
C264 VDD_t44 VSS 1.41428f
C265 VDD_t43 VSS 1.41428f
C266 VDD_t42 VSS 1.41428f
C267 VDD_t41 VSS 1.41427f
C268 VDD_t39 VSS 1.41428f
C269 VDD_t37 VSS 1.41428f
C270 VDD_t20 VSS 1.43266f
C271 VDD_n165 VSS 0.06986f
C272 VDD_n166 VSS 0.05003f
C273 VDD_n167 VSS 0.05004f
C274 VDD_n168 VSS 0.05003f
C275 VDD_n169 VSS 0.05003f
C276 VDD_n170 VSS 0.05003f
C277 VDD_n171 VSS 0.04254f
C278 VDD_n172 VSS 1.22531f
C279 VDD_n173 VSS 0.08997f
C280 VDD_n174 VSS 0.02165f
C281 VDD_n178 VSS 0.937f
C282 VDD_n179 VSS 0.47657f
C283 VDD_t38 VSS 0.44147f
C284 VDD_n180 VSS 0.19352f
C285 VDD_n182 VSS 0.61265f
C286 VDD_n184 VSS 0.61265f
C287 VDD_n186 VSS 0.61265f
C288 VDD_n188 VSS 0.61265f
C289 VDD_t50 VSS 0.61265f
C290 VDD_n192 VSS 0.61265f
C291 VDD_n193 VSS 0.24181f
C292 VDD_n194 VSS 0.08446f
C293 VDD_n195 VSS 0.08858f
C294 VDD_n197 VSS 0.61265f
C295 VDD_t16 VSS 1.09715f
C296 VDD_t19 VSS 0.13974f
C297 VDD_t14 VSS 0.13974f
C298 VDD_n199 VSS 0.08557f
C299 VDD_n200 VSS 0.08175f
C300 VDD_n201 VSS 0.01729f
C301 VDD_t36 VSS 0.61265f
C302 VDD_n204 VSS 0.61265f
C303 VDD_t18 VSS 0.61265f
C304 VDD_n205 VSS 0.61265f
C305 VDD_t17 VSS 0.61265f
C306 VDD_t15 VSS 0.61265f
C307 VDD_t13 VSS 0.61265f
C308 VDD_n211 VSS 0.61265f
C309 VDD_n212 VSS 0.61265f
C310 VDD_n214 VSS 1.22531f
C311 VDD_n216 VSS 0.45575f
C312 VDD_n218 VSS 0.72978f
C313 VDD_t52 VSS 1.22508f
C314 VDD_n220 VSS 0.11206f
C315 VDD_n221 VSS 0.01582f
C316 VDD_n222 VSS 0.61265f
C317 VDD_n224 VSS 0.61265f
C318 VDD_n227 VSS 0.78384f
C319 VDD_t46 VSS 0.70275f
C320 VDD_n228 VSS 0.61265f
C321 VDD_n230 VSS 0.12418f
C322 VDD_t51 VSS 1.88684f
C323 VDD_n231 VSS 0.12442f
C324 VDD_n232 VSS 0.11675f
C325 VDD_n233 VSS 0.06927f
C326 VDD_n234 VSS 0.1035f
C327 VDD_n235 VSS 0.0288f
C328 VDD_n236 VSS 0.09151f
C329 VDD_n237 VSS 0.10597f
C330 VDD_n238 VSS 0.08675f
C331 VDD_n239 VSS 0.0612f
C332 VDD_n240 VSS 0.04339f
C333 VDD_n241 VSS 1.53164f
C334 VDD_n242 VSS 0.47657f
C335 VDD_n244 VSS 0.61265f
C336 VDD_n246 VSS 0.2609f
C337 VDD_t40 VSS 9.20202f
C338 VDD_n249 VSS 0.08039f
C339 VDD_n250 VSS 0.32491f
C340 VDD_n251 VSS 0.10296f
C341 VDD_n252 VSS 0.04669f
C342 VDD_n253 VSS 0.0451f
C343 VDD_n254 VSS 0.01475f
C344 VDD_n255 VSS 0.01474f
C345 VDD_n256 VSS 0.01106f
C346 VDD_n258 VSS 0.01659f
C347 VDD_n260 VSS 0.04298f
C348 VDD_n261 VSS 0.06139f
C349 VDD_n262 VSS 0.07453f
C350 VDD_n263 VSS 0.10813f
C351 VDD_n264 VSS 0.05768f
C352 VDD_n265 VSS 1.22531f
C353 VDD_n266 VSS 1.22531f
C354 VDD_n267 VSS 1.83796f
C355 VDD_n268 VSS 1.83796f
C356 VDD_n270 VSS 1.83796f
C357 VDD_n271 VSS 1.22531f
C358 VDD_n272 VSS 0.97304f
C359 VDD_n273 VSS 0.01301f
C360 VDD_n274 VSS 0.01475f
C361 VDD_n277 VSS 0.01106f
C362 VDD_n278 VSS 0.01474f
C363 VDD_n279 VSS 0.01475f
C364 VDD_n280 VSS 0.01659f
C365 VDD_n282 VSS 0.01659f
C366 VDD_n285 VSS 0.01106f
C367 VDD_n286 VSS 0.01365f
C368 VDD_n287 VSS 0.01152f
C369 VDD_n288 VSS 0.01365f
C370 VDD_n291 VSS 0.01106f
C371 VDD_n292 VSS 0.05963f
C372 VDD_n293 VSS 0.0129f
C373 VDD_n294 VSS 0.01291f
C374 VDD_n295 VSS 0.01659f
C375 VDD_n297 VSS 0.01106f
C376 VDD_t47 VSS 1.69381f
C377 VDD_n299 VSS 0.3432f
C378 VDD_n301 VSS 1.83796f
C379 VDD_n303 VSS 0.6864f
C380 VDD_t35 VSS 1.4143f
C381 VDD_t33 VSS 1.41427f
C382 VDD_t31 VSS 1.41427f
C383 VDD_t29 VSS 1.41427f
C384 VDD_t27 VSS 1.41429f
C385 VDD_t25 VSS 1.41428f
C386 VDD_t24 VSS 1.41428f
C387 VDD_t22 VSS 1.43264f
C388 VDD_n305 VSS 0.06986f
C389 VDD_n306 VSS 0.05003f
C390 VDD_n307 VSS 0.05002f
C391 VDD_n308 VSS 0.05004f
C392 VDD_n309 VSS 0.05004f
C393 VDD_n310 VSS 0.05003f
C394 VDD_n311 VSS 0.04253f
C395 VDD_n312 VSS 0.03537f
C396 VDD_n314 VSS 4.45076f
C397 VDD_n315 VSS 0.61265f
C398 VDD_n317 VSS 0.61265f
C399 VDD_n319 VSS 0.65744f
C400 VDD_t30 VSS 4.56788f
C401 VDD_n320 VSS 0.53773f
C402 VDD_t5 VSS 2.83841f
C403 VDD_n321 VSS 0.10439f
C404 VDD_n322 VSS 0.38861f
C405 VDD_n323 VSS 0.07757f
C406 VDD_n324 VSS 0.08842f
C407 VDD_n325 VSS 0.07996f
C408 VDD_n326 VSS 0.08474f
C409 VDD_t3 VSS 2.21895f
C410 VDD_t8 VSS 0.16326f
C411 VDD_n327 VSS 0.0706f
C412 VDD_n328 VSS 0.06692f
C413 VDD_n329 VSS 0.01518f
C414 VDD_n330 VSS 0.07659f
C415 VDD_n331 VSS 0.1496f
C416 VDD_n332 VSS 0.11681f
C417 VDD_n333 VSS 0.06408f
C418 VDD_n334 VSS 0.08918f
C419 VDD_n335 VSS 0.06919f
C420 VDD_n336 VSS 0.09853f
C421 VDD_n337 VSS 0.27424f
C422 VDD_n338 VSS 0.1265f
C423 VDD_n339 VSS 0.05074f
C424 VDD_n340 VSS 0.0129f
C425 VDD_n341 VSS 0.01106f
C426 VDD_n342 VSS 0.01106f
C427 VDD_n343 VSS 0.01239f
C428 VDD_n344 VSS 0.01182f
C429 VDD_n345 VSS 0.01239f
C430 VDD_n346 VSS 0.01106f
C431 VDD_n347 VSS 0.01106f
C432 VDD_n348 VSS 0.01106f
C433 VDD_n349 VSS 0.01057f
C434 VDD_n350 VSS 0.0131f
C435 VDD_n351 VSS 0.07872f
C436 pn16_t9 VSS 1.70939f
C437 pn16_t1 VSS 1.70938f
C438 pn16_t14 VSS 1.70938f
C439 pn16_t11 VSS 1.70936f
C440 pn16_t5 VSS 1.70939f
C441 pn16_t3 VSS 1.70936f
C442 pn16_t7 VSS 1.75814f
C443 pn16_n0 VSS 0.18484f
C444 pn16_n1 VSS 0.13246f
C445 pn16_n2 VSS 0.13249f
C446 pn16_n3 VSS 0.13247f
C447 pn16_n4 VSS 0.13247f
C448 pn16_n5 VSS 0.17221f
C449 pn16_t15 VSS 3.54243f
C450 pn16_n6 VSS 2.33095f
C451 pn16_n7 VSS 0.27183f
C452 pn16_n8 VSS 0.16607f
C453 pn16_n9 VSS 0.16607f
C454 pn16_n10 VSS 0.16607f
C455 pn16_n11 VSS 0.16607f
C456 pn16_n12 VSS 0.16428f
C457 pn16_n13 VSS 0.88966f
C458 pn16_n14 VSS 0.88957f
C459 pn16_n15 VSS 0.16415f
C460 pn16_n16 VSS 0.16607f
C461 pn16_n17 VSS 0.16607f
C462 pn16_n18 VSS 0.16607f
C463 pn16_n19 VSS 0.16607f
C464 pn16_n20 VSS 0.14865f
C465 pn16_n21 VSS 0.07446f
C466 pn16_n22 VSS 0.09361f
C467 pn16_n23 VSS 0.14078f
C468 pn10_t10 VSS 0.87064f
C469 pn10_t8 VSS 0.81043f
C470 pn10_t7 VSS 0.86775f
C471 pn10_t9 VSS 5.27781f
C472 pn10_n0 VSS 0.44598f
C473 pn10_n1 VSS 0.48159f
C474 pn10_t1 VSS 2.07916f
C475 pn10_t0 VSS 2.07919f
C476 pn10_t6 VSS 2.07917f
C477 pn10_t4 VSS 2.07916f
C478 pn10_t12 VSS 2.0792f
C479 pn10_t2 VSS 2.07921f
C480 pn10_t3 VSS 2.18326f
C481 pn10_n2 VSS 0.32903f
C482 pn10_n3 VSS 0.23582f
C483 pn10_n4 VSS 0.23586f
C484 pn10_n5 VSS 0.23585f
C485 pn10_n6 VSS 0.23583f
C486 pn10_n7 VSS 0.22102f
C487 pn10_t5 VSS 2.08792f
C488 pn10_n8 VSS 0.87385f
C489 pn10_n9 VSS 3.08447f
C490 pn10_t11 VSS 5.47222f
C491 pn10_n10 VSS 0.93605f
C492 pn9_n0 VSS 0.04841f
C493 pn9_n1 VSS 0.1167f
C494 pn9_n2 VSS 1.88312f
C495 pn9_t2 VSS 0.83779f
C496 pn9_t1 VSS 0.61168f
C497 pn9_n3 VSS 0.69254f
C498 pn9_n4 VSS 2.3913f
C499 pn9_n5 VSS 1.10721f
C500 pn9_n6 VSS 0.30152f
C501 pn9_n7 VSS 0.02597f
C502 pn9_n8 VSS 0.04902f
C503 pn14_t1 VSS 0.1291f
C504 pn14_n0 VSS 0.80127f
C505 pn14_n1 VSS 6.26948f
C506 pn3_t1 VSS 5.38872f
C507 pn3_n0 VSS 1.46662f
C508 pn3_t0 VSS 3.15373f
C509 pn3_n1 VSS 2.41717f
C510 pn3_n2 VSS 0.10105f
C511 V_inn_n0 VSS 0.11552f
C512 V_inn_n1 VSS 0.04603f
C513 V_inn_n2 VSS 0.04635f
C514 V_inn_n3 VSS 0.04606f
C515 V_inn_n4 VSS 0.0336f
C516 V_inn_n5 VSS 0.0252f
C517 V_inn_n6 VSS 0.03347f
C518 V_inn_n7 VSS 0.04671f
C519 V_inn_n8 VSS 0.0467f
C520 V_inn_n9 VSS 0.04635f
C521 V_inn_n10 VSS 2.05888f
C522 pn15_t1 VSS 0.65338f
C523 pn15_t0 VSS 2.04979f
C524 pn15_t2 VSS 1.09516f
C525 pn15_n0 VSS 2.00171f
C526 pn15_n1 VSS 2.6178f
C527 pn13_t0 VSS 1.50912f
C528 pn13_t1 VSS 0.36791f
C529 pn13_n0 VSS 1.29265f
C530 pn13_t4 VSS 0.72727f
C531 pn13_n1 VSS 0.71769f
C532 pn13_t3 VSS 2.73022f
C533 pn13_n2 VSS 1.60198f
C534 pn13_t2 VSS 1.01976f
C535 pn13_n3 VSS 0.98568f
C536 pn13_n4 VSS 2.15674f
C537 V_out_t0 VSS 1.18009f
C538 V_out_t1 VSS 0.20163f
C539 V_out_n0 VSS 0.77735f
C540 V_out_t2 VSS 0.60449f
C541 V_out_n1 VSS 1.85985f
C542 pn7_t1 VSS 0.57777f
C543 pn7_n0 VSS 5.22615f
C544 pn7_t0 VSS 1.26009f
C545 pn7_n1 VSS 0.32342f
C546 pn2_t0 VSS 1.88444f
C547 pn2_t1 VSS 0.45923f
C548 pn2_n0 VSS 0.39724f
C549 pn2_n1 VSS 3.14406f
C550 pn4_t2 VSS 6.20316f
C551 pn4_n0 VSS 0.56196f
C552 pn4_t1 VSS 0.17033f
C553 pn4_t0 VSS 4.55021f
C554 pn4_n1 VSS 0.76491f
C555 pn4_n2 VSS 0.61049f
C556 pn4_n3 VSS 0.10959f
C557 pn11_t0 VSS 1.2112f
C558 pn11_t2 VSS 0.59659f
C559 pn11_n0 VSS 0.75991f
C560 pn11_n1 VSS 0.31708f
C561 V_inp_n0 VSS 0.11835f
C562 V_inp_n1 VSS 0.04893f
C563 V_inp_n2 VSS 0.17322f
C564 V_inp_n3 VSS 0.04965f
C565 V_inp_n4 VSS 0.04862f
C566 V_inp_n5 VSS 2.17003f
C567 pn12_t1 VSS 5.25498f
C568 pn12_t0 VSS 0.92494f
C569 pn12_t2 VSS 1.09692f
C570 pn12_n0 VSS 1.61414f
C571 pn12_n1 VSS 4.81252f
C572 pn8_t0 VSS 2.08483f
C573 pn8_t2 VSS 1.56124f
C574 pn8_n0 VSS 1.228f
C575 pn8_n1 VSS 0.69608f
C576 I_bias_n0 VSS 0.09037f
C577 I_bias_t1 VSS 0.09404f
C578 I_bias_n2 VSS 0.02124f
C579 I_bias_n3 VSS 0.0141f
C580 I_bias_n4 VSS 0.12071f
C581 pn6_t0 VSS 0.11779f
C582 pn6_t1 VSS 0.52381f
C583 pn6_n0 VSS 0.11377f
C584 pn1_t0 VSS 1.3088f
XCM_1 pn5 V_out cap_cmomi w=10.200u l=8.650u mmin=1 mmax=4 feed=double subblock=0 m=1
XCM_2 pn5 V_out cap_cmomi w=10.200u l=8.650u mmin=1 mmax=4 feed=double subblock=0 m=1
XCM_3 pn5 V_out cap_cmomi w=10.200u l=8.650u mmin=1 mmax=4 feed=double subblock=0 m=1
XCM_4 pn5 V_out cap_cmomi w=10.200u l=8.650u mmin=1 mmax=4 feed=double subblock=0 m=1
XCM_5 pn12 V_out cap_cmomi w=26.160u l=25.560u mmin=1 mmax=4 feed=double subblock=0 m=1
.ends gain_ota
