** post-layout netlist of gain_network: kpex -> ngspice by scripts/pex_netlist.py (source: /foss/designs/sg13cmos5l_spma_ip__instramp/runs/pex/gain_network/kpex/gain_network__gain_network/gain_network_k25d_pex_netlist.spice)
.subckt gain_network S4 S5 S0 S2 S1 S3 AVDD V_CM V_IN2 V_OUT2 I_BIAS AVSS
XM_1 n248 S1 n213 AVSS sg13_lv_nmos L=0.13U W=0.3U AS=0.102P AD=0.102P PS=1.28U PD=1.28U rfmode=0
XM_2 n252 S5 n213 AVSS sg13_lv_nmos L=0.13U W=0.18U AS=0.1026P AD=0.1026P PS=1.34U PD=1.34U rfmode=0
XM_3 n251 S4 n213 AVSS sg13_lv_nmos L=0.13U W=0.18U AS=0.1026P AD=0.1026P PS=1.34U PD=1.34U rfmode=0
XM_4 n254 S0 n213 AVSS sg13_lv_nmos L=0.13U W=0.4U AS=0.136P AD=0.136P PS=1.48U PD=1.48U rfmode=0
XM_5 n250 S3 n213 AVSS sg13_lv_nmos L=0.13U W=0.18U AS=0.1026P AD=0.1026P PS=1.34U PD=1.34U rfmode=0
XM_6 n230 S5 AVSS AVSS sg13_lv_nmos L=0.13U W=0.74U AS=0.2516P AD=0.2516P PS=2.16U PD=2.16U rfmode=0
XM_7 n228 S4 AVSS AVSS sg13_lv_nmos L=0.13U W=0.74U AS=0.2516P AD=0.2516P PS=2.16U PD=2.16U rfmode=0
XM_8 n226 S3 AVSS AVSS sg13_lv_nmos L=0.13U W=0.74U AS=0.2516P AD=0.2516P PS=2.16U PD=2.16U rfmode=0
XM_9 n249 S2 n213 AVSS sg13_lv_nmos L=0.13U W=0.2U AS=0.104P AD=0.104P PS=1.34U PD=1.34U rfmode=0
XM_10 n224 S2 AVSS AVSS sg13_lv_nmos L=0.13U W=0.74U AS=0.2516P AD=0.2516P PS=2.16U PD=2.16U rfmode=0
XM_11 n222 S1 AVSS AVSS sg13_lv_nmos L=0.13U W=0.74U AS=0.2516P AD=0.2516P PS=2.16U PD=2.16U rfmode=0
XM_12 n220 S0 AVSS AVSS sg13_lv_nmos L=0.13U W=0.74U AS=0.2516P AD=0.2516P PS=2.16U PD=2.16U rfmode=0
XM_13 n44 n196 n69 AVSS sg13_lv_nmos L=0.5U W=0.84U AS=0.2856P AD=0.2856P PS=2.36U PD=2.36U rfmode=0
XM_14 AVSS I_BIAS I_BIAS AVSS sg13_lv_nmos L=2U W=0.87U AS=0.2958P AD=0.2958P PS=2.42U PD=2.42U rfmode=0
XM_15 n86 n24 n26 AVSS sg13_lv_nmos L=2U W=6.41U AS=2.1794P AD=2.1794P PS=13.5U PD=13.5U rfmode=0
XM_16 n33 n25 AVSS AVSS sg13_lv_nmos L=2U W=9.21U AS=3.1314P AD=3.1314P PS=19.1U PD=19.1U rfmode=0
XM_17 n215 I_BIAS AVSS AVSS sg13_lv_nmos L=2U W=6U AS=2.04P AD=2.04P PS=12.68U PD=12.68U rfmode=0
XM_18 n33 n24 n44 AVSS sg13_lv_nmos L=2U W=6.41U AS=2.1794P AD=2.1794P PS=13.5U PD=13.5U rfmode=0
XM_19 n25 n25 AVSS AVSS sg13_lv_nmos L=2U W=9.21U AS=3.1314P AD=3.1314P PS=19.1U PD=19.1U rfmode=0
XM_20 n153 I_BIAS AVSS AVSS sg13_lv_nmos L=2U W=0.87U AS=0.2958P AD=0.2958P PS=2.42U PD=2.42U rfmode=0
XM_21 n196 n196 n93 AVSS sg13_lv_nmos L=0.5U W=0.84U AS=0.2856P AD=0.2856P PS=2.36U PD=2.36U rfmode=0
XM_22 AVSS n25 n26 AVSS sg13_lv_nmos L=2U W=9.21U AS=3.1314P AD=3.1314P PS=19.1U PD=19.1U rfmode=0
XM_23 n69 I_BIAS AVSS AVSS sg13_lv_nmos L=2U W=3.2U AS=1.088P AD=1.088P PS=7.08U PD=7.08U rfmode=0
XM_24 n24 n24 n10 AVSS sg13_lv_nmos L=2U W=1.6U AS=0.544P AD=0.544P PS=3.88U PD=3.88U rfmode=0
XM_25 V_OUT2 n69 AVSS AVSS sg13_lv_nmos L=0.5U W=8.4U AS=2.856P AD=2.856P PS=17.48U PD=17.48U rfmode=0
XM_26 n100 I_BIAS AVSS AVSS sg13_lv_nmos L=2U W=1.74U AS=0.5916P AD=0.5916P PS=4.16U PD=4.16U rfmode=0
XM_27 n93 n93 AVSS AVSS sg13_lv_nmos L=0.5U W=2.1U AS=0.714P AD=0.714P PS=4.88U PD=4.88U rfmode=0
XM_28 n145 n100 n100 AVDD sg13_lv_pmos L=0.5U W=2.2U AS=0.748P AD=0.748P PS=5.08U PD=5.08U rfmode=0
XM_29 AVDD n145 n145 AVDD sg13_lv_pmos L=0.5U W=5.55U AS=1.887P AD=1.887P PS=11.78U PD=11.78U rfmode=0
XM_30 n25 n153 AVDD AVDD sg13_lv_pmos L=2U W=5.75U AS=1.955P AD=1.0925P PS=12.18U PD=6.13U rfmode=0
XM_31 AVDD n153 n25 AVDD sg13_lv_pmos L=2U W=5.75U AS=1.0925P AD=1.0925P PS=6.13U PD=6.13U rfmode=0
XM_32 n25 n153 AVDD AVDD sg13_lv_pmos L=2U W=5.75U AS=1.0925P AD=1.0925P PS=6.13U PD=6.13U rfmode=0
XM_33 AVDD n153 n25 AVDD sg13_lv_pmos L=2U W=5.75U AS=1.0925P AD=1.955P PS=6.13U PD=12.18U rfmode=0
XM_34 n33 V_CM n142 AVDD sg13_lv_pmos L=2U W=6.64U AS=2.2576P AD=1.2616P PS=13.96U PD=7.02U rfmode=0
XM_35 n142 V_CM n33 AVDD sg13_lv_pmos L=2U W=6.64U AS=1.2616P AD=1.2616P PS=7.02U PD=7.02U rfmode=0
XM_36 n33 V_CM n142 AVDD sg13_lv_pmos L=2U W=6.64U AS=1.2616P AD=1.2616P PS=7.02U PD=7.02U rfmode=0
XM_37 n142 V_CM n33 AVDD sg13_lv_pmos L=2U W=6.64U AS=1.2616P AD=2.2576P PS=7.02U PD=13.96U rfmode=0
XM_38 AVDD n86 n44 AVDD sg13_lv_pmos L=2U W=7.33U AS=2.4922P AD=2.4922P PS=15.34U PD=15.34U rfmode=0
XM_39 AVDD n153 n153 AVDD sg13_lv_pmos L=2U W=2.3U AS=0.782P AD=0.782P PS=5.28U PD=5.28U rfmode=0
XM_40 AVDD n86 n86 AVDD sg13_lv_pmos L=2U W=7.33U AS=2.4922P AD=2.4922P PS=15.34U PD=15.34U rfmode=0
XM_41 AVDD n153 n44 AVDD sg13_lv_pmos L=2U W=9.21U AS=3.1314P AD=3.1314P PS=19.1U PD=19.1U rfmode=0
XM_42 V_OUT2 n44 AVDD AVDD sg13_lv_pmos L=0.5U W=5.55U AS=1.887P AD=1.0545P PS=11.78U PD=5.93U rfmode=0
XM_43 AVDD n44 V_OUT2 AVDD sg13_lv_pmos L=0.5U W=5.55U AS=1.0545P AD=1.0545P PS=5.93U PD=5.93U rfmode=0
XM_44 V_OUT2 n44 AVDD AVDD sg13_lv_pmos L=0.5U W=5.55U AS=1.0545P AD=1.0545P PS=5.93U PD=5.93U rfmode=0
XM_45 AVDD n44 V_OUT2 AVDD sg13_lv_pmos L=0.5U W=5.55U AS=1.0545P AD=1.887P PS=5.93U PD=11.78U rfmode=0
XM_46 n24 n153 AVDD AVDD sg13_lv_pmos L=2U W=5.75U AS=1.955P AD=1.0925P PS=12.18U PD=6.13U rfmode=0
XM_47 AVDD n153 n24 AVDD sg13_lv_pmos L=2U W=5.75U AS=1.0925P AD=1.955P PS=6.13U PD=12.18U rfmode=0
XM_48 n26 n213 n142 AVDD sg13_lv_pmos L=2U W=6.64U AS=2.2576P AD=1.2616P PS=13.96U PD=7.02U rfmode=0
XM_49 n142 n213 n26 AVDD sg13_lv_pmos L=2U W=6.64U AS=1.2616P AD=1.2616P PS=7.02U PD=7.02U rfmode=0
XM_50 n26 n213 n142 AVDD sg13_lv_pmos L=2U W=6.64U AS=1.2616P AD=1.2616P PS=7.02U PD=7.02U rfmode=0
XM_51 n142 n213 n26 AVDD sg13_lv_pmos L=2U W=6.64U AS=1.2616P AD=2.2576P PS=7.02U PD=13.96U rfmode=0
XM_52 n44 n100 n69 AVDD sg13_lv_pmos L=0.5U W=2.2U AS=0.748P AD=0.748P PS=5.08U PD=5.08U rfmode=0
XM_53 AVDD n215 n215 AVDD sg13_lv_pmos L=2U W=7.46U AS=2.5364P AD=2.5364P PS=15.6U PD=15.6U rfmode=0
XM_54 AVDD n215 n215 AVDD sg13_lv_pmos L=2U W=7.46U AS=2.5364P AD=2.5364P PS=15.6U PD=15.6U rfmode=0
XM_55 AVDD n215 n215 AVDD sg13_lv_pmos L=2U W=7.46U AS=2.5364P AD=2.5364P PS=15.6U PD=15.6U rfmode=0
XM_56 AVDD n153 n196 AVDD sg13_lv_pmos L=2U W=4.6U AS=1.564P AD=1.564P PS=9.88U PD=9.88U rfmode=0
XM_57 AVDD n215 n215 AVDD sg13_lv_pmos L=2U W=7.46U AS=2.5364P AD=2.5364P PS=15.6U PD=15.6U rfmode=0
XM_58 AVDD n215 n215 AVDD sg13_lv_pmos L=2U W=7.46U AS=2.5364P AD=2.5364P PS=15.6U PD=15.6U rfmode=0
XM_59 AVDD n215 n215 AVDD sg13_lv_pmos L=2U W=7.46U AS=2.5364P AD=2.5364P PS=15.6U PD=15.6U rfmode=0
XM_60 AVDD n215 n215 AVDD sg13_lv_pmos L=2U W=7.46U AS=2.5364P AD=2.5364P PS=15.6U PD=15.6U rfmode=0
XM_61 AVDD n215 n215 AVDD sg13_lv_pmos L=2U W=7.46U AS=2.5364P AD=2.5364P PS=15.6U PD=15.6U rfmode=0
XM_62 AVDD n215 n142 AVDD sg13_lv_pmos L=2U W=7.46U AS=2.5364P AD=2.5364P PS=15.6U PD=15.6U rfmode=0
XM_63 AVDD n215 n142 AVDD sg13_lv_pmos L=2U W=7.46U AS=2.5364P AD=2.5364P PS=15.6U PD=15.6U rfmode=0
XM_64 AVDD n215 n142 AVDD sg13_lv_pmos L=2U W=7.46U AS=2.5364P AD=2.5364P PS=15.6U PD=15.6U rfmode=0
XM_65 AVDD n215 n142 AVDD sg13_lv_pmos L=2U W=7.46U AS=2.5364P AD=2.5364P PS=15.6U PD=15.6U rfmode=0
XM_66 AVDD n215 n142 AVDD sg13_lv_pmos L=2U W=7.46U AS=2.5364P AD=2.5364P PS=15.6U PD=15.6U rfmode=0
XM_67 AVDD n215 n142 AVDD sg13_lv_pmos L=2U W=7.46U AS=2.5364P AD=2.5364P PS=15.6U PD=15.6U rfmode=0
XM_68 AVDD n215 n142 AVDD sg13_lv_pmos L=2U W=7.46U AS=2.5364P AD=2.5364P PS=15.6U PD=15.6U rfmode=0
XM_69 AVDD n215 n142 AVDD sg13_lv_pmos L=2U W=7.46U AS=2.5364P AD=2.5364P PS=15.6U PD=15.6U rfmode=0
XM_70 n254 n220 n213 AVDD sg13_lv_pmos L=0.13U W=1.2U AS=0.408P AD=0.408P PS=3.08U PD=3.08U rfmode=0
XM_71 n220 S0 AVDD AVDD sg13_lv_pmos L=0.13U W=1.12U AS=0.3808P AD=0.3808P PS=2.92U PD=2.92U rfmode=0
XM_72 n248 n222 n213 AVDD sg13_lv_pmos L=0.13U W=0.9U AS=0.306P AD=0.306P PS=2.48U PD=2.48U rfmode=0
XM_73 n222 S1 AVDD AVDD sg13_lv_pmos L=0.13U W=1.12U AS=0.3808P AD=0.3808P PS=2.92U PD=2.92U rfmode=0
XM_74 n249 n224 n213 AVDD sg13_lv_pmos L=0.13U W=0.6U AS=0.204P AD=0.204P PS=1.88U PD=1.88U rfmode=0
XM_75 n224 S2 AVDD AVDD sg13_lv_pmos L=0.13U W=1.12U AS=0.3808P AD=0.3808P PS=2.92U PD=2.92U rfmode=0
XM_76 n250 n226 n213 AVDD sg13_lv_pmos L=0.13U W=0.54U AS=0.1836P AD=0.1836P PS=1.76U PD=1.76U rfmode=0
XM_77 n226 S3 AVDD AVDD sg13_lv_pmos L=0.13U W=1.12U AS=0.3808P AD=0.3808P PS=2.92U PD=2.92U rfmode=0
XM_78 n251 n228 n213 AVDD sg13_lv_pmos L=0.13U W=0.54U AS=0.1836P AD=0.1836P PS=1.76U PD=1.76U rfmode=0
XM_79 n228 S4 AVDD AVDD sg13_lv_pmos L=0.13U W=1.12U AS=0.3808P AD=0.3808P PS=2.92U PD=2.92U rfmode=0
XM_80 n252 n230 n213 AVDD sg13_lv_pmos L=0.13U W=0.54U AS=0.1836P AD=0.1836P PS=1.76U PD=1.76U rfmode=0
XM_81 n230 S5 AVDD AVDD sg13_lv_pmos L=0.13U W=1.12U AS=0.3808P AD=0.3808P PS=2.92U PD=2.92U rfmode=0
XD_82 AVSS S5 dantenna w=0.78u l=0.78u
XR_83 n2 n44 AVSS rhigh w=0.5u l=4.0u ps=0 b=0 m=1
XR_84 n10 AVSS AVSS rhigh w=0.5u l=15.0u ps=0 b=0 m=1
XR_85 V_OUT2 n254 AVSS rhigh w=0.5u l=3.2u ps=0 b=0 m=1
XR_86 n250 n251 AVSS rhigh w=0.5u l=54.0u ps=0 b=0 m=1
XR_87 V_IN2 n213 AVSS rhigh w=0.5u l=6.66u ps=0 b=0 m=1
XR_88 n249 n250 AVSS rhigh w=0.5u l=26.95u ps=0 b=0 m=1
XR_89 n248 n249 AVSS rhigh w=0.5u l=13.42u ps=0 b=0 m=1
XR_90 n254 n248 AVSS rhigh w=0.5u l=6.66u ps=0 b=0 m=1
XR_91 n269 n251 AVSS rhigh w=0.5u l=54.0u ps=0 b=0 m=1
XR_92 n269 n252 AVSS rhigh w=0.5u l=54.0u ps=0 b=0 m=1
XC_93 n33 V_OUT2 cap_cmomi w=25e-6 l=25e-6 mmin=1 mmax=4 feed=double subblock=0 m=1
XC_94 n2 V_OUT2 cap_cmomi w=25e-6 l=25e-6 mmin=1 mmax=4 feed=double subblock=0 m=1
XC_95 n2 V_OUT2 cap_cmomi w=25e-6 l=25e-6 mmin=1 mmax=4 feed=double subblock=0 m=1
XC_96 n2 V_OUT2 cap_cmomi w=25e-6 l=25e-6 mmin=1 mmax=4 feed=double subblock=0 m=1
XC_97 n2 V_OUT2 cap_cmomi w=25e-6 l=25e-6 mmin=1 mmax=4 feed=double subblock=0 m=1
Cext_1 n10 n24 716.628a
Cext_2 n10 n25 31.7384a
Cext_3 n10 n26 3.38527a
Cext_4 n10 AVSS 961.281a
Cext_5 n10 I_BIAS 0.100778a
Cext_6 n10 VSS 1.8725f
Cext_7 n100 n142 127.263a
Cext_8 n100 n145 156.124a
Cext_9 n100 n153 291.801a
Cext_10 n100 n196 432.592a
Cext_11 n100 n213 3.26468a
Cext_12 n100 n215 28.239a
Cext_13 n100 n24 18.9182a
Cext_14 n100 n25 188.755a
Cext_15 n100 n26 223.85a
Cext_16 n100 n33 20.8982a
Cext_17 n100 n44 570.314a
Cext_18 n100 n69 287.041a
Cext_19 n100 n86 20.1552a
Cext_20 n100 n93 7.01634a
Cext_21 n100 AVDD 2.35207f
Cext_22 n100 AVSS 273.99a
Cext_23 n100 I_BIAS 120.683a
Cext_24 n100 V_CM 164.463a
Cext_25 n100 V_OUT2 139.68a
Cext_26 n100 VSS 5.02711f
Cext_27 n142 n153 0.246446a
Cext_28 n142 n196 171.558a
Cext_29 n142 n213 2.01927f
Cext_30 n142 n215 3.39654f
Cext_31 n142 n26 652.757a
Cext_32 n142 n33 389.607a
Cext_33 n142 n44 121.569a
Cext_34 n142 n69 3.29571a
Cext_35 n142 n86 26.2082a
Cext_36 n142 AVDD 5.68631f
Cext_37 n142 S3 0.513461a
Cext_38 n142 S4 6.98777a
Cext_39 n142 V_CM 1.60328f
Cext_40 n142 V_OUT2 291.004a
Cext_41 n142 VSS 4.00742f
Cext_42 n145 n153 34.6845a
Cext_43 n145 n215 16.0229a
Cext_44 n145 n24 13.4889a
Cext_45 n145 n25 5.39096a
Cext_46 n145 n44 7.15795a
Cext_47 n145 AVDD 860.018a
Cext_48 n145 I_BIAS 0.232728a
Cext_49 n145 V_CM 18.5073a
Cext_50 n145 VSS 1.59798f
Cext_51 n153 n196 599.226a
Cext_52 n153 n213 228.061a
Cext_53 n153 n215 1.99351f
Cext_54 n153 n24 1.45187f
Cext_55 n153 n25 1.90445f
Cext_56 n153 n26 6.12484a
Cext_57 n153 n44 647.093a
Cext_58 n153 AVDD 5.05127f
Cext_59 n153 AVSS 347.422a
Cext_60 n153 I_BIAS 388.584a
Cext_61 n153 V_CM 644.509a
Cext_62 n153 V_IN2 2.24668a
Cext_63 n153 VSS 19.5457f
Cext_64 n196 n213 325.257a
Cext_65 n196 n215 30.7402a
Cext_66 n196 n24 66.3079a
Cext_67 n196 n25 36.1299a
Cext_68 n196 n26 871.945a
Cext_69 n196 n33 929.372a
Cext_70 n196 n44 180.048a
Cext_71 n196 n69 522.541a
Cext_72 n196 n86 86.661a
Cext_73 n196 n93 105.49a
Cext_74 n196 AVDD 3.24579f
Cext_75 n196 AVSS 910.079a
Cext_76 n196 V_CM 412.088a
Cext_77 n196 V_OUT2 75.4863a
Cext_78 n196 VSS 3.19723f
Cext_79 n2 n24 90.9399a
Cext_80 n2 n26 3.22092a
Cext_81 n2 n33 2.11721a
Cext_82 n2 n44 161.589a
Cext_83 n2 n86 1.50158a
Cext_84 n2 AVSS 1.04249f
Cext_85 n2 V_OUT2 805.36a
Cext_86 n2 VSS 3.0166f
Cext_87 n213 n215 547.732a
Cext_88 n213 n220 86.3882a
Cext_89 n213 n222 54.3667a
Cext_90 n213 n224 47.0633a
Cext_91 n213 n226 70.9785a
Cext_92 n213 n228 77.1806a
Cext_93 n213 n230 16.0868a
Cext_94 n213 n24 20.7164a
Cext_95 n213 n248 311.514a
Cext_96 n213 n249 290.662a
Cext_97 n213 n250 293.715a
Cext_98 n213 n251 255.194a
Cext_99 n213 n252 148.274a
Cext_100 n213 n254 901.315a
Cext_101 n213 n26 2.41397f
Cext_102 n213 n44 70.7607a
Cext_103 n213 AVDD 1.78801f
Cext_104 n213 AVSS 871.042a
Cext_105 n213 S0 244.047a
Cext_106 n213 S1 228.674a
Cext_107 n213 S2 453.183a
Cext_108 n213 S3 615.138a
Cext_109 n213 S4 237.844a
Cext_110 n213 S5 446.846a
Cext_111 n213 V_CM 8.99176a
Cext_112 n213 V_IN2 16.6244a
Cext_113 n213 V_OUT2 17.2982a
Cext_114 n213 VSS 18.016f
Cext_115 n215 n220 1.93763a
Cext_116 n215 n222 1.55087a
Cext_117 n215 n224 0.878709a
Cext_118 n215 n226 0.675214a
Cext_119 n215 n228 0.614975a
Cext_120 n215 n24 331.072a
Cext_121 n215 n25 24.2479a
Cext_122 n215 n26 3.11757a
Cext_123 n215 n33 5.7459a
Cext_124 n215 n44 45.2346a
Cext_125 n215 n69 0.375416a
Cext_126 n215 AVDD 16.4394f
Cext_127 n215 AVSS 972.366a
Cext_128 n215 I_BIAS 702.849a
Cext_129 n215 S1 53.1992a
Cext_130 n215 S2 16.5748a
Cext_131 n215 S3 14.3787a
Cext_132 n215 S4 222.83a
Cext_133 n215 V_CM 111.984a
Cext_134 n215 V_IN2 0.292923a
Cext_135 n215 V_OUT2 2.90086a
Cext_136 n215 VSS 42.2543f
Cext_137 n220 n248 2.59005a
Cext_138 n220 n254 23.2567a
Cext_139 n220 AVDD 216.479a
Cext_140 n220 AVSS 85.3167a
Cext_141 n220 S0 82.8758a
Cext_142 n220 S1 88.8867a
Cext_143 n220 S2 6.33317a
Cext_144 n220 S3 1.52629a
Cext_145 n220 S4 1.09981a
Cext_146 n220 S5 0.881791a
Cext_147 n220 VSS 871.924a
Cext_148 n222 n248 12.5716a
Cext_149 n222 n254 1.97174a
Cext_150 n222 AVDD 260.353a
Cext_151 n222 AVSS 81.9869a
Cext_152 n222 S1 82.9931a
Cext_153 n222 S2 13.2536a
Cext_154 n222 S3 1.46697a
Cext_155 n222 S4 1.07025a
Cext_156 n222 S5 0.86383a
Cext_157 n222 VSS 879.633a
Cext_158 n224 n249 10.9248a
Cext_159 n224 n254 2.03175a
Cext_160 n224 AVDD 203.483a
Cext_161 n224 AVSS 86.5386a
Cext_162 n224 S2 90.778a
Cext_163 n224 S3 32.8969a
Cext_164 n224 S4 18.7055a
Cext_165 n224 S5 0.909123a
Cext_166 n224 VSS 922.032a
Cext_167 n226 n250 11.1041a
Cext_168 n226 n254 1.97994a
Cext_169 n226 AVDD 234.188a
Cext_170 n226 AVSS 88.8779a
Cext_171 n226 S3 87.3957a
Cext_172 n226 S4 81.7447a
Cext_173 n226 S5 3.1237a
Cext_174 n226 VSS 844.91a
Cext_175 n228 n251 30.0348a
Cext_176 n228 n254 1.66542a
Cext_177 n228 AVDD 239.075a
Cext_178 n228 AVSS 92.4463a
Cext_179 n228 S4 81.9707a
Cext_180 n228 S5 44.6356a
Cext_181 n228 VSS 823.906a
Cext_182 n230 n251 8.57318a
Cext_183 n230 n252 18.7116a
Cext_184 n230 n254 1.97994a
Cext_185 n230 AVDD 238.397a
Cext_186 n230 AVSS 88.8779a
Cext_187 n230 S5 81.6449a
Cext_188 n230 VSS 887.714a
Cext_189 n24 n25 206.568a
Cext_190 n24 n26 613.552a
Cext_191 n24 n33 412.218a
Cext_192 n24 n44 842.841a
Cext_193 n24 n69 4.36491a
Cext_194 n24 n86 487.033a
Cext_195 n24 AVDD 988.314a
Cext_196 n24 AVSS 1.74012f
Cext_197 n24 I_BIAS 188.635a
Cext_198 n24 V_CM 143.779a
Cext_199 n24 V_OUT2 33.4006a
Cext_200 n24 VSS 11.1789f
Cext_201 n248 n254 44.0818a
Cext_202 n248 AVDD 1.4332a
Cext_203 n248 AVSS 1.40548a
Cext_204 n248 S1 17.8768a
Cext_205 n248 S2 19.8978a
Cext_206 n248 S3 4.42405a
Cext_207 n248 S4 3.22422a
Cext_208 n248 S5 2.42328a
Cext_209 n248 VSS 754.226a
Cext_210 n249 n254 34.1024a
Cext_211 n249 AVDD 1.41307a
Cext_212 n249 AVSS 1.00716a
Cext_213 n249 S2 32.6275a
Cext_214 n249 S3 19.6221a
Cext_215 n249 S4 3.48637a
Cext_216 n249 S5 2.07367a
Cext_217 n249 VSS 717.103a
Cext_218 n25 n26 1.12174f
Cext_219 n25 n33 1.11539f
Cext_220 n25 n44 4.15771a
Cext_221 n25 n69 116.618a
Cext_222 n25 n86 1.35607a
Cext_223 n25 n93 15.7279a
Cext_224 n25 AVDD 385.934a
Cext_225 n25 AVSS 3.14794f
Cext_226 n25 I_BIAS 374.902a
Cext_227 n25 V_CM 51.9279a
Cext_228 n25 V_OUT2 20.7743a
Cext_229 n25 VSS 11.1144f
Cext_230 n250 n251 0.333949a
Cext_231 n250 n254 495.371a
Cext_232 n250 n269 14.5472a
Cext_233 n250 AVDD 1.28109a
Cext_234 n250 AVSS 0.837701a
Cext_235 n250 S3 55.5189a
Cext_236 n250 S4 17.5786a
Cext_237 n250 S5 267.521a
Cext_238 n250 VSS 2.86459f
Cext_239 n251 n252 410.321a
Cext_240 n251 n254 798.12a
Cext_241 n251 AVDD 4.99803a
Cext_242 n251 S4 8.02116a
Cext_243 n251 S5 134.096a
Cext_244 n251 VSS 3.45683f
Cext_245 n252 n254 2.15095f
Cext_246 n252 AVDD 7.40299a
Cext_247 n252 S5 103.753a
Cext_248 n252 VSS 2.00544f
Cext_249 n254 n269 1.75293a
Cext_250 n254 AVDD 61.2287a
Cext_251 n254 AVSS 21.8192a
Cext_252 n254 S0 19.2387a
Cext_253 n254 S1 2.85537a
Cext_254 n254 S2 771.971a
Cext_255 n254 S3 238.957a
Cext_256 n254 S4 106.093a
Cext_257 n254 S5 1.65829f
Cext_258 n254 V_OUT2 3.45582a
Cext_259 n254 VSS 6.75421f
Cext_260 n26 n33 279.997a
Cext_261 n26 n44 205.061a
Cext_262 n26 n69 181.04a
Cext_263 n26 n86 76.1316a
Cext_264 n26 n93 0.531942a
Cext_265 n26 AVDD 276.26a
Cext_266 n26 AVSS 1.63266f
Cext_267 n26 I_BIAS 0.249088a
Cext_268 n26 V_CM 481.14a
Cext_269 n26 V_OUT2 4.38815a
Cext_270 n26 VSS 3.5021f
Cext_271 n269 S3 0.193256a
Cext_272 n269 S5 38.009a
Cext_273 n269 VSS 386.985a
Cext_274 n33 n44 457.03a
Cext_275 n33 n69 394.564a
Cext_276 n33 n86 257.825a
Cext_277 n33 AVDD 259.835a
Cext_278 n33 AVSS 1.304f
Cext_279 n33 V_CM 2.07166f
Cext_280 n33 V_OUT2 1.39271f
Cext_281 n33 VSS 3.59417f
Cext_282 n44 n69 1.14014f
Cext_283 n44 n86 795.339a
Cext_284 n44 AVDD 2.59647f
Cext_285 n44 AVSS 681.318a
Cext_286 n44 V_CM 309.991a
Cext_287 n44 V_OUT2 1.52886f
Cext_288 n44 VSS 8.9021f
Cext_289 n69 n86 396.181a
Cext_290 n69 n93 78.379a
Cext_291 n69 AVDD 491.762a
Cext_292 n69 AVSS 1.22414f
Cext_293 n69 I_BIAS 177.671a
Cext_294 n69 V_CM 36.3815a
Cext_295 n69 V_OUT2 937.516a
Cext_296 n69 VSS 3.6815f
Cext_297 n86 AVDD 1.86545f
Cext_298 n86 AVSS 370.674a
Cext_299 n86 V_CM 11.1852a
Cext_300 n86 V_OUT2 226.71a
Cext_301 n86 VSS 6.63988f
Cext_302 n93 AVSS 486.445a
Cext_303 n93 I_BIAS 15.8842a
Cext_304 n93 VSS 666.921a
Cext_305 AVDD AVSS 1.06664f
Cext_306 AVDD I_BIAS 3.55288a
Cext_307 AVDD S0 97.8477a
Cext_308 AVDD S1 388.083a
Cext_309 AVDD S2 95.2532a
Cext_310 AVDD S3 93.1834a
Cext_311 AVDD S4 687.661a
Cext_312 AVDD S5 93.4982a
Cext_313 AVDD V_CM 651.897a
Cext_314 AVDD V_OUT2 1.22741f
Cext_315 AVDD VSS 40.4833f
Cext_316 AVSS I_BIAS 2.77241f
Cext_317 AVSS S0 451.307a
Cext_318 AVSS S1 663.382a
Cext_319 AVSS S2 475.399a
Cext_320 AVSS S3 336.978a
Cext_321 AVSS S4 775.847a
Cext_322 AVSS S5 329.172a
Cext_323 AVSS V_CM 1.04573a
Cext_324 AVSS V_OUT2 1.01542f
Cext_325 AVSS VSS 37.9377f
Cext_326 I_BIAS VSS 7.89253f
Cext_327 S0 S1 402.407a
Cext_328 S0 S2 2.7886a
Cext_329 S0 S3 0.328222a
Cext_330 S0 S4 0.159857a
Cext_331 S0 S5 0.127055a
Cext_332 S0 VSS 1.14614f
Cext_333 S1 S2 2.16823a
Cext_334 S1 S3 0.111263a
Cext_335 S1 VSS 1.55221f
Cext_336 S2 S3 2.69198f
Cext_337 S2 S4 5.47575a
Cext_338 S2 S5 1.22024a
Cext_339 S2 VSS 2.08321f
Cext_340 S3 S4 4.27911f
Cext_341 S3 S5 4.77813a
Cext_342 S3 VSS 2.81495f
Cext_343 S4 S5 3.39387f
Cext_344 S4 VSS 3.20682f
Cext_345 S5 VSS 5.97027f
Cext_346 V_CM V_IN2 19.8228a
Cext_347 V_CM V_OUT2 164.907a
Cext_348 VSS V_CM 8.88998f
Cext_349 VSS V_IN2 764.099a
Cext_350 VSS V_OUT2 14.4199f
.ends gain_network
