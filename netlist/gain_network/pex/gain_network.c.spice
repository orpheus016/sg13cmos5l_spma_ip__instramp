** post-layout netlist of gain_network: kpex -> ngspice by scripts/pex_netlist.py (source: /foss/designs/sg13cmos5l_spma_ip__instramp/runs/pex/gain_network/kpex/gain_network__gain_network/gain_network_k25d_pex_netlist.spice)
.subckt gain_network S4 S5 S0 S2 S1 S3 AVDD V_CM V_IN2 V_OUT2 I_BIAS AVSS
XM_1 n248 S4 n213 AVSS sg13_lv_nmos L=0.13U W=1.5U AS=0.51P AD=0.51P PS=3.68U PD=3.68U rfmode=0
XM_2 n249 S5 n213 AVSS sg13_lv_nmos L=0.13U W=0.9U AS=0.306P AD=0.306P PS=2.48U PD=2.48U rfmode=0
XM_3 n252 S2 n213 AVSS sg13_lv_nmos L=0.13U W=2.6U AS=0.884P AD=0.884P PS=5.88U PD=5.88U rfmode=0
XM_4 n251 S1 n213 AVSS sg13_lv_nmos L=0.13U W=2.9U AS=0.986P AD=0.986P PS=6.48U PD=6.48U rfmode=0
XM_5 n250 S0 n213 AVSS sg13_lv_nmos L=0.13U W=3U AS=1.02P AD=1.02P PS=6.68U PD=6.68U rfmode=0
XM_6 n231 S5 AVSS AVSS sg13_lv_nmos L=0.13U W=0.74U AS=0.2516P AD=0.2516P PS=2.16U PD=2.16U rfmode=0
XM_7 n229 S4 AVSS AVSS sg13_lv_nmos L=0.13U W=0.74U AS=0.2516P AD=0.2516P PS=2.16U PD=2.16U rfmode=0
XM_8 n223 S1 AVSS AVSS sg13_lv_nmos L=0.13U W=0.74U AS=0.2516P AD=0.2516P PS=2.16U PD=2.16U rfmode=0
XM_9 n44 n197 n69 AVSS sg13_lv_nmos L=0.5U W=0.84U AS=0.2856P AD=0.2856P PS=2.36U PD=2.36U rfmode=0
XM_10 AVSS I_BIAS I_BIAS AVSS sg13_lv_nmos L=2U W=0.87U AS=0.2958P AD=0.2958P PS=2.42U PD=2.42U rfmode=0
XM_11 n225 S2 AVSS AVSS sg13_lv_nmos L=0.13U W=0.74U AS=0.2516P AD=0.2516P PS=2.16U PD=2.16U rfmode=0
XM_12 n86 n24 n26 AVSS sg13_lv_nmos L=2U W=6.41U AS=2.1794P AD=2.1794P PS=13.5U PD=13.5U rfmode=0
XM_13 n33 n25 AVSS AVSS sg13_lv_nmos L=2U W=9.21U AS=3.1314P AD=3.1314P PS=19.1U PD=19.1U rfmode=0
XM_14 n222 S0 AVSS AVSS sg13_lv_nmos L=0.13U W=0.74U AS=0.2516P AD=0.2516P PS=2.16U PD=2.16U rfmode=0
XM_15 n216 I_BIAS AVSS AVSS sg13_lv_nmos L=2U W=6U AS=2.04P AD=2.04P PS=12.68U PD=12.68U rfmode=0
XM_16 n33 n24 n44 AVSS sg13_lv_nmos L=2U W=6.41U AS=2.1794P AD=2.1794P PS=13.5U PD=13.5U rfmode=0
XM_17 n247 S3 n213 AVSS sg13_lv_nmos L=0.13U W=2.2U AS=0.748P AD=0.748P PS=5.08U PD=5.08U rfmode=0
XM_18 n25 n25 AVSS AVSS sg13_lv_nmos L=2U W=9.21U AS=3.1314P AD=3.1314P PS=19.1U PD=19.1U rfmode=0
XM_19 n155 I_BIAS AVSS AVSS sg13_lv_nmos L=2U W=0.87U AS=0.2958P AD=0.2958P PS=2.42U PD=2.42U rfmode=0
XM_20 n197 n197 n93 AVSS sg13_lv_nmos L=0.5U W=0.84U AS=0.2856P AD=0.2856P PS=2.36U PD=2.36U rfmode=0
XM_21 AVSS n25 n26 AVSS sg13_lv_nmos L=2U W=9.21U AS=3.1314P AD=3.1314P PS=19.1U PD=19.1U rfmode=0
XM_22 n69 I_BIAS AVSS AVSS sg13_lv_nmos L=2U W=3.2U AS=1.088P AD=1.088P PS=7.08U PD=7.08U rfmode=0
XM_23 n24 n24 n10 AVSS sg13_lv_nmos L=2U W=1.6U AS=0.544P AD=0.544P PS=3.88U PD=3.88U rfmode=0
XM_24 V_OUT2 n69 AVSS AVSS sg13_lv_nmos L=0.5U W=8.4U AS=2.856P AD=2.856P PS=17.48U PD=17.48U rfmode=0
XM_25 n100 I_BIAS AVSS AVSS sg13_lv_nmos L=2U W=1.74U AS=0.5916P AD=0.5916P PS=4.16U PD=4.16U rfmode=0
XM_26 n227 S3 AVSS AVSS sg13_lv_nmos L=0.13U W=0.74U AS=0.2516P AD=0.2516P PS=2.16U PD=2.16U rfmode=0
XM_27 n93 n93 AVSS AVSS sg13_lv_nmos L=0.5U W=2.1U AS=0.714P AD=0.714P PS=4.88U PD=4.88U rfmode=0
XM_28 n145 n100 n100 AVDD sg13_lv_pmos L=0.5U W=2.2U AS=0.748P AD=0.748P PS=5.08U PD=5.08U rfmode=0
XM_29 AVDD n145 n145 AVDD sg13_lv_pmos L=0.5U W=5.55U AS=1.887P AD=1.887P PS=11.78U PD=11.78U rfmode=0
XM_30 n25 n155 AVDD AVDD sg13_lv_pmos L=2U W=5.75U AS=1.955P AD=1.0925P PS=12.18U PD=6.13U rfmode=0
XM_31 AVDD n155 n25 AVDD sg13_lv_pmos L=2U W=5.75U AS=1.0925P AD=1.0925P PS=6.13U PD=6.13U rfmode=0
XM_32 n25 n155 AVDD AVDD sg13_lv_pmos L=2U W=5.75U AS=1.0925P AD=1.0925P PS=6.13U PD=6.13U rfmode=0
XM_33 AVDD n155 n25 AVDD sg13_lv_pmos L=2U W=5.75U AS=1.0925P AD=1.955P PS=6.13U PD=12.18U rfmode=0
XM_34 n33 V_CM n142 AVDD sg13_lv_pmos L=2U W=6.64U AS=2.2576P AD=1.2616P PS=13.96U PD=7.02U rfmode=0
XM_35 n142 V_CM n33 AVDD sg13_lv_pmos L=2U W=6.64U AS=1.2616P AD=1.2616P PS=7.02U PD=7.02U rfmode=0
XM_36 n33 V_CM n142 AVDD sg13_lv_pmos L=2U W=6.64U AS=1.2616P AD=1.2616P PS=7.02U PD=7.02U rfmode=0
XM_37 n142 V_CM n33 AVDD sg13_lv_pmos L=2U W=6.64U AS=1.2616P AD=2.2576P PS=7.02U PD=13.96U rfmode=0
XM_38 AVDD n86 n44 AVDD sg13_lv_pmos L=2U W=7.33U AS=2.4922P AD=2.4922P PS=15.34U PD=15.34U rfmode=0
XM_39 AVDD n155 n155 AVDD sg13_lv_pmos L=2U W=2.3U AS=0.782P AD=0.782P PS=5.28U PD=5.28U rfmode=0
XM_40 AVDD n86 n86 AVDD sg13_lv_pmos L=2U W=7.33U AS=2.4922P AD=2.4922P PS=15.34U PD=15.34U rfmode=0
XM_41 AVDD n155 n44 AVDD sg13_lv_pmos L=2U W=9.21U AS=3.1314P AD=3.1314P PS=19.1U PD=19.1U rfmode=0
XM_42 V_OUT2 n44 AVDD AVDD sg13_lv_pmos L=0.5U W=5.55U AS=1.887P AD=1.0545P PS=11.78U PD=5.93U rfmode=0
XM_43 AVDD n44 V_OUT2 AVDD sg13_lv_pmos L=0.5U W=5.55U AS=1.0545P AD=1.0545P PS=5.93U PD=5.93U rfmode=0
XM_44 V_OUT2 n44 AVDD AVDD sg13_lv_pmos L=0.5U W=5.55U AS=1.0545P AD=1.0545P PS=5.93U PD=5.93U rfmode=0
XM_45 AVDD n44 V_OUT2 AVDD sg13_lv_pmos L=0.5U W=5.55U AS=1.0545P AD=1.887P PS=5.93U PD=11.78U rfmode=0
XM_46 n24 n155 AVDD AVDD sg13_lv_pmos L=2U W=5.75U AS=1.955P AD=1.0925P PS=12.18U PD=6.13U rfmode=0
XM_47 AVDD n155 n24 AVDD sg13_lv_pmos L=2U W=5.75U AS=1.0925P AD=1.955P PS=6.13U PD=12.18U rfmode=0
XM_48 n26 n213 n142 AVDD sg13_lv_pmos L=2U W=6.64U AS=2.2576P AD=1.2616P PS=13.96U PD=7.02U rfmode=0
XM_49 n142 n213 n26 AVDD sg13_lv_pmos L=2U W=6.64U AS=1.2616P AD=1.2616P PS=7.02U PD=7.02U rfmode=0
XM_50 n26 n213 n142 AVDD sg13_lv_pmos L=2U W=6.64U AS=1.2616P AD=1.2616P PS=7.02U PD=7.02U rfmode=0
XM_51 n142 n213 n26 AVDD sg13_lv_pmos L=2U W=6.64U AS=1.2616P AD=2.2576P PS=7.02U PD=13.96U rfmode=0
XM_52 n44 n100 n69 AVDD sg13_lv_pmos L=0.5U W=2.2U AS=0.748P AD=0.748P PS=5.08U PD=5.08U rfmode=0
XM_53 AVDD n216 n216 AVDD sg13_lv_pmos L=2U W=7.46U AS=2.5364P AD=2.5364P PS=15.6U PD=15.6U rfmode=0
XM_54 AVDD n216 n216 AVDD sg13_lv_pmos L=2U W=7.46U AS=2.5364P AD=2.5364P PS=15.6U PD=15.6U rfmode=0
XM_55 AVDD n216 n216 AVDD sg13_lv_pmos L=2U W=7.46U AS=2.5364P AD=2.5364P PS=15.6U PD=15.6U rfmode=0
XM_56 AVDD n155 n197 AVDD sg13_lv_pmos L=2U W=4.6U AS=1.564P AD=1.564P PS=9.88U PD=9.88U rfmode=0
XM_57 AVDD n216 n216 AVDD sg13_lv_pmos L=2U W=7.46U AS=2.5364P AD=2.5364P PS=15.6U PD=15.6U rfmode=0
XM_58 AVDD n216 n216 AVDD sg13_lv_pmos L=2U W=7.46U AS=2.5364P AD=2.5364P PS=15.6U PD=15.6U rfmode=0
XM_59 AVDD n216 n216 AVDD sg13_lv_pmos L=2U W=7.46U AS=2.5364P AD=2.5364P PS=15.6U PD=15.6U rfmode=0
XM_60 AVDD n216 n216 AVDD sg13_lv_pmos L=2U W=7.46U AS=2.5364P AD=2.5364P PS=15.6U PD=15.6U rfmode=0
XM_61 AVDD n216 n216 AVDD sg13_lv_pmos L=2U W=7.46U AS=2.5364P AD=2.5364P PS=15.6U PD=15.6U rfmode=0
XM_62 AVDD n216 n142 AVDD sg13_lv_pmos L=2U W=7.46U AS=2.5364P AD=2.5364P PS=15.6U PD=15.6U rfmode=0
XM_63 AVDD n216 n142 AVDD sg13_lv_pmos L=2U W=7.46U AS=2.5364P AD=2.5364P PS=15.6U PD=15.6U rfmode=0
XM_64 AVDD n216 n142 AVDD sg13_lv_pmos L=2U W=7.46U AS=2.5364P AD=2.5364P PS=15.6U PD=15.6U rfmode=0
XM_65 AVDD n216 n142 AVDD sg13_lv_pmos L=2U W=7.46U AS=2.5364P AD=2.5364P PS=15.6U PD=15.6U rfmode=0
XM_66 AVDD n216 n142 AVDD sg13_lv_pmos L=2U W=7.46U AS=2.5364P AD=2.5364P PS=15.6U PD=15.6U rfmode=0
XM_67 AVDD n216 n142 AVDD sg13_lv_pmos L=2U W=7.46U AS=2.5364P AD=2.5364P PS=15.6U PD=15.6U rfmode=0
XM_68 AVDD n216 n142 AVDD sg13_lv_pmos L=2U W=7.46U AS=2.5364P AD=2.5364P PS=15.6U PD=15.6U rfmode=0
XM_69 AVDD n216 n142 AVDD sg13_lv_pmos L=2U W=7.46U AS=2.5364P AD=2.5364P PS=15.6U PD=15.6U rfmode=0
XM_70 n250 n222 n213 AVDD sg13_lv_pmos L=0.13U W=9U AS=3.06P AD=3.06P PS=18.68U PD=18.68U rfmode=0
XM_71 n222 S0 AVDD AVDD sg13_lv_pmos L=0.13U W=1.12U AS=0.3808P AD=0.3808P PS=2.92U PD=2.92U rfmode=0
XM_72 n251 n223 n213 AVDD sg13_lv_pmos L=0.13U W=8.7U AS=2.958P AD=2.958P PS=18.08U PD=18.08U rfmode=0
XM_73 n223 S1 AVDD AVDD sg13_lv_pmos L=0.13U W=1.12U AS=0.3808P AD=0.3808P PS=2.92U PD=2.92U rfmode=0
XM_74 n252 n225 n213 AVDD sg13_lv_pmos L=0.13U W=7.8U AS=2.652P AD=2.652P PS=16.28U PD=16.28U rfmode=0
XM_75 n225 S2 AVDD AVDD sg13_lv_pmos L=0.13U W=1.12U AS=0.3808P AD=0.3808P PS=2.92U PD=2.92U rfmode=0
XM_76 n247 n227 n213 AVDD sg13_lv_pmos L=0.13U W=6.6U AS=2.244P AD=2.244P PS=13.88U PD=13.88U rfmode=0
XM_77 n227 S3 AVDD AVDD sg13_lv_pmos L=0.13U W=1.12U AS=0.3808P AD=0.3808P PS=2.92U PD=2.92U rfmode=0
XM_78 n248 n229 n213 AVDD sg13_lv_pmos L=0.13U W=4.5U AS=1.53P AD=1.53P PS=9.68U PD=9.68U rfmode=0
XM_79 n229 S4 AVDD AVDD sg13_lv_pmos L=0.13U W=1.12U AS=0.3808P AD=0.3808P PS=2.92U PD=2.92U rfmode=0
XM_80 n249 n231 n213 AVDD sg13_lv_pmos L=0.13U W=2.7U AS=0.918P AD=0.918P PS=6.08U PD=6.08U rfmode=0
XM_81 n231 S5 AVDD AVDD sg13_lv_pmos L=0.13U W=1.12U AS=0.3808P AD=0.3808P PS=2.92U PD=2.92U rfmode=0
XR_82 V_OUT2 n250 AVSS rppd w=2.0u l=7.0u ps=0 b=0 m=1
XR_83 n250 n251 AVSS rppd w=2.0u l=15.16u ps=0 b=0 m=1
XR_84 V_IN2 n213 AVSS rppd w=2.0u l=15.16u ps=0 b=0 m=1
XR_85 n3 n44 AVSS rhigh w=0.5u l=4.0u ps=0 b=0 m=1
XR_86 n10 AVSS AVSS rhigh w=0.5u l=15.0u ps=0 b=0 m=1
XR_87 n248 n249 AVSS rhigh w=0.5u l=10.72u ps=0 b=0 m=1
XR_88 n247 n248 AVSS rhigh w=0.5u l=5.3u ps=0 b=0 m=1
XR_89 n252 n247 AVSS rhigh w=0.5u l=2.6u ps=0 b=0 m=1
XR_90 n251 n252 AVSS rhigh w=0.5u l=1.25u ps=0 b=0 m=1
XC_91 n33 V_OUT2 cap_cmomi w=25e-6 l=25e-6 mmin=1 mmax=4 feed=double subblock=0 m=1
XC_92 n3 V_OUT2 cap_cmomi w=25e-6 l=25e-6 mmin=1 mmax=4 feed=double subblock=0 m=1
XC_93 n3 V_OUT2 cap_cmomi w=25e-6 l=25e-6 mmin=1 mmax=4 feed=double subblock=0 m=1
XC_94 n3 V_OUT2 cap_cmomi w=25e-6 l=25e-6 mmin=1 mmax=4 feed=double subblock=0 m=1
XC_95 n3 V_OUT2 cap_cmomi w=25e-6 l=25e-6 mmin=1 mmax=4 feed=double subblock=0 m=1
Cext_1 n10 n24 812.181a
Cext_2 n10 n25 31.7877a
Cext_3 n10 n26 5.79502a
Cext_4 n10 AVSS 1.68485f
Cext_5 n10 I_BIAS 0.100778a
Cext_6 n10 VSS 1.8725f
Cext_7 n100 n142 155.886a
Cext_8 n100 n145 227.739a
Cext_9 n100 n155 418.711a
Cext_10 n100 n197 562.78a
Cext_11 n100 n213 3.26468a
Cext_12 n100 n216 36.8047a
Cext_13 n100 n24 18.9182a
Cext_14 n100 n25 216.219a
Cext_15 n100 n26 357.936a
Cext_16 n100 n33 20.8982a
Cext_17 n100 n44 800.875a
Cext_18 n100 n69 444.804a
Cext_19 n100 n86 23.3345a
Cext_20 n100 n93 14.0327a
Cext_21 n100 AVDD 3.71311f
Cext_22 n100 AVSS 455.592a
Cext_23 n100 I_BIAS 124.899a
Cext_24 n100 V_CM 190.076a
Cext_25 n100 V_OUT2 143.117a
Cext_26 n100 VSS 5.02711f
Cext_27 n142 n155 0.246446a
Cext_28 n142 n197 200.46a
Cext_29 n142 n213 2.05516f
Cext_30 n142 n216 3.39867f
Cext_31 n142 n26 1.05544f
Cext_32 n142 n33 654.921a
Cext_33 n142 n44 130.623a
Cext_34 n142 n69 3.29571a
Cext_35 n142 n86 33.7326a
Cext_36 n142 AVDD 10.7864f
Cext_37 n142 S2 0.618409a
Cext_38 n142 S3 0.823475a
Cext_39 n142 V_CM 1.60645f
Cext_40 n142 V_OUT2 336.455a
Cext_41 n142 VSS 4.00742f
Cext_42 n145 n155 51.6529a
Cext_43 n145 n216 31.2921a
Cext_44 n145 n24 13.4889a
Cext_45 n145 n25 5.39096a
Cext_46 n145 n44 9.0485a
Cext_47 n145 AVDD 1.35015f
Cext_48 n145 I_BIAS 0.465457a
Cext_49 n145 V_CM 18.5073a
Cext_50 n145 VSS 1.59798f
Cext_51 n155 n197 762.632a
Cext_52 n155 n213 233.387a
Cext_53 n155 n216 3.45693f
Cext_54 n155 n24 1.61256f
Cext_55 n155 n25 1.9788f
Cext_56 n155 n26 11.8704a
Cext_57 n155 n44 648.744a
Cext_58 n155 AVDD 6.11034f
Cext_59 n155 AVSS 391.849a
Cext_60 n155 I_BIAS 520.236a
Cext_61 n155 V_CM 722.178a
Cext_62 n155 V_IN2 3.93098a
Cext_63 n155 VSS 19.5204f
Cext_64 n197 n213 343.156a
Cext_65 n197 n216 30.7402a
Cext_66 n197 n24 94.2986a
Cext_67 n197 n25 50.8765a
Cext_68 n197 n26 1.54637f
Cext_69 n197 n33 1.59695f
Cext_70 n197 n44 198.401a
Cext_71 n197 n69 772.599a
Cext_72 n197 n86 148.303a
Cext_73 n197 n93 173.291a
Cext_74 n197 AVDD 5.90708f
Cext_75 n197 AVSS 1.06934f
Cext_76 n197 V_CM 412.088a
Cext_77 n197 V_OUT2 76.0296a
Cext_78 n197 VSS 3.19723f
Cext_79 n213 n216 579.681a
Cext_80 n213 n222 214.211a
Cext_81 n213 n223 192.831a
Cext_82 n213 n225 180.27a
Cext_83 n213 n227 165.422a
Cext_84 n213 n229 140.914a
Cext_85 n213 n231 71.6616a
Cext_86 n213 n24 20.7164a
Cext_87 n213 n247 1.41024f
Cext_88 n213 n248 1.12706f
Cext_89 n213 n249 662.133a
Cext_90 n213 n250 2.5103f
Cext_91 n213 n251 1.55277f
Cext_92 n213 n252 1.7486f
Cext_93 n213 n26 2.42337f
Cext_94 n213 n44 78.4255a
Cext_95 n213 AVDD 5.08141f
Cext_96 n213 AVSS 2.41967f
Cext_97 n213 S0 465.243a
Cext_98 n213 S1 460.179a
Cext_99 n213 S2 628.587a
Cext_100 n213 S3 583.536a
Cext_101 n213 S4 603.271a
Cext_102 n213 S5 468.133a
Cext_103 n213 V_CM 15.8251a
Cext_104 n213 V_OUT2 17.2982a
Cext_105 n213 VSS 20.4201f
Cext_106 n216 n222 1.86555a
Cext_107 n216 n223 3.84743a
Cext_108 n216 n225 8.37422a
Cext_109 n216 n227 7.26982a
Cext_110 n216 n24 541.6a
Cext_111 n216 n25 46.218a
Cext_112 n216 n26 3.11757a
Cext_113 n216 n33 5.7459a
Cext_114 n216 n44 47.8674a
Cext_115 n216 n69 0.375416a
Cext_116 n216 AVDD 24.0298f
Cext_117 n216 AVSS 1.66806f
Cext_118 n216 I_BIAS 774.39a
Cext_119 n216 S0 29.5444a
Cext_120 n216 S1 176.708a
Cext_121 n216 S2 23.8332a
Cext_122 n216 S3 33.3875a
Cext_123 n216 S4 4.34307a
Cext_124 n216 V_CM 114.707a
Cext_125 n216 V_OUT2 2.90086a
Cext_126 n216 VSS 42.2389f
Cext_127 n222 n250 107.767a
Cext_128 n222 n251 3.10092a
Cext_129 n222 AVDD 313.405a
Cext_130 n222 AVSS 260.745a
Cext_131 n222 S0 109.436a
Cext_132 n222 S1 149.259a
Cext_133 n222 S2 6.21742a
Cext_134 n222 S3 2.10076a
Cext_135 n222 S4 1.73348a
Cext_136 n222 VSS 1.83843f
Cext_137 n223 n250 2.6067a
Cext_138 n223 n251 91.3926a
Cext_139 n223 n252 13.4376a
Cext_140 n223 AVDD 356.5a
Cext_141 n223 AVSS 280.872a
Cext_142 n223 S1 124.746a
Cext_143 n223 S2 70.3373a
Cext_144 n223 S3 1.6691a
Cext_145 n223 S4 0.756054a
Cext_146 n223 VSS 1.84035f
Cext_147 n225 n247 13.5755a
Cext_148 n225 n250 2.34254a
Cext_149 n225 n252 85.0393a
Cext_150 n225 AVDD 368.426a
Cext_151 n225 AVSS 192.943a
Cext_152 n225 S2 113.242a
Cext_153 n225 S3 90.2485a
Cext_154 n225 S4 0.756555a
Cext_155 n225 VSS 1.48492f
Cext_156 n227 n247 74.4457a
Cext_157 n227 n248 8.95043a
Cext_158 n227 n250 1.92887a
Cext_159 n227 AVDD 332.799a
Cext_160 n227 AVSS 225.052a
Cext_161 n227 S3 113.033a
Cext_162 n227 S4 94.6338a
Cext_163 n227 VSS 1.41705f
Cext_164 n229 n248 55.0091a
Cext_165 n229 n250 1.58174a
Cext_166 n229 AVDD 391.169a
Cext_167 n229 AVSS 173.302a
Cext_168 n229 S4 112.312a
Cext_169 n229 S5 80.1466a
Cext_170 n229 VSS 1.04877f
Cext_171 n231 n249 40.9662a
Cext_172 n231 n250 39.2741a
Cext_173 n231 AVDD 363.41a
Cext_174 n231 AVSS 142.432a
Cext_175 n231 S5 116.716a
Cext_176 n231 VSS 824.807a
Cext_177 n24 n25 247.076a
Cext_178 n24 n26 655.395a
Cext_179 n24 n3 130.954a
Cext_180 n24 n33 413.981a
Cext_181 n24 n44 1.05812f
Cext_182 n24 n69 6.18151a
Cext_183 n24 n86 489.522a
Cext_184 n24 AVDD 1.13301f
Cext_185 n24 AVSS 2.23752f
Cext_186 n24 I_BIAS 208.738a
Cext_187 n24 V_CM 144.544a
Cext_188 n24 V_OUT2 33.4006a
Cext_189 n24 VSS 11.1789f
Cext_190 n247 n248 27.615a
Cext_191 n247 n250 62.0311a
Cext_192 n247 n252 90.0926a
Cext_193 n247 AVDD 7.98311a
Cext_194 n247 AVSS 6.88776a
Cext_195 n247 S2 0.601012a
Cext_196 n247 S3 117.277a
Cext_197 n247 S4 17.7292a
Cext_198 n247 S5 6.19376a
Cext_199 n247 VSS 2.06251f
Cext_200 n248 n250 41.2558a
Cext_201 n248 AVDD 5.0807a
Cext_202 n248 AVSS 6.42237a
Cext_203 n248 S4 84.9678a
Cext_204 n248 S5 17.3711a
Cext_205 n248 VSS 1.57828f
Cext_206 n249 n250 19.5369a
Cext_207 n249 AVDD 3.48829a
Cext_208 n249 S5 204.749a
Cext_209 n249 VSS 734.187a
Cext_210 n25 n26 1.40233f
Cext_211 n25 n33 1.46282f
Cext_212 n25 n44 4.15771a
Cext_213 n25 n69 203.465a
Cext_214 n25 n86 1.35607a
Cext_215 n25 n93 16.2801a
Cext_216 n25 AVDD 616.912a
Cext_217 n25 AVSS 3.93954f
Cext_218 n25 I_BIAS 405.107a
Cext_219 n25 V_CM 51.9279a
Cext_220 n25 V_OUT2 33.2856a
Cext_221 n25 VSS 11.1144f
Cext_222 n250 n251 24.1502a
Cext_223 n250 n252 75.7772a
Cext_224 n250 AVDD 106.992a
Cext_225 n250 AVSS 32.0286a
Cext_226 n250 S0 39.7124a
Cext_227 n250 S1 6.68349a
Cext_228 n250 S2 939.406a
Cext_229 n250 S3 355.775a
Cext_230 n250 S4 217.053a
Cext_231 n250 S5 258.462a
Cext_232 n250 V_OUT2 11.2301a
Cext_233 n250 VSS 9.0343f
Cext_234 n251 n252 123.603a
Cext_235 n251 AVDD 6.44925a
Cext_236 n251 S1 36.7714a
Cext_237 n251 S2 19.2101a
Cext_238 n251 S3 3.39455a
Cext_239 n251 S4 2.58227a
Cext_240 n251 S5 1.25077a
Cext_241 n251 VSS 1.43268f
Cext_242 n252 AVDD 8.64428a
Cext_243 n252 AVSS 8.69347a
Cext_244 n252 S2 132.422a
Cext_245 n252 S3 27.1999a
Cext_246 n252 S4 10.8214a
Cext_247 n252 S5 7.69088a
Cext_248 n252 VSS 2.39914f
Cext_249 n26 n3 3.22092a
Cext_250 n26 n33 376.524a
Cext_251 n26 n44 274.646a
Cext_252 n26 n69 255.689a
Cext_253 n26 n86 149.21a
Cext_254 n26 n93 0.531942a
Cext_255 n26 AVDD 291.113a
Cext_256 n26 AVSS 2.5683f
Cext_257 n26 I_BIAS 0.249088a
Cext_258 n26 V_CM 599.036a
Cext_259 n26 V_OUT2 4.38815a
Cext_260 n26 VSS 3.5021f
Cext_261 n3 n33 2.11721a
Cext_262 n3 n44 178.185a
Cext_263 n3 n86 1.50158a
Cext_264 n3 AVSS 2.02896f
Cext_265 n3 V_OUT2 1.4658f
Cext_266 n3 VSS 3.0166f
Cext_267 n33 n44 505.372a
Cext_268 n33 n69 406.363a
Cext_269 n33 n86 273.639a
Cext_270 n33 AVDD 273.991a
Cext_271 n33 AVSS 1.91556f
Cext_272 n33 V_CM 2.07166f
Cext_273 n33 V_OUT2 2.63627f
Cext_274 n33 VSS 3.59417f
Cext_275 n44 n69 2.09761f
Cext_276 n44 n86 952.571a
Cext_277 n44 AVDD 3.45123f
Cext_278 n44 AVSS 990.359a
Cext_279 n44 V_CM 443.127a
Cext_280 n44 V_OUT2 1.73199f
Cext_281 n44 VSS 8.9021f
Cext_282 n69 n86 588.871a
Cext_283 n69 n93 126.971a
Cext_284 n69 AVDD 551.733a
Cext_285 n69 AVSS 1.45034f
Cext_286 n69 I_BIAS 177.671a
Cext_287 n69 V_CM 40.6608a
Cext_288 n69 V_OUT2 1.12353f
Cext_289 n69 VSS 3.6815f
Cext_290 n86 AVDD 2.4426f
Cext_291 n86 AVSS 572.956a
Cext_292 n86 V_CM 16.5067a
Cext_293 n86 V_OUT2 297.581a
Cext_294 n86 VSS 6.63988f
Cext_295 n93 AVSS 753.767a
Cext_296 n93 I_BIAS 24.4762a
Cext_297 n93 VSS 666.921a
Cext_298 AVDD AVSS 1.21104f
Cext_299 AVDD I_BIAS 3.55288a
Cext_300 AVDD S0 151.725a
Cext_301 AVDD S1 575.843a
Cext_302 AVDD S2 161.414a
Cext_303 AVDD S3 133.294a
Cext_304 AVDD S4 127.988a
Cext_305 AVDD S5 128.123a
Cext_306 AVDD V_CM 711.551a
Cext_307 AVDD V_OUT2 1.85725f
Cext_308 AVDD VSS 41.9198f
Cext_309 AVSS I_BIAS 3.9876f
Cext_310 AVSS S0 288.638a
Cext_311 AVSS S1 557.293a
Cext_312 AVSS S2 292.286a
Cext_313 AVSS S3 304.719a
Cext_314 AVSS S4 304.233a
Cext_315 AVSS S5 374.642a
Cext_316 AVSS V_CM 1.39777a
Cext_317 AVSS V_OUT2 1.47884f
Cext_318 AVSS VSS 38.4423f
Cext_319 I_BIAS VSS 7.89253f
Cext_320 S0 S1 1.1194f
Cext_321 S0 S2 2.9166a
Cext_322 S0 S3 0.819874a
Cext_323 S0 S4 0.674712a
Cext_324 S0 VSS 1.82961f
Cext_325 S1 S2 2.24873a
Cext_326 S1 S3 0.561641a
Cext_327 S1 S4 0.219451a
Cext_328 S1 VSS 2.57113f
Cext_329 S2 S3 7.89986f
Cext_330 S2 S4 2.79035a
Cext_331 S2 S5 1.11162a
Cext_332 S2 VSS 3.2371f
Cext_333 S3 S4 11.2845f
Cext_334 S3 S5 2.51178a
Cext_335 S3 VSS 2.61471f
Cext_336 S4 S5 13.5547f
Cext_337 S4 VSS 2.74905f
Cext_338 S5 VSS 5.99425f
Cext_339 V_CM V_IN2 308.007a
Cext_340 V_CM V_OUT2 164.907a
Cext_341 VSS V_CM 9.31829f
Cext_342 VSS V_IN2 829.591a
Cext_343 VSS V_OUT2 14.348f
.ends gain_network
