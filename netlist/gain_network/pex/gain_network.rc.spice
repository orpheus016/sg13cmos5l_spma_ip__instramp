** post-layout RC netlist of gain_network: Magic extresist -> ngspice by scripts/pex_netlist.py --magic (source: /foss/designs/sg13cmos5l_spma_ip__instramp/runs/pex/gain_network/magic/raw.spice)
.subckt gain_network S4 S5 S0 S2 S1 S3 AVDD V_CM V_IN2 V_OUT2 I_BIAS AVSS
X0 pn16_t0 S5_t0 AVSS_t17 AVSS_t16 sg13_lv_nmos ad=0.2516p pd=2.16u as=0.2516p ps=2.16u w=0.74u l=0.13u
X1 AVDD_t11 pn12_t3 pn7_t0 AVDD_t8 sg13_lv_pmos ad=1.955p pd=12.18u as=1.0925p ps=6.13u w=5.75u l=2u
X2 pn27_t4 pn28_t2 pn2_t1 AVSS_t35 sg13_lv_nmos ad=0.2856p pd=2.36u as=0.2856p ps=2.36u w=0.84u l=0.5u
X3 pn26_t0 pn7_t3 AVSS_t41 AVSS_t40 sg13_lv_nmos ad=3.1314p pd=19.1u as=3.1314p ps=19.1u w=9.21u l=2u
X4 pn15_t1 S4_t0 AVDD_t23 AVDD_t22 sg13_lv_pmos ad=0.3808p pd=2.92u as=0.3808p ps=2.92u w=1.12u l=0.13u
X5 pn27_t2 pn10_t2 pn2_t0 AVDD_t53 sg13_lv_pmos ad=0.748p pd=5.08u as=0.748p ps=5.08u w=2.2u l=0.5u
X6 pn26 V_CM_t0 pn24 AVDD_t21 sg13_lv_pmos ad=1.2616p pd=7.02u as=2.2576p ps=13.96u w=6.64u l=2u
X7 AVSS_t2 pn1_t0 AVSS_t1 rhigh l=15u w=0.5u ps=0 b=0 m=1
X8 pn24_t1 pn13_t12 pn29 AVDD_t21 sg13_lv_pmos ad=1.2616p pd=7.02u as=1.2616p ps=7.02u w=6.64u l=2u
X9 pn25_t0 pn10 pn10_t0 AVDD_t15 sg13_lv_pmos ad=0.748p pd=5.08u as=0.748p ps=5.08u w=2.2u l=0.5u
X10 pn23_t0 pn4_t1 AVSS_t54 rhigh l=54u w=0.5u ps=0 b=0 m=1
X11 pn12_t2 I_BIAS_t5 AVSS_t45 AVSS_t44 sg13_lv_nmos ad=0.2958p pd=2.42u as=0.2958p ps=2.42u w=0.87u l=2u
X12 pn27_t0 pn8 AVSS_t3 rhigh l=4u w=0.5u ps=0 b=0 m=1
X13 pn20_t0 pn21 AVSS_t4 rhigh l=13.42u w=0.5u ps=0 b=0 m=1
X14 AVDD_t31 pn30_t10 pn30_t11 AVDD_t30 sg13_lv_pmos ad=2.5364p pd=15.6u as=2.5364p ps=15.6u w=7.46u l=2u
X15 AVDD_t32 pn30_t0 pn30_t1 AVDD_t15 sg13_lv_pmos ad=2.5364p pd=15.6u as=2.5364p ps=15.6u w=7.46u l=2u
X16 pn29_t0 pn13_t12 pn24_t1 AVDD_t21 sg13_lv_pmos ad=1.2616p pd=7.02u as=1.2616p ps=7.02u w=6.64u l=2u
X17 AVDD_t49 pn30_t19 pn24_t10 AVDD_t47 sg13_lv_pmos ad=2.5364p pd=15.6u as=2.5364p ps=15.6u w=7.46u l=2u
X18 V_OUT2_t2 pn27_t5 AVDD_t57 AVDD_t56 sg13_lv_pmos ad=1.0545p pd=5.93u as=1.887p ps=11.78u w=5.55u l=0.5u
X19 V_OUT2_t3 pn27_t5 AVDD_t58 AVDD_t59 sg13_lv_pmos ad=1.0545p pd=5.93u as=1.0545p ps=5.93u w=5.55u l=0.5u
X20 pn7_t1 pn12_t3 AVDD_t18 AVDD_t8 sg13_lv_pmos ad=1.0925p pd=6.13u as=1.955p ps=12.18u w=5.75u l=2u
X21 AVDD_t52 pn30_t16 pn24_t7 AVDD_t47 sg13_lv_pmos ad=2.5364p pd=15.6u as=2.5364p ps=15.6u w=7.46u l=2u
X22 pn21_t0 pn22_t0 AVSS_t12 rhigh l=26.95u w=0.5u ps=0 b=0 m=1
X23 pn4_t0 pn16 pn13_t11 AVDD_t2 sg13_lv_pmos ad=0.1836p pd=1.76u as=0.1836p ps=1.76u w=0.54u l=0.13u
X24 pn15_t0 S4_t0 AVSS_t26 AVSS_t25 sg13_lv_nmos ad=0.2516p pd=2.16u as=0.2516p ps=2.16u w=0.74u l=0.13u
X25 pn20_t1 pn17 pn13_t8 AVDD_t24 sg13_lv_pmos ad=0.306p pd=2.48u as=0.306p ps=2.48u w=0.9u l=0.13u
X26 pn3 S4_t1 pn13_t6 AVSS_t24 sg13_lv_nmos ad=0.1026p pd=1.34u as=0.1026p ps=1.34u w=0.18u l=0.13u
X27 pn19_t1 S0_t0 AVDD_t1 AVDD_t0 sg13_lv_pmos ad=0.3808p pd=2.92u as=0.3808p ps=2.92u w=1.12u l=0.13u
X28 pn18_t0 S2_t0 AVDD_t5 AVDD_t4 sg13_lv_pmos ad=0.3808p pd=2.92u as=0.3808p ps=2.92u w=1.12u l=0.13u
X29 pn13 V_IN2_t0 AVSS_t0 rhigh l=6.66u w=0.5u ps=0 b=0 m=1
X30 AVDD_t64 pn11_t1 pn11_t2 AVDD_t62 sg13_lv_pmos ad=2.4922p pd=15.34u as=2.4922p ps=15.34u w=7.33u l=2u
X31 pn14_t1 S3_t0 AVDD_t20 AVDD_t19 sg13_lv_pmos ad=0.3808p pd=2.92u as=0.3808p ps=2.92u w=1.12u l=0.13u
X32 AVDD_t48 pn30_t20 pn24_t8 AVDD_t47 sg13_lv_pmos ad=2.5364p pd=15.6u as=2.5364p ps=15.6u w=7.46u l=2u
X33 pn5 S0_t1 pn13_t1 AVSS_t8 sg13_lv_nmos ad=0.136p pd=1.48u as=0.136p ps=1.48u w=0.4u l=0.13u
X34 pn5_t1 V_OUT2_t0 AVSS_t6 rhigh l=3.2u w=0.5u ps=0 b=0 m=1
X35 pn11_t0 pn6_t3 pn29_t1 AVSS_t28 sg13_lv_nmos ad=2.1794p pd=13.5u as=2.1794p ps=13.5u w=6.41u l=2u
X36 AVDD_t16 pn12_t0 pn12_t1 AVDD_t15 sg13_lv_pmos ad=0.782p pd=5.28u as=0.782p ps=5.28u w=2.3u l=2u
X37 pn21_t1 S2_t1 pn13_t2 AVSS_t18 sg13_lv_nmos ad=0.104p pd=1.34u as=0.104p ps=1.34u w=0.2u l=0.13u
X38 pn17_t0 S1_t0 AVDD_t25 AVDD_t24 sg13_lv_pmos ad=0.3808p pd=2.92u as=0.3808p ps=2.92u w=1.12u l=0.13u
X39 AVDD_t55 pn25_t1 pn25_t2 AVDD_t54 sg13_lv_pmos ad=1.887p pd=11.78u as=1.887p ps=11.78u w=5.55u l=0.5u
X40 pn6_t1 pn6 pn1 AVSS_t27 sg13_lv_nmos ad=0.544p pd=3.88u as=0.544p ps=3.88u w=1.6u l=2u
X41 AVDD_t34 pn30_t23 pn24_t6 AVDD_t33 sg13_lv_pmos ad=2.5364p pd=15.6u as=2.5364p ps=15.6u w=7.46u l=2u
X42 pn24_t12 V_CM_t0 pn26 AVDD_t21 sg13_lv_pmos ad=1.2616p pd=7.02u as=1.2616p ps=7.02u w=6.64u l=2u
X43 AVSS_t39 pn7_t4 pn29_t2 AVSS_t38 sg13_lv_nmos ad=3.1314p pd=19.1u as=3.1314p ps=19.1u w=9.21u l=2u
X44 pn23 pn3_t0 AVSS_t7 rhigh l=54u w=0.5u ps=0 b=0 m=1
X45 pn19_t0 S0_t0 AVSS_t10 AVSS_t9 sg13_lv_nmos ad=0.2516p pd=2.16u as=0.2516p ps=2.16u w=0.74u l=0.13u
X46 pn18_t1 S2_t0 AVSS_t20 AVSS_t19 sg13_lv_nmos ad=0.2516p pd=2.16u as=0.2516p ps=2.16u w=0.74u l=0.13u
X47 pn14_t0 S3_t0 AVSS_t23 AVSS_t22 sg13_lv_nmos ad=0.2516p pd=2.16u as=0.2516p ps=2.16u w=0.74u l=0.13u
X48 AVDD_t9 pn12_t4 pn6_t0 AVDD_t8 sg13_lv_pmos ad=1.955p pd=12.18u as=1.0925p ps=6.13u w=5.75u l=2u
X49 pn24_t0 pn13_t12 pn29_t0 AVDD_t21 sg13_lv_pmos ad=2.2576p pd=13.96u as=1.2616p ps=7.02u w=6.64u l=2u
X50 AVDD_t14 pn12 pn27 AVDD_t13 sg13_lv_pmos ad=3.1314p pd=19.1u as=3.1314p ps=19.1u w=9.21u l=2u
X51 pn28_t1 pn28_t0 pn9_t0 AVSS_t34 sg13_lv_nmos ad=0.2856p pd=2.36u as=0.2856p ps=2.36u w=0.84u l=0.5u
X52 pn21_t2 pn18 pn13_t7 AVDD_t4 sg13_lv_pmos ad=0.204p pd=1.88u as=0.204p ps=1.88u w=0.6u l=0.13u
X53 AVDD_t36 pn30_t6 pn30_t7 AVDD_t35 sg13_lv_pmos ad=2.5364p pd=15.6u as=2.5364p ps=15.6u w=7.46u l=2u
X54 AVDD_t12 pn12_t3 pn7_t1 AVDD_t8 sg13_lv_pmos ad=1.0925p pd=6.13u as=1.0925p ps=6.13u w=5.75u l=2u
X55 pn17_t1 S1_t0 AVSS_t31 AVSS_t30 sg13_lv_nmos ad=0.2516p pd=2.16u as=0.2516p ps=2.16u w=0.74u l=0.13u
X56 AVDD_t38 pn30_t4 pn30_t5 AVDD_t37 sg13_lv_pmos ad=2.5364p pd=15.6u as=2.5364p ps=15.6u w=7.46u l=2u
X57 AVDD_t40 pn30_t12 pn30_t13 AVDD_t39 sg13_lv_pmos ad=2.5364p pd=15.6u as=2.5364p ps=15.6u w=7.46u l=2u
X58 AVDD_t50 pn30_t18 pn24_t9 AVDD_t47 sg13_lv_pmos ad=2.5364p pd=15.6u as=2.5364p ps=15.6u w=7.46u l=2u
X59 AVDD_t51 pn30_t17 pn24_t3 AVDD_t47 sg13_lv_pmos ad=2.5364p pd=15.6u as=2.5364p ps=15.6u w=7.46u l=2u
X60 pn10_t1 I_BIAS_t4 AVSS_t51 AVSS_t50 sg13_lv_nmos ad=0.5916p pd=4.16u as=0.5916p ps=4.16u w=1.74u l=2u
X61 pn7_t2 pn7 AVSS_t37 AVSS_t36 sg13_lv_nmos ad=3.1314p pd=19.1u as=3.1314p ps=19.1u w=9.21u l=2u
X62 pn20_t2 S1_t1 pn13_t9 AVSS_t29 sg13_lv_nmos ad=0.102p pd=1.28u as=0.102p ps=1.28u w=0.3u l=0.13u
X63 V_OUT2_t1 pn2_t2 AVSS_t43 AVSS_t42 sg13_lv_nmos ad=2.856p pd=17.48u as=2.856p ps=17.48u w=8.4u l=0.5u
X64 AVDD_t58 pn27_t5 V_OUT2_t2 AVDD_t33 sg13_lv_pmos ad=1.0545p pd=5.93u as=1.0545p ps=5.93u w=5.55u l=0.5u
X65 pn26_t1 V_CM_t0 pn24_t12 AVDD_t21 sg13_lv_pmos ad=1.2616p pd=7.02u as=1.2616p ps=7.02u w=6.64u l=2u
X66 pn9_t1 pn9 AVSS_t33 AVSS_t32 sg13_lv_nmos ad=0.714p pd=4.88u as=0.714p ps=4.88u w=2.1u l=0.5u
X67 pn3_t2 pn15 pn13_t10 AVDD_t22 sg13_lv_pmos ad=0.1836p pd=1.76u as=0.1836p ps=1.76u w=0.54u l=0.13u
X68 pn4 S5_t1 pn13_t0 AVSS_t15 sg13_lv_nmos ad=0.1026p pd=1.34u as=0.1026p ps=1.34u w=0.18u l=0.13u
X69 AVDD_t46 pn30_t22 pn24_t5 AVDD_t45 sg13_lv_pmos ad=2.5364p pd=15.6u as=2.5364p ps=15.6u w=7.46u l=2u
X70 pn22_t2 S3_t1 pn13_t5 AVSS_t21 sg13_lv_nmos ad=0.1026p pd=1.34u as=0.1026p ps=1.34u w=0.18u l=0.13u
X71 pn7_t0 pn12_t3 AVDD_t12 AVDD_t8 sg13_lv_pmos ad=1.0925p pd=6.13u as=1.0925p ps=6.13u w=5.75u l=2u
X72 pn22 pn3_t1 AVSS_t11 rhigh l=54u w=0.5u ps=0 b=0 m=1
X73 AVDD_t61 pn27_t5 V_OUT2_t3 AVDD_t60 sg13_lv_pmos ad=1.887p pd=11.78u as=1.0545p ps=5.93u w=5.55u l=0.5u
X74 AVDD_t7 pn12_t5 pn28 AVDD_t6 sg13_lv_pmos ad=1.564p pd=9.88u as=1.564p ps=9.88u w=4.6u l=2u
X75 AVSS_t49 I_BIAS_t0 I_BIAS_t1 AVSS_t48 sg13_lv_nmos ad=0.2958p pd=2.42u as=0.2958p ps=2.42u w=0.87u l=2u
X76 AVDD_t29 pn30_t14 pn30 AVDD_t28 sg13_lv_pmos ad=2.5364p pd=15.6u as=2.5364p ps=15.6u w=7.46u l=2u
X77 pn29 pn13_t12 pn24_t2 AVDD_t21 sg13_lv_pmos ad=1.2616p pd=7.02u as=2.2576p ps=13.96u w=6.64u l=2u
X78 AVSS_t13 S5_t2 dantenna l=0.78u w=0.78u
X79 pn26_t2 pn6_t2 pn27_t1 AVSS_t28 sg13_lv_nmos ad=2.1794p pd=13.5u as=2.1794p ps=13.5u w=6.41u l=2u
X80 pn16_t1 S5_t0 AVDD_t3 AVDD_t2 sg13_lv_pmos ad=0.3808p pd=2.92u as=0.3808p ps=2.92u w=1.12u l=0.13u
X81 AVDD_t42 pn30_t8 pn30_t9 AVDD_t41 sg13_lv_pmos ad=2.5364p pd=15.6u as=2.5364p ps=15.6u w=7.46u l=2u
X82 AVDD_t44 pn30_t2 pn30_t3 AVDD_t43 sg13_lv_pmos ad=2.5364p pd=15.6u as=2.5364p ps=15.6u w=7.46u l=2u
X83 AVDD_t27 pn30_t21 pn24_t4 AVDD_t26 sg13_lv_pmos ad=2.5364p pd=15.6u as=2.5364p ps=15.6u w=7.46u l=2u
X84 pn5_t2 pn19 pn13_t3 AVDD_t0 sg13_lv_pmos ad=0.408p pd=3.08u as=0.408p ps=3.08u w=1.2u l=0.13u
X85 pn6_t0 pn12_t4 AVDD_t10 AVDD_t8 sg13_lv_pmos ad=1.0925p pd=6.13u as=1.955p ps=12.18u w=5.75u l=2u
X86 AVDD_t63 pn11 pn27_t3 AVDD_t62 sg13_lv_pmos ad=2.4922p pd=15.34u as=2.4922p ps=15.34u w=7.33u l=2u
X87 pn5_t0 pn20 AVSS_t5 rhigh l=6.66u w=0.5u ps=0 b=0 m=1
X88 pn22_t1 pn14 pn13_t4 AVDD_t19 sg13_lv_pmos ad=0.1836p pd=1.76u as=0.1836p ps=1.76u w=0.54u l=0.13u
X89 pn24_t11 V_CM_t0 pn26_t1 AVDD_t21 sg13_lv_pmos ad=2.2576p pd=13.96u as=1.2616p ps=7.02u w=6.64u l=2u
X90 pn2 I_BIAS_t2 AVSS_t53 AVSS_t52 sg13_lv_nmos ad=1.088p pd=7.08u as=1.088p ps=7.08u w=3.2u l=2u
X91 pn30_t15 I_BIAS_t3 AVSS_t47 AVSS_t46 sg13_lv_nmos ad=2.04p pd=12.68u as=2.04p ps=12.68u w=6u l=2u
R0 pn1 pn1_t0 51.8954
R1 pn9_n0 pn9_t0 17.8873
R2 pn9 pn9_n0 15.3273
R3 pn9_n0 pn9_t1 2.94632
R4 I_BIAS_n0 I_BIAS_t3 25.7258
R5 I_BIAS I_BIAS_n4 20.5487
R6 I_BIAS_t5 I_BIAS_t4 16.8947
R7 I_BIAS_t0 I_BIAS_t5 16.8903
R8 I_BIAS_t0 I_BIAS_n2 15.0005
R9 I_BIAS_t3 I_BIAS_t2 14.0016
R10 I_BIAS_n4 I_BIAS_n3 9.07096
R11 I_BIAS_n1 I_BIAS_n0 9.0005
R12 I_BIAS_n2 I_BIAS_t1 8.81129
R13 I_BIAS_n3 I_BIAS_t0 7.49231
R14 I_BIAS_n3 I_BIAS_n1 0.108892
R15 I_BIAS_n4 I_BIAS_n0 0.0389734
R16 I_BIAS_n2 I_BIAS_n1 0.0152561
R17 pn11_n0 pn11_t0 23.0364
R18 pn11 pn11_n1 5.15561
R19 pn11_n1 pn11_t1 4.56061
R20 pn11_n0 pn11_t2 1.82304
R21 pn11_n1 pn11_n0 0.5912
R22 pn26_n1 pn26_n0 21.5278
R23 pn26_n0 pn26_t2 3.90438
R24 pn26_n1 pn26_t1 3.542
R25 pn26 pn26_n1 2.48315
R26 pn26_n0 pn26_t0 1.16537
R27 V_CM V_CM_n5 14.2079
R28 V_CM_n2 V_CM_t0 12.7904
R29 V_CM_n3 V_CM_n0 9.0912
R30 V_CM_n2 V_CM_n1 9.05697
R31 V_CM_n1 V_CM_n0 9.0137
R32 V_CM_n5 V_CM_n4 9.0005
R33 V_CM_n3 V_CM_n2 4.52153
R34 V_CM_n4 V_CM_n1 0.0775
R35 V_CM_n4 V_CM_n3 0.0388129
R36 V_CM_n5 V_CM_n0 0.00123333
R37 pn25_n1 pn25_n0 18.0731
R38 pn25_n0 pn25_t1 16.3392
R39 pn25_n0 pn25_t2 0.703105
R40 pn25 pn25_n1 0.00240162
R41 pn25_n1 pn25_t0 0.00159825
R42 pn7_n2 pn7_n0 22.354
R43 pn7_n2 pn7_n1 14.2797
R44 pn7_n0 pn7_t3 6.97267
R45 pn7_n0 pn7_t4 6.15134
R46 pn7 pn7_n3 5.64773
R47 pn7_n1 pn7_t0 3.6622
R48 pn7_n1 pn7_t1 3.54154
R49 pn7_n3 pn7_n2 2.93392
R50 pn7_n3 pn7_t2 0.193742
R51 pn2_n1 pn2_t0 37.3573
R52 pn2 pn2_n1 35.7213
R53 pn2_n0 pn2_t2 24.0005
R54 pn2_n0 pn2_t1 13.562
R55 pn2_n1 pn2_n0 4.80997
R56 pn10_n0 pn10_t2 95.3284
R57 pn10_n1 pn10_n0 20.1156
R58 pn10_n0 pn10_t1 16.1539
R59 pn10 pn10_n1 15.0005
R60 pn10_n1 pn10_t0 3.64157
R61 pn27 pn27_n4 44.5178
R62 pn27_n1 pn27_t4 27.6562
R63 pn27_n0 pn27_t0 24.3167
R64 pn27_n0 pn27_t1 23.4573
R65 pn27_n2 pn27_t3 21.8367
R66 pn27_n3 pn27_n2 20.8686
R67 pn27_n4 pn27_n3 19.9402
R68 pn27_n4 pn27_t5 11.401
R69 pn27_n3 pn27_t2 4.69053
R70 pn27_n2 pn27_n1 0.523367
R71 pn27_n1 pn27_n0 0.391367
R72 V_OUT2_n2 V_OUT2_n1 126.001
R73 V_OUT2_n2 V_OUT2_t0 39.3356
R74 V_OUT2_n1 V_OUT2_n0 21.3188
R75 V_OUT2_n0 V_OUT2_t3 2.71307
R76 V_OUT2_n1 V_OUT2_t1 2.66599
R77 V_OUT2_n0 V_OUT2_t2 2.3407
R78 V_OUT2 V_OUT2_n2 0.0753
R79 pn29_n0 pn29_t1 25.8127
R80 pn29_n1 pn29_n0 23.557
R81 pn29_n1 pn29_t0 2.66048
R82 pn29 pn29_n1 1.61005
R83 pn29_n0 pn29_t2 1.17713
R84 V_IN2 V_IN2_t0 18.8808
R85 pn6_n1 pn6_t0 47.2302
R86 pn6_n1 pn6_n0 37.4277
R87 pn6_n0 pn6_t2 6.78973
R88 pn6_n0 pn6_t3 6.47445
R89 pn6_n2 pn6_t1 4.23839
R90 pn6 pn6_n2 4.22391
R91 pn6_n2 pn6_n1 1.85858
R92 pn28 pn28_n1 65.8331
R93 pn28_n1 pn28_t2 63.1062
R94 pn28_n1 pn28_n0 23.8719
R95 pn28_n0 pn28_t0 15.2505
R96 pn28_n0 pn28_t1 8.50305
R97 pn12_n4 pn12_t2 25.9904
R98 pn12_n5 pn12_t5 15.4267
R99 pn12_n4 pn12_n3 12.9235
R100 pn12_n6 pn12_n5 9.44417
R101 pn12_n1 pn12_n0 9.07539
R102 pn12_n8 pn12_n1 9.05326
R103 pn12_n7 pn12_n6 9.0005
R104 pn12_t5 pn12_n2 7.16221
R105 pn12_n2 pn12_t3 5.80793
R106 pn12 pn12_n8 5.0034
R107 pn12 pn12_n0 4.99428
R108 pn12_n3 pn12_t1 3.79089
R109 pn12_n3 pn12_t0 2.48849
R110 pn12_n2 pn12_t4 2.46963
R111 pn12_n5 pn12_n4 0.648767
R112 pn12_n7 pn12_n0 0.108864
R113 pn12_n8 pn12_n7 0.0942444
R114 pn12_n6 pn12_n1 0.00343333
R115 pn24_n9 pn24_n8 15.89
R116 pn24_n10 pn24_n9 11.3042
R117 pn24_n10 pn24_t11 5.49471
R118 pn24 pn24_n10 5.49195
R119 pn24_n0 pn24_t0 5.4088
R120 pn24_n0 pn24_t2 5.40812
R121 pn24_n2 pn24_t7 4.12163
R122 pn24_n8 pn24_t6 2.26695
R123 pn24_n2 pn24_t3 2.13621
R124 pn24_n3 pn24_t9 2.13566
R125 pn24_n5 pn24_t8 2.13536
R126 pn24_n6 pn24_t4 2.13533
R127 pn24_n7 pn24_t5 2.13492
R128 pn24_n4 pn24_t10 2.13428
R129 pn24_n7 pn24_n6 1.98738
R130 pn24_n6 pn24_n5 1.98738
R131 pn24_n5 pn24_n4 1.98738
R132 pn24_n4 pn24_n3 1.98738
R133 pn24_n3 pn24_n2 1.98738
R134 pn24_n10 pn24_t12 1.72375
R135 pn24_n9 pn24_n1 1.64653
R136 pn24_n8 pn24_n7 1.38512
R137 pn24_n1 pn24_t1 1.17139
R138 pn24_n1 pn24_n0 0.400134
R139 pn30_n6 pn30_t15 48.9998
R140 pn30_n22 pn30_t14 4.95984
R141 pn30_t14 pn30_n21 4.95984
R142 pn30_n0 pn30_t3 4.12107
R143 pn30_n23 pn30_n5 3.81591
R144 pn30_n14 pn30_n13 3.36038
R145 pn30_n7 pn30_t16 3.20148
R146 pn30_n14 pn30_t2 2.42277
R147 pn30_n13 pn30_t23 2.42272
R148 pn30_n20 pn30_t10 2.41279
R149 pn30_n19 pn30_t0 2.41279
R150 pn30_n18 pn30_t6 2.41279
R151 pn30_n17 pn30_t4 2.41279
R152 pn30_n16 pn30_t12 2.41279
R153 pn30_n15 pn30_t8 2.41279
R154 pn30_n12 pn30_t22 2.41279
R155 pn30_n11 pn30_t21 2.41279
R156 pn30_n10 pn30_t20 2.41279
R157 pn30_n9 pn30_t19 2.41279
R158 pn30_n8 pn30_t18 2.41279
R159 pn30_n7 pn30_t17 2.41279
R160 pn30_n23 pn30_n22 2.37189
R161 pn30_n4 pn30_t1 2.13576
R162 pn30_n5 pn30_t11 2.13542
R163 pn30_n3 pn30_t7 2.13533
R164 pn30_n1 pn30_t13 2.13505
R165 pn30_n2 pn30_t5 2.1349
R166 pn30_n0 pn30_t9 2.13458
R167 pn30_n5 pn30_n4 1.98738
R168 pn30_n4 pn30_n3 1.98738
R169 pn30_n3 pn30_n2 1.98738
R170 pn30_n2 pn30_n1 1.98738
R171 pn30_n1 pn30_n0 1.98738
R172 pn30_n20 pn30_n19 0.790191
R173 pn30_n19 pn30_n18 0.790191
R174 pn30_n18 pn30_n17 0.790191
R175 pn30_n17 pn30_n16 0.790191
R176 pn30_n16 pn30_n15 0.790191
R177 pn30_n12 pn30_n11 0.790191
R178 pn30_n11 pn30_n10 0.790191
R179 pn30_n10 pn30_n9 0.790191
R180 pn30_n9 pn30_n8 0.790191
R181 pn30_n8 pn30_n7 0.790191
R182 pn30_n13 pn30_n12 0.778958
R183 pn30_n15 pn30_n14 0.777179
R184 pn30_n21 pn30_n20 0.65392
R185 pn30 pn30_n23 0.307615
R186 pn30_n22 pn30_n6 0.188087
R187 pn30_n21 pn30_n6 0.0942483
R188 pn16 pn16_n0 17.1716
R189 pn16_n0 pn16_t0 8.69261
R190 pn16_n0 pn16_t1 6.03031
R191 pn15 pn15_n0 17.1716
R192 pn15_n0 pn15_t0 8.69261
R193 pn15_n0 pn15_t1 6.03031
R194 S4 S4_n0 48.2714
R195 S4_n0 S4_t0 33.638
R196 S4_n0 S4_t1 15.9878
R197 pn14 pn14_n0 17.1716
R198 pn14_n0 pn14_t0 8.69261
R199 pn14_n0 pn14_t1 6.03031
R200 S3 S3_n0 45.6119
R201 S3_n0 S3_t0 34.6239
R202 S3_n0 S3_t1 15.0019
R203 pn18 pn18_n0 17.1579
R204 pn18_n0 pn18_t1 8.73326
R205 pn18_n0 pn18_t0 5.98966
R206 S2 S2_n0 41.1067
R207 S2_n0 S2_t0 34.7523
R208 S2_n0 S2_t1 15.0005
R209 pn17 pn17_n0 16.9681
R210 pn17_n0 pn17_t1 8.72848
R211 pn17_n0 pn17_t0 5.99445
R212 S1_n0 S1_t0 33.748
R213 S1 S1_n0 20.1394
R214 S1_n0 S1_t1 16.0111
R215 pn13_n13 pn13_n11 47.3
R216 pn13_n19 pn13_n18 46.2417
R217 pn13_n17 pn13_n16 46.1848
R218 pn13_n15 pn13_n14 46.1641
R219 pn13_n13 pn13_n12 46.1641
R220 pn13_n21 pn13_n20 18.8794
R221 pn13_n20 pn13_t1 17.9905
R222 pn13_n18 pn13_t9 17.853
R223 pn13_n16 pn13_t2 17.7564
R224 pn13_n14 pn13_t5 17.6189
R225 pn13_n12 pn13_t6 17.6189
R226 pn13_n11 pn13_t0 17.6189
R227 pn13_n16 pn13_t7 17.5436
R228 pn13_n22 pn13_n10 17.5169
R229 pn13_n14 pn13_t4 17.3993
R230 pn13_n12 pn13_t10 17.3993
R231 pn13_n11 pn13_t11 17.3993
R232 pn13 pn13_n22 15.0012
R233 pn13_n21 pn13_n19 10.9033
R234 pn13_n4 pn13_n3 9.05448
R235 pn13_n7 pn13_n6 9.0476
R236 pn13_n1 pn13_n0 9.0335
R237 pn13_n8 pn13_n0 9.03277
R238 pn13_n10 pn13_n9 9.0005
R239 pn13_n9 pn13_n2 9.0005
R240 pn13_n8 pn13_n7 9.0005
R241 pn13_n3 pn13_n1 9.0005
R242 pn13_n5 pn13_n2 9.0005
R243 pn13_n18 pn13_t8 8.91864
R244 pn13_n4 pn13_t12 7.4777
R245 pn13_n6 pn13_t12 7.4777
R246 pn13_n20 pn13_t3 6.3601
R247 pn13_n17 pn13_n15 4.25237
R248 pn13_n22 pn13_n21 3.02307
R249 pn13_n19 pn13_n17 2.10223
R250 pn13_n15 pn13_n13 1.19803
R251 pn13_n6 pn13_n5 0.0971047
R252 pn13_n5 pn13_n4 0.0916048
R253 pn13_n9 pn13_n1 0.0775
R254 pn13_n3 pn13_n2 0.0775
R255 pn13_n9 pn13_n8 0.0767667
R256 pn13_n7 pn13_n2 0.0767667
R257 pn13_n10 pn13_n0 0.00196667
R258 pn19 pn19_n0 17.0396
R259 pn19_n0 pn19_t0 8.70696
R260 pn19_n0 pn19_t1 6.01597
R261 S0_n0 S0_t1 25.106
R262 S0_n0 S0_t0 24.8013
R263 S0 S0_n0 9.64437
R264 S5 S5_n1 66.6072
R265 S5_n0 S5_t0 34.6253
R266 S5_n0 S5_t1 15.0005
R267 S5_n1 S5_t2 4.49609
R268 S5_n1 S5_n0 0.622
R269 pn21_n0 pn21_t2 18.4133
R270 pn21_n0 pn21_t1 17.0005
R271 pn21_n1 pn21_t0 15.1472
R272 pn21 pn21_n1 15.0647
R273 pn21_n1 pn21_n0 0.435
R274 pn20_n0 pn20_t2 17.0005
R275 pn20 pn20_n1 15.2123
R276 pn20_n1 pn20_t0 15.006
R277 pn20_n0 pn20_t1 9.87426
R278 pn20_n1 pn20_n0 0.435
R279 pn5_n0 pn5_t1 48.5
R280 pn5 pn5_n1 17.0005
R281 pn5_n0 pn5_t0 15.0005
R282 pn5_n1 pn5_t2 7.4876
R283 pn5_n1 pn5_n0 0.4295
R284 pn22 pn22_n1 19.0109
R285 pn22_n0 pn22_t1 17.8908
R286 pn22_n0 pn22_t2 17.1518
R287 pn22_n1 pn22_t0 15.2242
R288 pn22_n1 pn22_n0 0.452417
R289 pn3 pn3_n1 18.2277
R290 pn3_n1 pn3_t2 17.0005
R291 pn3_n0 pn3_t0 15.2572
R292 pn3_n0 pn3_t1 15.0005
R293 pn3_n1 pn3_n0 5.803
R294 pn4_n0 pn4_t1 37.7132
R295 pn4_n0 pn4_t0 17.7155
R296 pn4 pn4_n0 17.3271
R297 pn23 pn23_t0 30.2572
R298 AVDD_n367 AVDD_n366 28.6789
R299 AVDD_n369 AVDD_n363 28.052
R300 AVDD_n368 AVDD_n364 27.9973
R301 AVDD_n367 AVDD_n365 27.9973
R302 AVDD_n371 AVDD_n357 27.9416
R303 AVDD_n370 AVDD_n362 27.9229
R304 AVDD_n361 AVDD_n359 17.0555
R305 AVDD_n335 AVDD_n41 17.0005
R306 AVDD_n335 AVDD_n73 17.0005
R307 AVDD_n335 AVDD_n42 17.0005
R308 AVDD_n335 AVDD_n72 17.0005
R309 AVDD_n335 AVDD_t43 17.0005
R310 AVDD_n335 AVDD_n71 17.0005
R311 AVDD_n335 AVDD_n44 17.0005
R312 AVDD_n335 AVDD_n70 17.0005
R313 AVDD_n335 AVDD_t8 17.0005
R314 AVDD_n335 AVDD_n69 17.0005
R315 AVDD_n335 AVDD_n45 17.0005
R316 AVDD_n335 AVDD_n46 17.0005
R317 AVDD_n335 AVDD_n68 17.0005
R318 AVDD_n335 AVDD_n47 17.0005
R319 AVDD_n335 AVDD_n67 17.0005
R320 AVDD_n335 AVDD_n48 17.0005
R321 AVDD_n335 AVDD_n66 17.0005
R322 AVDD_n335 AVDD_n49 17.0005
R323 AVDD_n335 AVDD_t54 17.0005
R324 AVDD_n335 AVDD_n50 17.0005
R325 AVDD_n335 AVDD_n64 17.0005
R326 AVDD_n335 AVDD_n51 17.0005
R327 AVDD_n335 AVDD_n62 17.0005
R328 AVDD_n335 AVDD_t6 17.0005
R329 AVDD_n335 AVDD_t35 17.0005
R330 AVDD_n335 AVDD_n30 17.0005
R331 AVDD_n335 AVDD_t13 17.0005
R332 AVDD_n335 AVDD_n53 17.0005
R333 AVDD_n335 AVDD_n32 17.0005
R334 AVDD_n335 AVDD_n33 17.0005
R335 AVDD_n335 AVDD_n55 17.0005
R336 AVDD_n335 AVDD_n59 17.0005
R337 AVDD_n335 AVDD_n56 17.0005
R338 AVDD_n287 AVDD_t53 17.0005
R339 AVDD_n287 AVDD_n146 17.0005
R340 AVDD_n287 AVDD_n167 17.0005
R341 AVDD_n287 AVDD_n150 17.0005
R342 AVDD_n287 AVDD_n166 17.0005
R343 AVDD_n287 AVDD_n151 17.0005
R344 AVDD_n287 AVDD_n164 17.0005
R345 AVDD_n287 AVDD_n152 17.0005
R346 AVDD_n287 AVDD_n163 17.0005
R347 AVDD_n287 AVDD_t45 17.0005
R348 AVDD_n287 AVDD_t62 17.0005
R349 AVDD_n287 AVDD_n139 17.0005
R350 AVDD_n287 AVDD_t59 17.0005
R351 AVDD_n287 AVDD_n154 17.0005
R352 AVDD_n287 AVDD_n161 17.0005
R353 AVDD_n287 AVDD_t56 17.0005
R354 AVDD_n287 AVDD_n160 17.0005
R355 AVDD_n287 AVDD_n155 17.0005
R356 AVDD_n287 AVDD_n159 17.0005
R357 AVDD_n287 AVDD_n156 17.0005
R358 AVDD_n287 AVDD_n158 17.0005
R359 AVDD_n357 AVDD_n356 17.0005
R360 AVDD_n362 AVDD_n361 17.0005
R361 AVDD_n372 AVDD_n353 13.6796
R362 AVDD_n286 AVDD_n285 8.61936
R363 AVDD_n82 AVDD_n74 8.61464
R364 AVDD_t28 AVDD_n23 8.501
R365 AVDD_t28 AVDD_n22 8.501
R366 AVDD_t28 AVDD_n21 8.501
R367 AVDD_t28 AVDD_n20 8.501
R368 AVDD_t28 AVDD_n19 8.501
R369 AVDD_t28 AVDD_n18 8.501
R370 AVDD_t28 AVDD_n17 8.501
R371 AVDD_t28 AVDD_n16 8.501
R372 AVDD_t28 AVDD_n15 8.501
R373 AVDD_n259 AVDD_n182 8.501
R374 AVDD_n259 AVDD_n181 8.501
R375 AVDD_n259 AVDD_n180 8.501
R376 AVDD_n259 AVDD_n183 8.501
R377 AVDD_n259 AVDD_n184 8.501
R378 AVDD_n248 AVDD_n198 8.501
R379 AVDD_n246 AVDD_n245 8.501
R380 AVDD_n236 AVDD_n200 8.501
R381 AVDD_n239 AVDD_n238 8.501
R382 AVDD_t21 AVDD_n234 8.501
R383 AVDD_n226 AVDD_n204 8.501
R384 AVDD_n229 AVDD_n228 8.501
R385 AVDD_n224 AVDD_n223 8.501
R386 AVDD_n215 AVDD_n208 8.501
R387 AVDD_n218 AVDD_n217 8.501
R388 AVDD_n335 AVDD_n43 8.5005
R389 AVDD_n335 AVDD_t37 8.5005
R390 AVDD_n336 AVDD_n335 8.5005
R391 AVDD_n335 AVDD_n57 8.5005
R392 AVDD_n340 AVDD_n339 8.5005
R393 AVDD_n287 AVDD_n149 8.5005
R394 AVDD_n287 AVDD_t26 8.5005
R395 AVDD_n287 AVDD_t60 8.5005
R396 AVDD_n287 AVDD_t33 8.5005
R397 AVDD_n248 AVDD_n179 8.5005
R398 AVDD_n246 AVDD_n179 8.5005
R399 AVDD_n236 AVDD_n179 8.5005
R400 AVDD_n238 AVDD_n179 8.5005
R401 AVDD_t21 AVDD_n179 8.5005
R402 AVDD_n226 AVDD_n179 8.5005
R403 AVDD_n228 AVDD_n179 8.5005
R404 AVDD_n224 AVDD_n179 8.5005
R405 AVDD_n215 AVDD_n179 8.5005
R406 AVDD_n217 AVDD_n179 8.5005
R407 AVDD_n314 AVDD_n53 8.5005
R408 AVDD_n262 AVDD_n163 8.5005
R409 AVDD_n262 AVDD_t33 8.5005
R410 AVDD_t54 AVDD_n26 8.5005
R411 AVDD_n337 AVDD_n30 8.5005
R412 AVDD_n337 AVDD_n32 8.5005
R413 AVDD_n337 AVDD_n33 8.5005
R414 AVDD_n109 AVDD_n66 8.5005
R415 AVDD_n109 AVDD_n49 8.5005
R416 AVDD_n109 AVDD_n50 8.5005
R417 AVDD_n109 AVDD_n64 8.5005
R418 AVDD_n109 AVDD_n51 8.5005
R419 AVDD_n109 AVDD_n62 8.5005
R420 AVDD_n30 AVDD_n28 8.5005
R421 AVDD_t13 AVDD_n28 8.5005
R422 AVDD_n53 AVDD_n28 8.5005
R423 AVDD_n32 AVDD_n28 8.5005
R424 AVDD_n33 AVDD_n28 8.5005
R425 AVDD_n55 AVDD_n28 8.5005
R426 AVDD_n59 AVDD_n28 8.5005
R427 AVDD_n56 AVDD_n28 8.5005
R428 AVDD_n289 AVDD_t53 8.5005
R429 AVDD_n289 AVDD_n146 8.5005
R430 AVDD_n289 AVDD_t45 8.5005
R431 AVDD_n289 AVDD_t62 8.5005
R432 AVDD_n289 AVDD_n139 8.5005
R433 AVDD_n289 AVDD_t59 8.5005
R434 AVDD_n167 AVDD_n130 8.5005
R435 AVDD_n164 AVDD_n130 8.5005
R436 AVDD_n152 AVDD_n130 8.5005
R437 AVDD_n154 AVDD_n130 8.5005
R438 AVDD_n161 AVDD_n130 8.5005
R439 AVDD_t56 AVDD_n130 8.5005
R440 AVDD_n160 AVDD_n130 8.5005
R441 AVDD_n155 AVDD_n130 8.5005
R442 AVDD_n159 AVDD_n130 8.5005
R443 AVDD_n156 AVDD_n130 8.5005
R444 AVDD_n356 AVDD_n355 8.49851
R445 AVDD_n353 AVDD_n0 8.49791
R446 AVDD_n343 AVDD_n10 8.46995
R447 AVDD_n344 AVDD_n9 8.46995
R448 AVDD_n345 AVDD_n8 8.46995
R449 AVDD_n346 AVDD_n7 8.46995
R450 AVDD_n347 AVDD_n6 8.46995
R451 AVDD_n348 AVDD_n5 8.46995
R452 AVDD_n349 AVDD_n4 8.46995
R453 AVDD_n350 AVDD_n3 8.46995
R454 AVDD_n351 AVDD_n2 8.46995
R455 AVDD_n352 AVDD_n1 8.46995
R456 AVDD_n191 AVDD_n190 8.46995
R457 AVDD_n192 AVDD_n189 8.46995
R458 AVDD_n193 AVDD_n188 8.46995
R459 AVDD_n194 AVDD_n187 8.46995
R460 AVDD_n195 AVDD_n186 8.46995
R461 AVDD_n196 AVDD_n185 8.46995
R462 AVDD_n253 AVDD_n252 8.46995
R463 AVDD_n244 AVDD_n197 8.46995
R464 AVDD_n243 AVDD_n242 8.46995
R465 AVDD_n241 AVDD_n240 8.46995
R466 AVDD_n202 AVDD_n201 8.46995
R467 AVDD_n231 AVDD_n230 8.46995
R468 AVDD_n206 AVDD_n205 8.46995
R469 AVDD_n222 AVDD_n221 8.46995
R470 AVDD_n220 AVDD_n219 8.46995
R471 AVDD_n85 AVDD_n84 8.46995
R472 AVDD_n84 AVDD_n83 8.46995
R473 AVDD_n317 AVDD_n26 8.46995
R474 AVDD_n233 AVDD_n232 8.45904
R475 AVDD_n364 AVDD_t20 6.11392
R476 AVDD_n365 AVDD_t23 6.11392
R477 AVDD_n366 AVDD_t3 6.11392
R478 AVDD_n363 AVDD_t5 6.00228
R479 AVDD_n355 AVDD_t1 5.99877
R480 AVDD_n359 AVDD_t25 5.96578
R481 AVDD_t0 AVDD_n354 5.96294
R482 AVDD_n324 AVDD_t10 5.8568
R483 AVDD_t28 AVDD_n24 5.66778
R484 AVDD_t28 AVDD_n0 5.66778
R485 AVDD_n259 AVDD_n157 5.66778
R486 AVDD_n213 AVDD_n211 5.66778
R487 AVDD_t30 AVDD_n14 5.66767
R488 AVDD_n213 AVDD_n212 5.66767
R489 AVDD_n335 AVDD_t41 5.66717
R490 AVDD_n335 AVDD_t15 5.66717
R491 AVDD_n288 AVDD_n287 5.66717
R492 AVDD_n356 AVDD_t0 5.66717
R493 AVDD_n342 AVDD_n11 5.61281
R494 AVDD_n210 AVDD_n209 5.61281
R495 AVDD_n110 AVDD_n109 5.61281
R496 AVDD_n125 AVDD_t11 5.4441
R497 AVDD_n364 AVDD_t19 4.89166
R498 AVDD_n365 AVDD_t22 4.89166
R499 AVDD_n366 AVDD_t2 4.89166
R500 AVDD_n363 AVDD_t4 4.88395
R501 AVDD_n125 AVDD_n124 4.58809
R502 AVDD_n251 AVDD_n250 4.251
R503 AVDD_n314 AVDD_n311 4.251
R504 AVDD_n314 AVDD_n310 4.251
R505 AVDD_n314 AVDD_n308 4.251
R506 AVDD_n305 AVDD_n87 4.251
R507 AVDD_n305 AVDD_n88 4.251
R508 AVDD_n305 AVDD_n90 4.251
R509 AVDD_n305 AVDD_n91 4.251
R510 AVDD_n305 AVDD_n92 4.251
R511 AVDD_n305 AVDD_n93 4.251
R512 AVDD_n305 AVDD_n94 4.251
R513 AVDD_n262 AVDD_n172 4.251
R514 AVDD_n262 AVDD_n174 4.251
R515 AVDD_n262 AVDD_n175 4.251
R516 AVDD_n262 AVDD_n176 4.251
R517 AVDD_n262 AVDD_n177 4.251
R518 AVDD_n65 AVDD_n26 4.251
R519 AVDD_n63 AVDD_n26 4.251
R520 AVDD_n61 AVDD_n26 4.251
R521 AVDD_n52 AVDD_n26 4.251
R522 AVDD_n34 AVDD_n26 4.251
R523 AVDD_n54 AVDD_n26 4.251
R524 AVDD_n58 AVDD_n26 4.251
R525 AVDD_n276 AVDD_n274 4.251
R526 AVDD_n302 AVDD_n114 4.251
R527 AVDD_n302 AVDD_n116 4.251
R528 AVDD_n302 AVDD_n117 4.251
R529 AVDD_n302 AVDD_n118 4.251
R530 AVDD_n302 AVDD_n119 4.251
R531 AVDD_n302 AVDD_n121 4.251
R532 AVDD_n302 AVDD_n122 4.251
R533 AVDD_n337 AVDD_n31 4.251
R534 AVDD_n337 AVDD_n35 4.251
R535 AVDD_n249 AVDD_n128 4.251
R536 AVDD_n247 AVDD_n128 4.251
R537 AVDD_n199 AVDD_n128 4.251
R538 AVDD_n237 AVDD_n128 4.251
R539 AVDD_n235 AVDD_n128 4.251
R540 AVDD_n203 AVDD_n128 4.251
R541 AVDD_n227 AVDD_n128 4.251
R542 AVDD_n225 AVDD_n128 4.251
R543 AVDD_n207 AVDD_n128 4.251
R544 AVDD_n216 AVDD_n128 4.251
R545 AVDD_n214 AVDD_n128 4.251
R546 AVDD_n289 AVDD_n142 4.251
R547 AVDD_n289 AVDD_n141 4.251
R548 AVDD_n289 AVDD_n137 4.251
R549 AVDD_n289 AVDD_n136 4.251
R550 AVDD_n289 AVDD_n135 4.251
R551 AVDD_n289 AVDD_n134 4.251
R552 AVDD_n165 AVDD_n130 4.251
R553 AVDD_n162 AVDD_n130 4.251
R554 AVDD_n138 AVDD_n130 4.251
R555 AVDD_t37 AVDD_n26 4.2505
R556 AVDD_n276 AVDD_t26 4.2505
R557 AVDD_n337 AVDD_t15 4.2505
R558 AVDD_t15 AVDD_n28 4.2505
R559 AVDD_n57 AVDD_n28 4.2505
R560 AVDD_n289 AVDD_t60 4.2505
R561 AVDD_n150 AVDD_n130 4.2505
R562 AVDD_t33 AVDD_n130 4.2505
R563 AVDD_n337 AVDD_n38 4.18423
R564 AVDD_n278 AVDD_t34 4.13323
R565 AVDD_n75 AVDD_t29 4.13252
R566 AVDD_n360 AVDD_n358 3.99818
R567 AVDD_n37 AVDD_t16 3.99681
R568 AVDD_n263 AVDD_t61 3.52578
R569 AVDD_n263 AVDD_t57 3.52521
R570 AVDD_n361 AVDD_n360 3.25209
R571 AVDD_n314 AVDD_n40 2.83444
R572 AVDD_n305 AVDD_n89 2.83444
R573 AVDD_n262 AVDD_n173 2.83444
R574 AVDD_n39 AVDD_n26 2.83444
R575 AVDD_n27 AVDD_n26 2.83444
R576 AVDD_n276 AVDD_n147 2.83444
R577 AVDD_n302 AVDD_n115 2.83444
R578 AVDD_n337 AVDD_n36 2.83444
R579 AVDD_n109 AVDD_n108 2.83444
R580 AVDD_n289 AVDD_n145 2.83444
R581 AVDD_n289 AVDD_n144 2.83444
R582 AVDD_n168 AVDD_n130 2.83444
R583 AVDD_n140 AVDD_n130 2.83444
R584 AVDD_n314 AVDD_n312 2.83433
R585 AVDD_n302 AVDD_n120 2.83433
R586 AVDD_n305 AVDD_t41 2.83383
R587 AVDD_n100 AVDD_t55 2.79905
R588 AVDD_n326 AVDD_n305 2.72834
R589 AVDD_n268 AVDD_n262 2.72387
R590 AVDD_n369 AVDD_n368 2.56394
R591 AVDD_n315 AVDD_t7 2.53363
R592 AVDD_n341 AVDD_n12 2.48779
R593 AVDD_n263 AVDD_t58 2.31643
R594 AVDD_n109 AVDD_n107 2.29499
R595 AVDD_n125 AVDD_t12 2.28131
R596 AVDD_n279 AVDD_t27 2.14666
R597 AVDD_n283 AVDD_t51 2.14656
R598 AVDD_n77 AVDD_t36 2.14647
R599 AVDD_n75 AVDD_t31 2.14643
R600 AVDD_n280 AVDD_t48 2.1464
R601 AVDD_n79 AVDD_t40 2.14619
R602 AVDD_n78 AVDD_t38 2.14574
R603 AVDD_n278 AVDD_t46 2.1457
R604 AVDD_n76 AVDD_t32 2.1457
R605 AVDD_n284 AVDD_t52 2.14567
R606 AVDD_n80 AVDD_t42 2.14543
R607 AVDD_n281 AVDD_t49 2.1454
R608 AVDD_n81 AVDD_t44 2.1454
R609 AVDD_n282 AVDD_t50 2.14532
R610 AVDD_n314 AVDD_n309 2.126
R611 AVDD_n60 AVDD_n26 2.126
R612 AVDD_n338 AVDD_n26 2.126
R613 AVDD_n335 AVDD_t39 2.1255
R614 AVDD_n279 AVDD_n278 1.98738
R615 AVDD_n280 AVDD_n279 1.98738
R616 AVDD_n281 AVDD_n280 1.98738
R617 AVDD_n282 AVDD_n281 1.98738
R618 AVDD_n283 AVDD_n282 1.98738
R619 AVDD_n284 AVDD_n283 1.98738
R620 AVDD_n76 AVDD_n75 1.98738
R621 AVDD_n77 AVDD_n76 1.98738
R622 AVDD_n78 AVDD_n77 1.98738
R623 AVDD_n79 AVDD_n78 1.98738
R624 AVDD_n80 AVDD_n79 1.98738
R625 AVDD_n81 AVDD_n80 1.98738
R626 AVDD_n289 AVDD_n143 1.97072
R627 AVDD_n101 AVDD_n28 1.96996
R628 AVDD_n324 AVDD_t9 1.96541
R629 AVDD_n132 AVDD_t64 1.94032
R630 AVDD_n294 AVDD_t63 1.94032
R631 AVDD_n272 AVDD_n271 1.93283
R632 AVDD_n318 AVDD_t14 1.8359
R633 AVDD_n265 AVDD_n262 1.71685
R634 AVDD_n258 AVDD_n257 1.60827
R635 AVDD_n336 AVDD_n28 1.54595
R636 AVDD_t30 AVDD_n28 1.54595
R637 AVDD_n266 AVDD_n169 1.53209
R638 AVDD_n319 AVDD_n318 1.52027
R639 AVDD_n264 AVDD_n171 1.51606
R640 AVDD_n102 AVDD_n29 1.51383
R641 AVDD_n301 AVDD_n126 1.50512
R642 AVDD_n291 AVDD_n290 1.50486
R643 AVDD_n285 AVDD_n169 1.46989
R644 AVDD_n329 AVDD_n328 1.45558
R645 AVDD_n333 AVDD_n12 1.44486
R646 AVDD_n106 AVDD_n99 1.43841
R647 AVDD_n104 AVDD_n103 1.42945
R648 AVDD_n254 AVDD_n253 1.42318
R649 AVDD_n37 AVDD_n29 1.42233
R650 AVDD_n320 AVDD_n319 1.41878
R651 AVDD_n292 AVDD_n129 1.41345
R652 AVDD_n290 AVDD_n132 1.40923
R653 AVDD_n328 AVDD_n327 1.38007
R654 AVDD_n256 AVDD_n254 1.37003
R655 AVDD_n299 AVDD_n298 1.36727
R656 AVDD_n272 AVDD_n170 1.36249
R657 AVDD_n298 AVDD_n297 1.35935
R658 AVDD_n270 AVDD_n170 1.35905
R659 AVDD_n301 AVDD_n300 1.35367
R660 AVDD_n335 AVDD_n334 1.34122
R661 AVDD_n302 AVDD_n97 1.34122
R662 AVDD_n296 AVDD_n129 1.33979
R663 AVDD_n360 AVDD_t24 1.33349
R664 AVDD_n111 AVDD_n99 1.3318
R665 AVDD_n269 AVDD_n171 1.31346
R666 AVDD_n325 AVDD_n86 1.31055
R667 AVDD_n329 AVDD_n86 1.30149
R668 AVDD_n322 AVDD_n321 1.29653
R669 AVDD_n331 AVDD_n330 1.28613
R670 AVDD_n255 AVDD_n83 1.27756
R671 AVDD_n105 AVDD_n104 1.25634
R672 AVDD_n296 AVDD_n295 1.25624
R673 AVDD_n323 AVDD_n322 1.24686
R674 AVDD_n370 AVDD_n369 1.23514
R675 AVDD_n299 AVDD_n127 1.23239
R676 AVDD_n297 AVDD_n127 1.22679
R677 AVDD_n332 AVDD_n331 1.22253
R678 AVDD_n337 AVDD_n336 1.21479
R679 AVDD_n124 AVDD_n123 1.2031
R680 AVDD_n302 AVDD_n98 1.19727
R681 AVDD_n295 AVDD_n294 1.18096
R682 AVDD_n259 AVDD_n258 1.13744
R683 AVDD_t39 AVDD_n26 1.13383
R684 AVDD_n289 AVDD_n288 1.13383
R685 AVDD_n158 AVDD_n130 1.13383
R686 AVDD_n342 AVDD_n341 1.13153
R687 AVDD_n191 AVDD_n153 1.10283
R688 AVDD_n256 AVDD_n255 1.07475
R689 AVDD_n271 AVDD_n131 1.07012
R690 AVDD_n316 AVDD_n315 1.06684
R691 AVDD_n277 AVDD_n276 1.0635
R692 AVDD_n276 AVDD_n275 1.0635
R693 AVDD_t28 AVDD_n13 1.06345
R694 AVDD_t30 AVDD_n337 1.063
R695 AVDD_n330 AVDD_n329 1.02487
R696 AVDD_n314 AVDD_n313 1.001
R697 AVDD_n314 AVDD_n307 1.001
R698 AVDD_n26 AVDD_n25 1.001
R699 AVDD_n289 AVDD_n133 1.001
R700 AVDD_n148 AVDD_n130 1.001
R701 AVDD_n321 AVDD_n316 0.985829
R702 AVDD_n293 AVDD_n130 0.967806
R703 AVDD_n276 AVDD_n273 0.966768
R704 AVDD_n266 AVDD_n153 0.958261
R705 AVDD_n126 AVDD_n113 0.954733
R706 AVDD_n327 AVDD_n323 0.942375
R707 AVDD_n323 AVDD_n306 0.938447
R708 AVDD_n291 AVDD_n131 0.934976
R709 AVDD_n113 AVDD_n112 0.922086
R710 AVDD_n315 AVDD_n306 0.877989
R711 AVDD_n294 AVDD_n293 0.875268
R712 AVDD_n124 AVDD_t18 0.85343
R713 AVDD_n106 AVDD_n105 0.804875
R714 AVDD_n285 AVDD_n284 0.798
R715 AVDD_n82 AVDD_n81 0.798
R716 AVDD_n321 AVDD_n320 0.791125
R717 AVDD_n305 AVDD_n304 0.773227
R718 AVDD_n297 AVDD_n296 0.752167
R719 AVDD_n257 AVDD_n256 0.744833
R720 AVDD_n267 AVDD_n266 0.743
R721 AVDD_n325 AVDD_n324 0.743
R722 AVDD_n123 AVDD_n98 0.739166
R723 AVDD_n293 AVDD_n292 0.724239
R724 AVDD_n302 AVDD_n113 0.720216
R725 AVDD_n368 AVDD_n367 0.71902
R726 AVDD_n314 AVDD_n306 0.718841
R727 AVDD_n371 AVDD_n370 0.71022
R728 AVDD_n109 AVDD_t39 0.708833
R729 AVDD_n109 AVDD_t6 0.708833
R730 AVDD_n300 AVDD_n97 0.705804
R731 AVDD_n123 AVDD_n97 0.691425
R732 AVDD_n273 AVDD_n272 0.688891
R733 AVDD_n273 AVDD_n270 0.687
R734 AVDD_n300 AVDD_n299 0.656833
R735 AVDD_n333 AVDD_n332 0.656833
R736 AVDD_n262 AVDD_n261 0.654846
R737 AVDD_n262 AVDD_n260 0.654846
R738 AVDD_n305 AVDD_n95 0.654793
R739 AVDD_n334 AVDD_n82 0.643471
R740 AVDD_n112 AVDD_n98 0.632917
R741 AVDD_n112 AVDD_n111 0.6165
R742 AVDD_n304 AVDD_n74 0.61023
R743 AVDD_n334 AVDD_n333 0.607092
R744 AVDD_n267 AVDD_n265 0.601312
R745 AVDD_n341 AVDD_n340 0.60045
R746 AVDD_n143 AVDD_n132 0.570737
R747 AVDD_n105 AVDD_n101 0.565506
R748 AVDD_n270 AVDD_n269 0.554167
R749 AVDD_n287 AVDD_n153 0.548275
R750 AVDD_n289 AVDD_n131 0.541445
R751 AVDD_n316 AVDD_n314 0.540795
R752 AVDD_n103 AVDD_n102 0.529875
R753 AVDD_n126 AVDD_n125 0.48175
R754 AVDD_n265 AVDD_n264 0.481055
R755 AVDD_n259 AVDD_n179 0.472722
R756 AVDD_n304 AVDD_n84 0.472722
R757 AVDD_n303 AVDD_n302 0.448368
R758 AVDD_n178 AVDD_n128 0.448368
R759 AVDD_n302 AVDD_t39 0.447868
R760 AVDD_n128 AVDD_n96 0.426427
R761 AVDD_n271 AVDD_n143 0.421413
R762 AVDD_n269 AVDD_n268 0.409822
R763 AVDD_n107 AVDD_n100 0.405803
R764 AVDD_n292 AVDD_n291 0.403833
R765 AVDD_n327 AVDD_n326 0.396912
R766 AVDD_n326 AVDD_n325 0.395585
R767 AVDD_n107 AVDD_n106 0.394531
R768 AVDD_n103 AVDD_n101 0.383897
R769 AVDD_n255 AVDD_n179 0.378894
R770 AVDD_n264 AVDD_n263 0.378625
R771 AVDD_n128 AVDD_n127 0.344981
R772 AVDD_n347 AVDD_n346 0.327378
R773 AVDD_n343 AVDD_n342 0.312698
R774 AVDD_n209 AVDD_n85 0.312698
R775 AVDD_n220 AVDD_n209 0.312358
R776 AVDD_n38 AVDD_n37 0.279676
R777 AVDD_n232 AVDD_n231 0.272189
R778 AVDD_n232 AVDD_n201 0.272189
R779 AVDD_n295 AVDD_n130 0.266767
R780 AVDD_n268 AVDD_n267 0.262443
R781 AVDD_n257 AVDD_n196 0.255606
R782 AVDD_n344 AVDD_n343 0.250378
R783 AVDD_n345 AVDD_n344 0.250378
R784 AVDD_n346 AVDD_n345 0.250378
R785 AVDD_n348 AVDD_n347 0.250378
R786 AVDD_n349 AVDD_n348 0.250378
R787 AVDD_n350 AVDD_n349 0.250378
R788 AVDD_n351 AVDD_n350 0.250378
R789 AVDD_n352 AVDD_n351 0.250378
R790 AVDD_n221 AVDD_n220 0.250378
R791 AVDD_n221 AVDD_n205 0.250378
R792 AVDD_n231 AVDD_n205 0.250378
R793 AVDD_n241 AVDD_n201 0.250378
R794 AVDD_n242 AVDD_n241 0.250378
R795 AVDD_n242 AVDD_n197 0.250378
R796 AVDD_n253 AVDD_n197 0.250378
R797 AVDD_n192 AVDD_n191 0.250378
R798 AVDD_n193 AVDD_n192 0.250378
R799 AVDD_n194 AVDD_n193 0.250378
R800 AVDD_n195 AVDD_n194 0.250378
R801 AVDD_n196 AVDD_n195 0.250378
R802 AVDD_n111 AVDD_n110 0.250092
R803 AVDD_n286 AVDD_t47 0.249701
R804 AVDD_n110 AVDD_n100 0.231419
R805 AVDD_n322 AVDD_n314 0.205691
R806 AVDD_n276 AVDD_n170 0.191084
R807 AVDD_n320 AVDD_n317 0.187772
R808 AVDD_n332 AVDD_n83 0.187772
R809 AVDD AVDD_n372 0.18486
R810 AVDD_n318 AVDD_n317 0.182272
R811 AVDD_n372 AVDD_n371 0.15626
R812 AVDD_n353 AVDD_n352 0.148959
R813 AVDD_n355 AVDD_n354 0.148386
R814 AVDD_n102 AVDD_n38 0.146176
R815 AVDD_n331 AVDD_n84 0.144223
R816 AVDD_n305 AVDD_n86 0.143444
R817 AVDD_n254 AVDD_n179 0.136067
R818 AVDD_n330 AVDD_n85 0.125439
R819 AVDD_n362 AVDD_n358 0.1205
R820 AVDD_n104 AVDD_n28 0.116039
R821 AVDD_n130 AVDD_n129 0.0810905
R822 AVDD_n359 AVDD_n358 0.0655
R823 AVDD_n328 AVDD_n305 0.0534423
R824 AVDD_n337 AVDD_n29 0.0416869
R825 AVDD_n290 AVDD_n289 0.0270412
R826 AVDD_n109 AVDD_n99 0.0260595
R827 AVDD_n262 AVDD_n171 0.0111532
R828 AVDD_n335 AVDD_n12 0.00941537
R829 AVDD_n335 AVDD_n74 0.00772326
R830 AVDD_n302 AVDD_n301 0.00674758
R831 AVDD_n258 AVDD_n185 0.00642611
R832 AVDD_n357 AVDD_n354 0.0055
R833 AVDD_n287 AVDD_n169 0.00402211
R834 AVDD_n287 AVDD_n286 0.00394628
R835 AVDD_n319 AVDD_n26 0.0027407
R836 AVDD_n298 AVDD_n128 0.00205444
R837 AVDD_n13 AVDD_n11 0.00193748
R838 AVDD_n95 AVDD_n48 0.00192304
R839 AVDD_n339 AVDD_n338 0.00175
R840 AVDD_n252 AVDD_n251 0.00175
R841 AVDD_n173 AVDD_n139 0.00166667
R842 AVDD_n167 AVDD_n145 0.00166667
R843 AVDD_t30 AVDD_n27 0.00166667
R844 AVDD_n56 AVDD_n36 0.00166667
R845 AVDD_n39 AVDD_n30 0.00166667
R846 AVDD_t35 AVDD_n40 0.00166667
R847 AVDD_n108 AVDD_t54 0.00166667
R848 AVDD_n89 AVDD_t43 0.00166667
R849 AVDD_n115 AVDD_n72 0.00166667
R850 AVDD_t62 AVDD_n140 0.00166667
R851 AVDD_n166 AVDD_n144 0.00166667
R852 AVDD_n168 AVDD_n146 0.00166667
R853 AVDD_n149 AVDD_n147 0.00166667
R854 AVDD_n24 AVDD_n10 0.00166667
R855 AVDD_n1 AVDD_n0 0.00166667
R856 AVDD_n211 AVDD_n84 0.00166667
R857 AVDD_n190 AVDD_n157 0.00166667
R858 AVDD_n304 AVDD_n96 0.00152503
R859 AVDD_n213 AVDD_n96 0.00147495
R860 AVDD_n24 AVDD_n11 0.00133332
R861 AVDD_n287 AVDD_n157 0.00133332
R862 AVDD_n211 AVDD_n210 0.00133332
R863 AVDD_n336 AVDD_n40 0.00133331
R864 AVDD_n89 AVDD_n43 0.00133331
R865 AVDD_n336 AVDD_n39 0.00133331
R866 AVDD_n57 AVDD_n27 0.00133331
R867 AVDD_n288 AVDD_n147 0.00133331
R868 AVDD_n115 AVDD_n43 0.00133331
R869 AVDD_n57 AVDD_n36 0.00133331
R870 AVDD_n108 AVDD_t37 0.00133331
R871 AVDD_n150 AVDD_n144 0.00133331
R872 AVDD_t26 AVDD_n168 0.00133331
R873 AVDD_n140 AVDD_t60 0.00133331
R874 AVDD_n173 AVDD_t60 0.00133331
R875 AVDD_t26 AVDD_n145 0.00133331
R876 AVDD_n251 AVDD_n179 0.00124998
R877 AVDD_n338 AVDD_t30 0.00124997
R878 AVDD_n95 AVDD_t39 0.00107691
R879 AVDD_n340 AVDD_n13 0.00106249
R880 AVDD_n23 AVDD_n10 0.001
R881 AVDD_n22 AVDD_n8 0.001
R882 AVDD_n21 AVDD_n7 0.001
R883 AVDD_n20 AVDD_n6 0.001
R884 AVDD_n19 AVDD_n5 0.001
R885 AVDD_n18 AVDD_n5 0.001
R886 AVDD_n17 AVDD_n3 0.001
R887 AVDD_n16 AVDD_n2 0.001
R888 AVDD_n15 AVDD_n1 0.001
R889 AVDD_n335 AVDD_n14 0.001
R890 AVDD_n340 AVDD_n14 0.001
R891 AVDD_n23 AVDD_n9 0.001
R892 AVDD_n22 AVDD_n9 0.001
R893 AVDD_n21 AVDD_n8 0.001
R894 AVDD_n20 AVDD_n7 0.001
R895 AVDD_n19 AVDD_n6 0.001
R896 AVDD_n18 AVDD_n4 0.001
R897 AVDD_n17 AVDD_n4 0.001
R898 AVDD_n16 AVDD_n3 0.001
R899 AVDD_n15 AVDD_n2 0.001
R900 AVDD_n189 AVDD_n182 0.001
R901 AVDD_n189 AVDD_n181 0.001
R902 AVDD_n188 AVDD_n180 0.001
R903 AVDD_n186 AVDD_n183 0.001
R904 AVDD_n185 AVDD_n184 0.001
R905 AVDD_n252 AVDD_n198 0.001
R906 AVDD_n245 AVDD_n244 0.001
R907 AVDD_n243 AVDD_n200 0.001
R908 AVDD_n240 AVDD_n239 0.001
R909 AVDD_n234 AVDD_n202 0.001
R910 AVDD_n233 AVDD_n204 0.001
R911 AVDD_n230 AVDD_n229 0.001
R912 AVDD_n223 AVDD_n206 0.001
R913 AVDD_n222 AVDD_n208 0.001
R914 AVDD_n219 AVDD_n218 0.001
R915 AVDD_n212 AVDD_n179 0.001
R916 AVDD_n313 AVDD_n66 0.001
R917 AVDD_n312 AVDD_n49 0.001
R918 AVDD_n311 AVDD_t54 0.001
R919 AVDD_n310 AVDD_n64 0.001
R920 AVDD_n309 AVDD_t6 0.001
R921 AVDD_n308 AVDD_t13 0.001
R922 AVDD_n307 AVDD_n32 0.001
R923 AVDD_n87 AVDD_n41 0.001
R924 AVDD_n88 AVDD_n72 0.001
R925 AVDD_n90 AVDD_n44 0.001
R926 AVDD_n91 AVDD_n70 0.001
R927 AVDD_n92 AVDD_n45 0.001
R928 AVDD_n93 AVDD_n68 0.001
R929 AVDD_n94 AVDD_n47 0.001
R930 AVDD_n261 AVDD_n152 0.001
R931 AVDD_n172 AVDD_t62 0.001
R932 AVDD_n174 AVDD_n154 0.001
R933 AVDD_n175 AVDD_t56 0.001
R934 AVDD_n176 AVDD_n155 0.001
R935 AVDD_n177 AVDD_n159 0.001
R936 AVDD_n260 AVDD_n158 0.001
R937 AVDD_n66 AVDD_n65 0.001
R938 AVDD_n63 AVDD_n50 0.001
R939 AVDD_n62 AVDD_n61 0.001
R940 AVDD_n60 AVDD_t6 0.001
R941 AVDD_n53 AVDD_n52 0.001
R942 AVDD_t15 AVDD_n34 0.001
R943 AVDD_n55 AVDD_n54 0.001
R944 AVDD_n58 AVDD_n56 0.001
R945 AVDD_n339 AVDD_n25 0.001
R946 AVDD_n277 AVDD_n149 0.001
R947 AVDD_n274 AVDD_t53 0.001
R948 AVDD_n275 AVDD_n167 0.001
R949 AVDD_n303 AVDD_n41 0.001
R950 AVDD_n114 AVDD_n73 0.001
R951 AVDD_n116 AVDD_n71 0.001
R952 AVDD_n117 AVDD_n70 0.001
R953 AVDD_n118 AVDD_t8 0.001
R954 AVDD_n119 AVDD_t41 0.001
R955 AVDD_n120 AVDD_t41 0.001
R956 AVDD_n121 AVDD_n68 0.001
R957 AVDD_n122 AVDD_n67 0.001
R958 AVDD_n53 AVDD_n31 0.001
R959 AVDD_n55 AVDD_n35 0.001
R960 AVDD_n250 AVDD_n178 0.001
R961 AVDD_n250 AVDD_n249 0.001
R962 AVDD_n247 AVDD_n246 0.001
R963 AVDD_n246 AVDD_n199 0.001
R964 AVDD_n237 AVDD_n236 0.001
R965 AVDD_n238 AVDD_n235 0.001
R966 AVDD_t21 AVDD_n203 0.001
R967 AVDD_n228 AVDD_n227 0.001
R968 AVDD_n228 AVDD_n225 0.001
R969 AVDD_n224 AVDD_n207 0.001
R970 AVDD_n216 AVDD_n215 0.001
R971 AVDD_n217 AVDD_n214 0.001
R972 AVDD_n151 AVDD_n142 0.001
R973 AVDD_n163 AVDD_n141 0.001
R974 AVDD_t33 AVDD_n137 0.001
R975 AVDD_n161 AVDD_n136 0.001
R976 AVDD_n160 AVDD_n135 0.001
R977 AVDD_n159 AVDD_n134 0.001
R978 AVDD_n158 AVDD_n133 0.001
R979 AVDD_n148 AVDD_t53 0.001
R980 AVDD_n165 AVDD_n151 0.001
R981 AVDD_n163 AVDD_n162 0.001
R982 AVDD_n139 AVDD_n138 0.001
R983 AVDD_n25 AVDD_t28 0.001
R984 AVDD_n59 AVDD_n58 0.001
R985 AVDD_n59 AVDD_n35 0.001
R986 AVDD_n54 AVDD_t15 0.001
R987 AVDD_n34 AVDD_n33 0.001
R988 AVDD_n307 AVDD_n33 0.001
R989 AVDD_n52 AVDD_n32 0.001
R990 AVDD_t13 AVDD_n31 0.001
R991 AVDD_n308 AVDD_n30 0.001
R992 AVDD_t35 AVDD_n60 0.001
R993 AVDD_n309 AVDD_n62 0.001
R994 AVDD_n61 AVDD_n51 0.001
R995 AVDD_n310 AVDD_n51 0.001
R996 AVDD_n64 AVDD_n63 0.001
R997 AVDD_n311 AVDD_n50 0.001
R998 AVDD_n312 AVDD_t37 0.001
R999 AVDD_n65 AVDD_n49 0.001
R1000 AVDD_n313 AVDD_t39 0.001
R1001 AVDD_n122 AVDD_n48 0.001
R1002 AVDD_n94 AVDD_n67 0.001
R1003 AVDD_n121 AVDD_n47 0.001
R1004 AVDD_n93 AVDD_n46 0.001
R1005 AVDD_n120 AVDD_n46 0.001
R1006 AVDD_n119 AVDD_n45 0.001
R1007 AVDD_n92 AVDD_n69 0.001
R1008 AVDD_n118 AVDD_n69 0.001
R1009 AVDD_n91 AVDD_t8 0.001
R1010 AVDD_n117 AVDD_n44 0.001
R1011 AVDD_n90 AVDD_n71 0.001
R1012 AVDD_n116 AVDD_t43 0.001
R1013 AVDD_n88 AVDD_n42 0.001
R1014 AVDD_n114 AVDD_n42 0.001
R1015 AVDD_n87 AVDD_n73 0.001
R1016 AVDD_n304 AVDD_n303 0.001
R1017 AVDD_n214 AVDD_n213 0.001
R1018 AVDD_n217 AVDD_n216 0.001
R1019 AVDD_n215 AVDD_n207 0.001
R1020 AVDD_n225 AVDD_n224 0.001
R1021 AVDD_n227 AVDD_n226 0.001
R1022 AVDD_n226 AVDD_n203 0.001
R1023 AVDD_n235 AVDD_t21 0.001
R1024 AVDD_n238 AVDD_n237 0.001
R1025 AVDD_n236 AVDD_n199 0.001
R1026 AVDD_n248 AVDD_n247 0.001
R1027 AVDD_n249 AVDD_n248 0.001
R1028 AVDD_n259 AVDD_n178 0.001
R1029 AVDD_n260 AVDD_n259 0.001
R1030 AVDD_n156 AVDD_n133 0.001
R1031 AVDD_n177 AVDD_n156 0.001
R1032 AVDD_n155 AVDD_n134 0.001
R1033 AVDD_n176 AVDD_n160 0.001
R1034 AVDD_t56 AVDD_n135 0.001
R1035 AVDD_n175 AVDD_n161 0.001
R1036 AVDD_t33 AVDD_n136 0.001
R1037 AVDD_n154 AVDD_n137 0.001
R1038 AVDD_n174 AVDD_t59 0.001
R1039 AVDD_n138 AVDD_t59 0.001
R1040 AVDD_n172 AVDD_t45 0.001
R1041 AVDD_n162 AVDD_t45 0.001
R1042 AVDD_n152 AVDD_n141 0.001
R1043 AVDD_n261 AVDD_n164 0.001
R1044 AVDD_n164 AVDD_n142 0.001
R1045 AVDD_n166 AVDD_n165 0.001
R1046 AVDD_n275 AVDD_n150 0.001
R1047 AVDD_n274 AVDD_n146 0.001
R1048 AVDD_n288 AVDD_n148 0.001
R1049 AVDD_t47 AVDD_n277 0.001
R1050 AVDD_n212 AVDD_n84 0.001
R1051 AVDD_n218 AVDD_n210 0.001
R1052 AVDD_n219 AVDD_n208 0.001
R1053 AVDD_n223 AVDD_n222 0.001
R1054 AVDD_n229 AVDD_n206 0.001
R1055 AVDD_n230 AVDD_n204 0.001
R1056 AVDD_n234 AVDD_n233 0.001
R1057 AVDD_n239 AVDD_n202 0.001
R1058 AVDD_n240 AVDD_n200 0.001
R1059 AVDD_n245 AVDD_n243 0.001
R1060 AVDD_n244 AVDD_n198 0.001
R1061 AVDD_n190 AVDD_n182 0.001
R1062 AVDD_n188 AVDD_n181 0.001
R1063 AVDD_n187 AVDD_n180 0.001
R1064 AVDD_n187 AVDD_n183 0.001
R1065 AVDD_n186 AVDD_n184 0.001
R1066 AVSS_n632 AVSS_t0 8776.19
R1067 AVSS_n804 AVSS_t0 5957.38
R1068 AVSS_n801 AVSS_t15 4400.57
R1069 AVSS_n804 AVSS_n803 4000
R1070 AVSS_n803 AVSS_n797 3356.2
R1071 AVSS_t6 AVSS_t3 3266
R1072 AVSS_n800 AVSS_t12 3254.65
R1073 AVSS_n804 AVSS_n7 2843.06
R1074 AVSS_n804 AVSS_n12 2605.04
R1075 AVSS_n804 AVSS_n6 2210.78
R1076 AVSS_n801 AVSS_n797 2167.6
R1077 AVSS_n803 AVSS_n802 2058.25
R1078 AVSS_n799 AVSS_n798 1672.53
R1079 AVSS_n798 AVSS_t5 1633.18
R1080 AVSS_n5 AVSS_t9 1560.98
R1081 AVSS_n799 AVSS_t18 1555.76
R1082 AVSS_t15 AVSS_n796 1527.7
R1083 AVSS_n804 AVSS_n8 1289.21
R1084 AVSS_n11 AVSS_t25 1043.48
R1085 AVSS_n3 AVSS_t22 1024.91
R1086 AVSS_n9 AVSS_t19 982.936
R1087 AVSS_n4 AVSS_t30 939.641
R1088 AVSS_t5 AVSS_t8 902.038
R1089 AVSS_n800 AVSS_n799 882.973
R1090 AVSS_n799 AVSS_t4 863.385
R1091 AVSS_t13 AVSS_n801 679.63
R1092 AVSS_n801 AVSS_t21 661.572
R1093 AVSS_n803 AVSS_n796 649.077
R1094 AVSS_n804 AVSS_t6 603.909
R1095 AVSS_t29 AVSS_n7 549.297
R1096 AVSS_n804 AVSS_n10 512.518
R1097 AVSS_t24 AVSS_n12 473.389
R1098 AVSS_n798 AVSS_t29 431.591
R1099 AVSS_n802 AVSS_t24 417.368
R1100 AVSS_n804 AVSS_n5 406.505
R1101 AVSS_n802 AVSS_t13 396.005
R1102 AVSS_t8 AVSS_n6 379.096
R1103 AVSS_t3 AVSS_n770 342.409
R1104 AVSS_n804 AVSS_n11 271.74
R1105 AVSS_n804 AVSS_n3 266.904
R1106 AVSS_n804 AVSS_n9 255.974
R1107 AVSS_n804 AVSS_n4 244.698
R1108 AVSS_t18 AVSS_n8 231.189
R1109 AVSS_n692 AVSS_t1 230.394
R1110 AVSS_n562 AVSS_t1 219.423
R1111 AVSS_t11 AVSS_t7 160.52
R1112 AVSS_t7 AVSS_t54 160.52
R1113 AVSS_t21 AVSS_n10 117.523
R1114 AVSS_n805 AVSS_t16 113.677
R1115 AVSS_n800 AVSS_t11 105.484
R1116 AVSS_n797 AVSS_t16 93.547
R1117 AVSS_n503 AVSS_n495 67.0464
R1118 AVSS_t28 AVSS_n460 60.3418
R1119 AVSS_n808 AVSS_n807 45.8404
R1120 AVSS_n724 AVSS_t42 39.009
R1121 AVSS_n495 AVSS_n412 39.009
R1122 AVSS_n427 AVSS_n426 39.009
R1123 AVSS_n431 AVSS_n430 39.009
R1124 AVSS_n429 AVSS_n425 39.009
R1125 AVSS_n435 AVSS_n434 39.009
R1126 AVSS_n320 AVSS_n239 36.571
R1127 AVSS_n289 AVSS_n238 36.571
R1128 AVSS_n288 AVSS_n237 36.571
R1129 AVSS_n287 AVSS_n236 36.571
R1130 AVSS_n133 AVSS_n82 35.352
R1131 AVSS_n401 AVSS_n84 35.352
R1132 AVSS_n400 AVSS_n81 35.352
R1133 AVSS_n399 AVSS_n85 35.352
R1134 AVSS_n398 AVSS_n80 35.352
R1135 AVSS_t35 AVSS_n432 32.9139
R1136 AVSS_n243 AVSS_n242 31.6949
R1137 AVSS_n241 AVSS_n199 31.6949
R1138 AVSS_n396 AVSS_n79 30.4759
R1139 AVSS_n395 AVSS_n87 30.4759
R1140 AVSS_n394 AVSS_n77 30.4759
R1141 AVSS_n393 AVSS_n88 30.4759
R1142 AVSS_n392 AVSS_n76 30.4759
R1143 AVSS_n696 AVSS_n98 30.4759
R1144 AVSS_n805 AVSS_n804 29.6038
R1145 AVSS_n645 AVSS_n198 26.8189
R1146 AVSS_n648 AVSS_n197 26.8189
R1147 AVSS_n217 AVSS_n196 26.8189
R1148 AVSS_n216 AVSS_n195 26.8189
R1149 AVSS_n259 AVSS_t27 25.5998
R1150 AVSS_n274 AVSS_n167 24.3808
R1151 AVSS_n273 AVSS_n166 24.3808
R1152 AVSS_n235 AVSS_t44 23.7713
R1153 AVSS_t36 AVSS_n165 23.7713
R1154 AVSS_n231 AVSS_n174 23.1618
R1155 AVSS_n230 AVSS_n173 23.1618
R1156 AVSS_n229 AVSS_n172 23.1618
R1157 AVSS_n228 AVSS_n171 23.1618
R1158 AVSS_n227 AVSS_n170 23.1618
R1159 AVSS_n226 AVSS_n169 23.1618
R1160 AVSS_n225 AVSS_n168 23.1618
R1161 AVSS_n224 AVSS_t50 23.1618
R1162 AVSS_n272 AVSS_n164 23.1618
R1163 AVSS_n61 AVSS_n36 23.1618
R1164 AVSS_n389 AVSS_n39 23.1618
R1165 AVSS_n388 AVSS_n35 23.1618
R1166 AVSS_n387 AVSS_n40 23.1618
R1167 AVSS_n386 AVSS_n34 23.1618
R1168 AVSS_n384 AVSS_n41 23.1618
R1169 AVSS_n383 AVSS_n33 23.1618
R1170 AVSS_n382 AVSS_n42 23.1618
R1171 AVSS_n381 AVSS_n32 23.1618
R1172 AVSS_n380 AVSS_n43 23.1618
R1173 AVSS_n53 AVSS_n31 23.1618
R1174 AVSS_n752 AVSS_n44 23.1618
R1175 AVSS_n285 AVSS_n177 21.9428
R1176 AVSS_n284 AVSS_n176 21.9428
R1177 AVSS_n306 AVSS_n175 21.9428
R1178 AVSS_n356 AVSS_n162 21.9428
R1179 AVSS_n357 AVSS_n161 21.9428
R1180 AVSS_n358 AVSS_n160 21.9428
R1181 AVSS_n359 AVSS_n159 21.9428
R1182 AVSS_n360 AVSS_n158 21.9428
R1183 AVSS_n521 AVSS_n153 21.9428
R1184 AVSS_n437 AVSS_n424 21.9428
R1185 AVSS_n438 AVSS_n436 21.9428
R1186 AVSS_n468 AVSS_n423 21.9428
R1187 AVSS_n483 AVSS_n465 21.9428
R1188 AVSS_n213 AVSS_n193 20.7238
R1189 AVSS_n211 AVSS_n192 20.7238
R1190 AVSS_n256 AVSS_n191 20.7238
R1191 AVSS_n286 AVSS_n179 19.5048
R1192 AVSS_n343 AVSS_n163 19.5048
R1193 AVSS_n565 AVSS_n162 19.5048
R1194 AVSS_n356 AVSS_n161 19.5048
R1195 AVSS_n558 AVSS_n157 19.5048
R1196 AVSS_n523 AVSS_n155 19.5048
R1197 AVSS_n521 AVSS_n154 19.5048
R1198 AVSS_n520 AVSS_n153 19.5048
R1199 AVSS_n432 AVSS_n424 19.5048
R1200 AVSS_n438 AVSS_n437 19.5048
R1201 AVSS_n436 AVSS_n423 19.5048
R1202 AVSS_n483 AVSS_n468 19.5048
R1203 AVSS_n461 AVSS_t28 18.8953
R1204 AVSS_n408 AVSS_n391 18.6794
R1205 AVSS_n234 AVSS_n178 18.2857
R1206 AVSS_n233 AVSS_n177 18.2857
R1207 AVSS_n232 AVSS_n176 18.2857
R1208 AVSS_n231 AVSS_n175 18.2857
R1209 AVSS_n230 AVSS_n174 18.2857
R1210 AVSS_n598 AVSS_t50 18.2857
R1211 AVSS_n270 AVSS_n164 18.2857
R1212 AVSS_n573 AVSS_n163 18.2857
R1213 AVSS_t38 AVSS_n86 18.2857
R1214 AVSS_n724 AVSS_n61 18.2857
R1215 AVSS_n389 AVSS_n36 18.2857
R1216 AVSS_n388 AVSS_n39 18.2857
R1217 AVSS_n387 AVSS_n35 18.2857
R1218 AVSS_n386 AVSS_n40 18.2857
R1219 AVSS_n404 AVSS_n34 18.2857
R1220 AVSS_t40 AVSS_n41 18.2857
R1221 AVSS_n384 AVSS_n33 18.2857
R1222 AVSS_n383 AVSS_n42 18.2857
R1223 AVSS_n382 AVSS_n32 18.2857
R1224 AVSS_n381 AVSS_n43 18.2857
R1225 AVSS_n380 AVSS_n31 18.2857
R1226 AVSS_n752 AVSS_n53 18.2857
R1227 AVSS_n783 AVSS_n8 18.0726
R1228 AVSS_n791 AVSS_n12 18.0501
R1229 AVSS_n796 AVSS_n795 18.0201
R1230 AVSS_n787 AVSS_n10 18.0051
R1231 AVSS_t46 AVSS_n178 17.0667
R1232 AVSS_n587 AVSS_n173 17.0667
R1233 AVSS_n279 AVSS_n172 17.0667
R1234 AVSS_n278 AVSS_n171 17.0667
R1235 AVSS_n277 AVSS_n170 17.0667
R1236 AVSS_n276 AVSS_n169 17.0667
R1237 AVSS_n275 AVSS_n168 17.0667
R1238 AVSS_n590 AVSS_n167 17.0667
R1239 AVSS_n274 AVSS_n166 17.0667
R1240 AVSS_n273 AVSS_n165 17.0667
R1241 AVSS_n649 AVSS_n648 17.0005
R1242 AVSS_n647 AVSS_n191 17.0005
R1243 AVSS_n647 AVSS_n192 17.0005
R1244 AVSS_n647 AVSS_n193 17.0005
R1245 AVSS_n647 AVSS_n200 17.0005
R1246 AVSS_n647 AVSS_n201 17.0005
R1247 AVSS_n647 AVSS_n195 17.0005
R1248 AVSS_n647 AVSS_n196 17.0005
R1249 AVSS_n648 AVSS_n647 17.0005
R1250 AVSS_n649 AVSS_n191 17.0005
R1251 AVSS_n649 AVSS_n192 17.0005
R1252 AVSS_n649 AVSS_n193 17.0005
R1253 AVSS_n649 AVSS_n195 17.0005
R1254 AVSS_n649 AVSS_n196 17.0005
R1255 AVSS_n185 AVSS_n149 17.0005
R1256 AVSS_n185 AVSS_n150 17.0005
R1257 AVSS_n185 AVSS_n151 17.0005
R1258 AVSS_n185 AVSS_n152 17.0005
R1259 AVSS_n185 AVSS_n153 17.0005
R1260 AVSS_n185 AVSS_n154 17.0005
R1261 AVSS_n185 AVSS_n155 17.0005
R1262 AVSS_n185 AVSS_n156 17.0005
R1263 AVSS_n185 AVSS_n157 17.0005
R1264 AVSS_n185 AVSS_n158 17.0005
R1265 AVSS_n185 AVSS_n159 17.0005
R1266 AVSS_n185 AVSS_n160 17.0005
R1267 AVSS_n185 AVSS_n161 17.0005
R1268 AVSS_n185 AVSS_n162 17.0005
R1269 AVSS_n185 AVSS_n163 17.0005
R1270 AVSS_n185 AVSS_n164 17.0005
R1271 AVSS_n185 AVSS_n165 17.0005
R1272 AVSS_n185 AVSS_n166 17.0005
R1273 AVSS_n185 AVSS_n167 17.0005
R1274 AVSS_n185 AVSS_t50 17.0005
R1275 AVSS_n185 AVSS_n168 17.0005
R1276 AVSS_n185 AVSS_n169 17.0005
R1277 AVSS_n185 AVSS_n170 17.0005
R1278 AVSS_n185 AVSS_n171 17.0005
R1279 AVSS_n185 AVSS_n172 17.0005
R1280 AVSS_n185 AVSS_n173 17.0005
R1281 AVSS_n185 AVSS_n174 17.0005
R1282 AVSS_n185 AVSS_n175 17.0005
R1283 AVSS_n185 AVSS_n176 17.0005
R1284 AVSS_n185 AVSS_n177 17.0005
R1285 AVSS_n185 AVSS_n178 17.0005
R1286 AVSS_n185 AVSS_n179 17.0005
R1287 AVSS_n663 AVSS_n149 17.0005
R1288 AVSS_n663 AVSS_n150 17.0005
R1289 AVSS_n663 AVSS_n151 17.0005
R1290 AVSS_n663 AVSS_n152 17.0005
R1291 AVSS_n663 AVSS_n153 17.0005
R1292 AVSS_n663 AVSS_n154 17.0005
R1293 AVSS_n663 AVSS_n155 17.0005
R1294 AVSS_n663 AVSS_n156 17.0005
R1295 AVSS_n663 AVSS_n157 17.0005
R1296 AVSS_n663 AVSS_n158 17.0005
R1297 AVSS_n663 AVSS_n159 17.0005
R1298 AVSS_n663 AVSS_n160 17.0005
R1299 AVSS_n663 AVSS_n161 17.0005
R1300 AVSS_n663 AVSS_n162 17.0005
R1301 AVSS_n663 AVSS_n163 17.0005
R1302 AVSS_n663 AVSS_n164 17.0005
R1303 AVSS_n663 AVSS_n165 17.0005
R1304 AVSS_n663 AVSS_n166 17.0005
R1305 AVSS_n663 AVSS_n167 17.0005
R1306 AVSS_n663 AVSS_t50 17.0005
R1307 AVSS_n663 AVSS_n168 17.0005
R1308 AVSS_n663 AVSS_n169 17.0005
R1309 AVSS_n663 AVSS_n170 17.0005
R1310 AVSS_n663 AVSS_n171 17.0005
R1311 AVSS_n663 AVSS_n172 17.0005
R1312 AVSS_n663 AVSS_n173 17.0005
R1313 AVSS_n663 AVSS_n174 17.0005
R1314 AVSS_n663 AVSS_n175 17.0005
R1315 AVSS_n663 AVSS_n176 17.0005
R1316 AVSS_n663 AVSS_n177 17.0005
R1317 AVSS_n663 AVSS_n178 17.0005
R1318 AVSS_n663 AVSS_n179 17.0005
R1319 AVSS_n549 AVSS_n149 17.0005
R1320 AVSS_n549 AVSS_n150 17.0005
R1321 AVSS_n549 AVSS_n151 17.0005
R1322 AVSS_n549 AVSS_n520 17.0005
R1323 AVSS_n549 AVSS_n521 17.0005
R1324 AVSS_n549 AVSS_n523 17.0005
R1325 AVSS_n549 AVSS_n525 17.0005
R1326 AVSS_n560 AVSS_n374 17.0005
R1327 AVSS_n560 AVSS_n149 17.0005
R1328 AVSS_n560 AVSS_n150 17.0005
R1329 AVSS_n560 AVSS_n151 17.0005
R1330 AVSS_n560 AVSS_n520 17.0005
R1331 AVSS_n560 AVSS_n521 17.0005
R1332 AVSS_n560 AVSS_n523 17.0005
R1333 AVSS_n560 AVSS_n525 17.0005
R1334 AVSS_n505 AVSS_n44 17.0005
R1335 AVSS_n505 AVSS_n53 17.0005
R1336 AVSS_n505 AVSS_n380 17.0005
R1337 AVSS_n505 AVSS_n381 17.0005
R1338 AVSS_n505 AVSS_n382 17.0005
R1339 AVSS_n505 AVSS_n383 17.0005
R1340 AVSS_n505 AVSS_n384 17.0005
R1341 AVSS_n505 AVSS_t40 17.0005
R1342 AVSS_n505 AVSS_n404 17.0005
R1343 AVSS_n505 AVSS_n386 17.0005
R1344 AVSS_n505 AVSS_n387 17.0005
R1345 AVSS_n505 AVSS_n388 17.0005
R1346 AVSS_n505 AVSS_n389 17.0005
R1347 AVSS_n505 AVSS_n61 17.0005
R1348 AVSS_n505 AVSS_n90 17.0005
R1349 AVSS_n505 AVSS_n98 17.0005
R1350 AVSS_n505 AVSS_n392 17.0005
R1351 AVSS_n505 AVSS_n393 17.0005
R1352 AVSS_n505 AVSS_n394 17.0005
R1353 AVSS_n505 AVSS_n395 17.0005
R1354 AVSS_n505 AVSS_n396 17.0005
R1355 AVSS_n505 AVSS_n407 17.0005
R1356 AVSS_n505 AVSS_n406 17.0005
R1357 AVSS_n505 AVSS_n398 17.0005
R1358 AVSS_n505 AVSS_n399 17.0005
R1359 AVSS_n505 AVSS_n400 17.0005
R1360 AVSS_n505 AVSS_n401 17.0005
R1361 AVSS_n514 AVSS_n377 17.0005
R1362 AVSS_n514 AVSS_n53 17.0005
R1363 AVSS_n514 AVSS_n380 17.0005
R1364 AVSS_n514 AVSS_n381 17.0005
R1365 AVSS_n514 AVSS_n382 17.0005
R1366 AVSS_n514 AVSS_n383 17.0005
R1367 AVSS_n514 AVSS_n384 17.0005
R1368 AVSS_n514 AVSS_n386 17.0005
R1369 AVSS_n514 AVSS_n387 17.0005
R1370 AVSS_n514 AVSS_n388 17.0005
R1371 AVSS_n514 AVSS_n389 17.0005
R1372 AVSS_n514 AVSS_n61 17.0005
R1373 AVSS_n514 AVSS_n390 17.0005
R1374 AVSS_n514 AVSS_n98 17.0005
R1375 AVSS_n514 AVSS_n392 17.0005
R1376 AVSS_n514 AVSS_n393 17.0005
R1377 AVSS_n514 AVSS_n394 17.0005
R1378 AVSS_n514 AVSS_n395 17.0005
R1379 AVSS_n514 AVSS_n396 17.0005
R1380 AVSS_n514 AVSS_n398 17.0005
R1381 AVSS_n514 AVSS_n399 17.0005
R1382 AVSS_n514 AVSS_n400 17.0005
R1383 AVSS_n514 AVSS_n401 17.0005
R1384 AVSS_n218 AVSS_n211 17.0005
R1385 AVSS_n218 AVSS_n213 17.0005
R1386 AVSS_n218 AVSS_n215 17.0005
R1387 AVSS_n218 AVSS_n216 17.0005
R1388 AVSS_n218 AVSS_n217 17.0005
R1389 AVSS_n218 AVSS_n197 17.0005
R1390 AVSS_n218 AVSS_n198 17.0005
R1391 AVSS_n630 AVSS_n210 17.0005
R1392 AVSS_n630 AVSS_n211 17.0005
R1393 AVSS_n630 AVSS_n213 17.0005
R1394 AVSS_n630 AVSS_n215 17.0005
R1395 AVSS_n630 AVSS_n216 17.0005
R1396 AVSS_n630 AVSS_n217 17.0005
R1397 AVSS_n630 AVSS_n197 17.0005
R1398 AVSS_n630 AVSS_n198 17.0005
R1399 AVSS_n296 AVSS_n284 17.0005
R1400 AVSS_n296 AVSS_n285 17.0005
R1401 AVSS_n296 AVSS_n286 17.0005
R1402 AVSS_n296 AVSS_n184 17.0005
R1403 AVSS_n296 AVSS_n287 17.0005
R1404 AVSS_n296 AVSS_n288 17.0005
R1405 AVSS_n296 AVSS_n289 17.0005
R1406 AVSS_n325 AVSS_n280 17.0005
R1407 AVSS_n325 AVSS_n284 17.0005
R1408 AVSS_n325 AVSS_n285 17.0005
R1409 AVSS_n325 AVSS_n286 17.0005
R1410 AVSS_n325 AVSS_n184 17.0005
R1411 AVSS_n325 AVSS_n287 17.0005
R1412 AVSS_n325 AVSS_n288 17.0005
R1413 AVSS_n325 AVSS_n289 17.0005
R1414 AVSS_n270 AVSS_n267 17.0005
R1415 AVSS_n272 AVSS_n267 17.0005
R1416 AVSS_n273 AVSS_n267 17.0005
R1417 AVSS_n274 AVSS_n267 17.0005
R1418 AVSS_n590 AVSS_n267 17.0005
R1419 AVSS_n275 AVSS_n267 17.0005
R1420 AVSS_n276 AVSS_n267 17.0005
R1421 AVSS_n277 AVSS_n267 17.0005
R1422 AVSS_n278 AVSS_n267 17.0005
R1423 AVSS_n279 AVSS_n267 17.0005
R1424 AVSS_n589 AVSS_n270 17.0005
R1425 AVSS_n589 AVSS_n272 17.0005
R1426 AVSS_n589 AVSS_n273 17.0005
R1427 AVSS_n589 AVSS_n274 17.0005
R1428 AVSS_n590 AVSS_n589 17.0005
R1429 AVSS_n589 AVSS_n275 17.0005
R1430 AVSS_n589 AVSS_n276 17.0005
R1431 AVSS_n589 AVSS_n277 17.0005
R1432 AVSS_n589 AVSS_n278 17.0005
R1433 AVSS_n589 AVSS_n279 17.0005
R1434 AVSS_n264 AVSS_n224 17.0005
R1435 AVSS_n264 AVSS_n225 17.0005
R1436 AVSS_n264 AVSS_n226 17.0005
R1437 AVSS_n264 AVSS_n227 17.0005
R1438 AVSS_n264 AVSS_n228 17.0005
R1439 AVSS_n264 AVSS_n229 17.0005
R1440 AVSS_n264 AVSS_n230 17.0005
R1441 AVSS_n264 AVSS_n231 17.0005
R1442 AVSS_n264 AVSS_n232 17.0005
R1443 AVSS_n264 AVSS_n233 17.0005
R1444 AVSS_n264 AVSS_n234 17.0005
R1445 AVSS_n264 AVSS_n235 17.0005
R1446 AVSS_n264 AVSS_n236 17.0005
R1447 AVSS_n264 AVSS_n237 17.0005
R1448 AVSS_n264 AVSS_n238 17.0005
R1449 AVSS_n264 AVSS_n239 17.0005
R1450 AVSS_n264 AVSS_n240 17.0005
R1451 AVSS_n264 AVSS_n241 17.0005
R1452 AVSS_n264 AVSS_n243 17.0005
R1453 AVSS_n264 AVSS_n257 17.0005
R1454 AVSS_n264 AVSS_n258 17.0005
R1455 AVSS_n264 AVSS_n259 17.0005
R1456 AVSS_n616 AVSS_n224 17.0005
R1457 AVSS_n616 AVSS_n225 17.0005
R1458 AVSS_n616 AVSS_n226 17.0005
R1459 AVSS_n616 AVSS_n227 17.0005
R1460 AVSS_n616 AVSS_n228 17.0005
R1461 AVSS_n616 AVSS_n229 17.0005
R1462 AVSS_n616 AVSS_n230 17.0005
R1463 AVSS_n616 AVSS_n231 17.0005
R1464 AVSS_n616 AVSS_n232 17.0005
R1465 AVSS_n616 AVSS_n233 17.0005
R1466 AVSS_n616 AVSS_n234 17.0005
R1467 AVSS_n616 AVSS_n235 17.0005
R1468 AVSS_n616 AVSS_n236 17.0005
R1469 AVSS_n616 AVSS_n237 17.0005
R1470 AVSS_n616 AVSS_n238 17.0005
R1471 AVSS_n616 AVSS_n239 17.0005
R1472 AVSS_n616 AVSS_n240 17.0005
R1473 AVSS_n616 AVSS_n241 17.0005
R1474 AVSS_n616 AVSS_n243 17.0005
R1475 AVSS_n616 AVSS_n257 17.0005
R1476 AVSS_n616 AVSS_n258 17.0005
R1477 AVSS_n616 AVSS_n259 17.0005
R1478 AVSS_n485 AVSS_n423 17.0005
R1479 AVSS_n485 AVSS_n438 17.0005
R1480 AVSS_n485 AVSS_n424 17.0005
R1481 AVSS_n485 AVSS_n435 17.0005
R1482 AVSS_n485 AVSS_n425 17.0005
R1483 AVSS_n485 AVSS_n431 17.0005
R1484 AVSS_n485 AVSS_n427 17.0005
R1485 AVSS_n481 AVSS_n423 17.0005
R1486 AVSS_n481 AVSS_n438 17.0005
R1487 AVSS_n481 AVSS_n424 17.0005
R1488 AVSS_n481 AVSS_n435 17.0005
R1489 AVSS_n481 AVSS_n425 17.0005
R1490 AVSS_n481 AVSS_n431 17.0005
R1491 AVSS_n481 AVSS_n427 17.0005
R1492 AVSS_n698 AVSS_n76 17.0005
R1493 AVSS_n698 AVSS_n88 17.0005
R1494 AVSS_n698 AVSS_n77 17.0005
R1495 AVSS_n698 AVSS_n87 17.0005
R1496 AVSS_n698 AVSS_n79 17.0005
R1497 AVSS_n698 AVSS_n86 17.0005
R1498 AVSS_n698 AVSS_n80 17.0005
R1499 AVSS_n698 AVSS_n85 17.0005
R1500 AVSS_n698 AVSS_n81 17.0005
R1501 AVSS_n698 AVSS_n84 17.0005
R1502 AVSS_n698 AVSS_n82 17.0005
R1503 AVSS_n694 AVSS_n76 17.0005
R1504 AVSS_n694 AVSS_n88 17.0005
R1505 AVSS_n694 AVSS_n77 17.0005
R1506 AVSS_n694 AVSS_n87 17.0005
R1507 AVSS_n694 AVSS_n79 17.0005
R1508 AVSS_n694 AVSS_n86 17.0005
R1509 AVSS_n694 AVSS_n80 17.0005
R1510 AVSS_n694 AVSS_n85 17.0005
R1511 AVSS_n694 AVSS_n81 17.0005
R1512 AVSS_n694 AVSS_n84 17.0005
R1513 AVSS_n694 AVSS_n82 17.0005
R1514 AVSS_n754 AVSS_n31 17.0005
R1515 AVSS_n754 AVSS_n43 17.0005
R1516 AVSS_n754 AVSS_n32 17.0005
R1517 AVSS_n754 AVSS_n42 17.0005
R1518 AVSS_n754 AVSS_n33 17.0005
R1519 AVSS_n754 AVSS_n41 17.0005
R1520 AVSS_n754 AVSS_n34 17.0005
R1521 AVSS_n754 AVSS_n40 17.0005
R1522 AVSS_n754 AVSS_n35 17.0005
R1523 AVSS_n754 AVSS_n39 17.0005
R1524 AVSS_n754 AVSS_n36 17.0005
R1525 AVSS_n28 AVSS_n27 17.0005
R1526 AVSS_n58 AVSS_n31 17.0005
R1527 AVSS_n58 AVSS_n43 17.0005
R1528 AVSS_n58 AVSS_n32 17.0005
R1529 AVSS_n58 AVSS_n42 17.0005
R1530 AVSS_n58 AVSS_n33 17.0005
R1531 AVSS_n58 AVSS_n41 17.0005
R1532 AVSS_n58 AVSS_n34 17.0005
R1533 AVSS_n58 AVSS_n40 17.0005
R1534 AVSS_n58 AVSS_n35 17.0005
R1535 AVSS_n58 AVSS_n39 17.0005
R1536 AVSS_n58 AVSS_n36 17.0005
R1537 AVSS_n444 AVSS_n23 17.0005
R1538 AVSS_n446 AVSS_n23 17.0005
R1539 AVSS_n448 AVSS_n23 17.0005
R1540 AVSS_n450 AVSS_n23 17.0005
R1541 AVSS_n452 AVSS_n23 17.0005
R1542 AVSS_n454 AVSS_n23 17.0005
R1543 AVSS_n456 AVSS_n23 17.0005
R1544 AVSS_n458 AVSS_n23 17.0005
R1545 AVSS_n460 AVSS_n23 17.0005
R1546 AVSS_n461 AVSS_n23 17.0005
R1547 AVSS_n463 AVSS_n23 17.0005
R1548 AVSS_n465 AVSS_n23 17.0005
R1549 AVSS_n468 AVSS_n23 17.0005
R1550 AVSS_n436 AVSS_n23 17.0005
R1551 AVSS_n437 AVSS_n23 17.0005
R1552 AVSS_n432 AVSS_n23 17.0005
R1553 AVSS_n433 AVSS_n23 17.0005
R1554 AVSS_n434 AVSS_n23 17.0005
R1555 AVSS_n429 AVSS_n23 17.0005
R1556 AVSS_n430 AVSS_n23 17.0005
R1557 AVSS_n426 AVSS_n23 17.0005
R1558 AVSS_n440 AVSS_n18 17.0005
R1559 AVSS_n461 AVSS_n18 17.0005
R1560 AVSS_n468 AVSS_n18 17.0005
R1561 AVSS_n436 AVSS_n18 17.0005
R1562 AVSS_n437 AVSS_n18 17.0005
R1563 AVSS_n432 AVSS_n18 17.0005
R1564 AVSS_n433 AVSS_n18 17.0005
R1565 AVSS_n434 AVSS_n18 17.0005
R1566 AVSS_n429 AVSS_n18 17.0005
R1567 AVSS_n430 AVSS_n18 17.0005
R1568 AVSS_n426 AVSS_n18 17.0005
R1569 AVSS_n777 AVSS_n776 17.0005
R1570 AVSS_n781 AVSS_n780 17.0005
R1571 AVSS_n785 AVSS_n784 17.0005
R1572 AVSS_n789 AVSS_n788 17.0005
R1573 AVSS_n793 AVSS_n792 17.0005
R1574 AVSS_n806 AVSS_n2 17.0005
R1575 AVSS_n390 AVSS_t42 15.8477
R1576 AVSS_n517 AVSS_t2 15.182
R1577 AVSS_n645 AVSS_n632 14.6287
R1578 AVSS_n648 AVSS_n198 14.6287
R1579 AVSS_n197 AVSS_n196 14.6287
R1580 AVSS_n217 AVSS_n195 14.6287
R1581 AVSS_n808 AVSS_n0 14.0432
R1582 AVSS_n776 AVSS_n6 13.22
R1583 AVSS_n216 AVSS_t48 12.8002
R1584 AVSS_n779 AVSS_n7 12.4165
R1585 AVSS_n525 AVSS_n524 12.1907
R1586 AVSS_n523 AVSS_n522 12.1907
R1587 AVSS_n407 AVSS_t38 12.1907
R1588 AVSS_n215 AVSS_n200 10.9717
R1589 AVSS_n259 AVSS_n213 10.9717
R1590 AVSS_n258 AVSS_n211 10.9717
R1591 AVSS_n257 AVSS_n256 10.9717
R1592 AVSS_n235 AVSS_n179 10.9717
R1593 AVSS_t52 AVSS_n156 10.9717
R1594 AVSS_n520 AVSS_t34 10.9717
R1595 AVSS_t34 AVSS_n152 10.9717
R1596 AVSS_n396 AVSS_n86 10.9717
R1597 AVSS_n395 AVSS_n79 10.9717
R1598 AVSS_n394 AVSS_n87 10.9717
R1599 AVSS_n393 AVSS_n77 10.9717
R1600 AVSS_n392 AVSS_n88 10.9717
R1601 AVSS_n98 AVSS_n76 10.9717
R1602 AVSS_n696 AVSS_n90 10.9717
R1603 AVSS_n258 AVSS_n193 9.75263
R1604 AVSS_n257 AVSS_n192 9.75263
R1605 AVSS_n243 AVSS_n191 9.75263
R1606 AVSS_n242 AVSS_n241 9.75263
R1607 AVSS_n240 AVSS_n199 9.75263
R1608 AVSS_n542 AVSS_n357 9.75263
R1609 AVSS_n542 AVSS_n160 9.75263
R1610 AVSS_n365 AVSS_n358 9.75263
R1611 AVSS_n365 AVSS_n159 9.75263
R1612 AVSS_n366 AVSS_n359 9.75263
R1613 AVSS_n366 AVSS_n158 9.75263
R1614 AVSS_n367 AVSS_n360 9.75263
R1615 AVSS_n367 AVSS_n157 9.75263
R1616 AVSS_n368 AVSS_n361 9.75263
R1617 AVSS_n368 AVSS_n156 9.75263
R1618 AVSS_n524 AVSS_n155 9.75263
R1619 AVSS_n200 AVSS_n194 9.33995
R1620 AVSS_n408 AVSS_n390 9.33995
R1621 AVSS_n503 AVSS_n379 9.33995
R1622 AVSS_t40 AVSS_n385 9.33995
R1623 AVSS_n407 AVSS_n397 9.33995
R1624 AVSS_n442 AVSS_n441 9.33995
R1625 AVSS_n443 AVSS_n442 9.33995
R1626 AVSS_n447 AVSS_n446 9.33995
R1627 AVSS_n451 AVSS_n450 9.33995
R1628 AVSS_n455 AVSS_n454 9.33995
R1629 AVSS_n459 AVSS_n458 9.33995
R1630 AVSS_n465 AVSS_n464 9.33995
R1631 AVSS_n201 AVSS_n194 9.33995
R1632 AVSS_n406 AVSS_n397 9.33995
R1633 AVSS_n391 AVSS_n90 9.33995
R1634 AVSS_n404 AVSS_n385 9.33995
R1635 AVSS_n379 AVSS_n44 9.33995
R1636 AVSS_n464 AVSS_n463 9.33995
R1637 AVSS_n460 AVSS_n459 9.33995
R1638 AVSS_n456 AVSS_n455 9.33995
R1639 AVSS_n452 AVSS_n451 9.33995
R1640 AVSS_n448 AVSS_n447 9.33995
R1641 AVSS_n444 AVSS_n443 9.33995
R1642 AVSS_n441 AVSS_n440 9.33995
R1643 AVSS_n628 AVSS_t49 9.12784
R1644 AVSS_n311 AVSS_t45 9.12784
R1645 AVSS_n775 AVSS_t10 8.75631
R1646 AVSS_n774 AVSS_t31 8.75631
R1647 AVSS_n773 AVSS_t20 8.75631
R1648 AVSS_n772 AVSS_t23 8.75631
R1649 AVSS_n771 AVSS_t26 8.75631
R1650 AVSS_n1 AVSS_t17 8.75631
R1651 AVSS_n525 AVSS_t52 8.53362
R1652 AVSS_n433 AVSS_t35 8.53362
R1653 AVSS_n645 AVSS_n189 8.501
R1654 AVSS_n645 AVSS_n633 8.501
R1655 AVSS_n645 AVSS_n644 8.501
R1656 AVSS_n645 AVSS_n634 8.501
R1657 AVSS_n645 AVSS_n204 8.501
R1658 AVSS_n242 AVSS_n190 8.501
R1659 AVSS_n661 AVSS_n181 8.501
R1660 AVSS_n661 AVSS_n183 8.501
R1661 AVSS_n558 AVSS_n527 8.501
R1662 AVSS_n558 AVSS_n557 8.501
R1663 AVSS_n558 AVSS_n528 8.501
R1664 AVSS_n562 AVSS_n364 8.501
R1665 AVSS_n562 AVSS_n372 8.501
R1666 AVSS_n562 AVSS_n363 8.501
R1667 AVSS_n402 AVSS_n133 8.501
R1668 AVSS_n508 AVSS_n133 8.501
R1669 AVSS_n506 AVSS_n133 8.501
R1670 AVSS_n504 AVSS_n503 8.501
R1671 AVSS_n503 AVSS_n502 8.501
R1672 AVSS_n503 AVSS_n496 8.501
R1673 AVSS_n503 AVSS_n378 8.501
R1674 AVSS_n632 AVSS_n208 8.501
R1675 AVSS_n632 AVSS_n207 8.501
R1676 AVSS_n256 AVSS_n255 8.501
R1677 AVSS_n256 AVSS_n245 8.501
R1678 AVSS_n256 AVSS_n244 8.501
R1679 AVSS_n307 AVSS_n306 8.501
R1680 AVSS_n321 AVSS_n320 8.501
R1681 AVSS_n320 AVSS_n319 8.501
R1682 AVSS_n320 AVSS_n295 8.501
R1683 AVSS_n320 AVSS_n294 8.501
R1684 AVSS_n320 AVSS_n293 8.501
R1685 AVSS_n306 AVSS_n298 8.501
R1686 AVSS_n306 AVSS_n305 8.501
R1687 AVSS_n587 AVSS_n333 8.501
R1688 AVSS_n587 AVSS_n331 8.501
R1689 AVSS_n573 AVSS_n336 8.501
R1690 AVSS_n573 AVSS_n572 8.501
R1691 AVSS_n573 AVSS_n566 8.501
R1692 AVSS_n542 AVSS_n539 8.501
R1693 AVSS_n262 AVSS_n200 8.501
R1694 AVSS_n610 AVSS_n200 8.501
R1695 AVSS_n608 AVSS_n200 8.501
R1696 AVSS_n598 AVSS_n266 8.501
R1697 AVSS_n598 AVSS_n592 8.501
R1698 AVSS_n349 AVSS_n343 8.501
R1699 AVSS_n344 AVSS_n343 8.501
R1700 AVSS_n428 AVSS_n412 8.501
R1701 AVSS_n484 AVSS_n483 8.501
R1702 AVSS_n483 AVSS_n467 8.501
R1703 AVSS_n483 AVSS_n466 8.501
R1704 AVSS_n697 AVSS_n696 8.501
R1705 AVSS_n692 AVSS_n134 8.501
R1706 AVSS_n692 AVSS_n691 8.501
R1707 AVSS_n692 AVSS_n144 8.501
R1708 AVSS_n692 AVSS_n142 8.501
R1709 AVSS_n692 AVSS_n141 8.501
R1710 AVSS_n692 AVSS_n140 8.501
R1711 AVSS_n692 AVSS_n138 8.501
R1712 AVSS_n692 AVSS_n137 8.501
R1713 AVSS_n696 AVSS_n97 8.501
R1714 AVSS_n696 AVSS_n96 8.501
R1715 AVSS_n696 AVSS_n99 8.501
R1716 AVSS_n696 AVSS_n95 8.501
R1717 AVSS_n696 AVSS_n94 8.501
R1718 AVSS_n696 AVSS_n101 8.501
R1719 AVSS_n696 AVSS_n102 8.501
R1720 AVSS_n696 AVSS_n93 8.501
R1721 AVSS_n696 AVSS_n92 8.501
R1722 AVSS_n696 AVSS_n91 8.501
R1723 AVSS_n753 AVSS_n752 8.501
R1724 AVSS_n724 AVSS_n37 8.501
R1725 AVSS_n724 AVSS_n60 8.501
R1726 AVSS_n724 AVSS_n63 8.501
R1727 AVSS_n724 AVSS_n72 8.501
R1728 AVSS_n724 AVSS_n64 8.501
R1729 AVSS_n724 AVSS_n66 8.501
R1730 AVSS_n724 AVSS_n70 8.501
R1731 AVSS_n724 AVSS_n69 8.501
R1732 AVSS_n724 AVSS_n68 8.501
R1733 AVSS_n752 AVSS_n52 8.501
R1734 AVSS_n752 AVSS_n50 8.501
R1735 AVSS_n752 AVSS_n49 8.501
R1736 AVSS_n752 AVSS_n55 8.501
R1737 AVSS_n752 AVSS_n48 8.501
R1738 AVSS_n752 AVSS_n47 8.501
R1739 AVSS_n752 AVSS_n56 8.501
R1740 AVSS_n752 AVSS_n57 8.501
R1741 AVSS_n495 AVSS_n416 8.501
R1742 AVSS_n495 AVSS_n414 8.501
R1743 AVSS_n495 AVSS_n415 8.501
R1744 AVSS_n770 AVSS_n14 8.501
R1745 AVSS_n770 AVSS_n17 8.501
R1746 AVSS_n770 AVSS_n13 8.501
R1747 AVSS_n371 AVSS_n153 8.5005
R1748 AVSS_n522 AVSS_n371 8.5005
R1749 AVSS_n524 AVSS_n371 8.5005
R1750 AVSS_n371 AVSS_n368 8.5005
R1751 AVSS_n371 AVSS_n367 8.5005
R1752 AVSS_n371 AVSS_n366 8.5005
R1753 AVSS_n371 AVSS_n365 8.5005
R1754 AVSS_n564 AVSS_n152 8.5005
R1755 AVSS_n564 AVSS_n153 8.5005
R1756 AVSS_n564 AVSS_n154 8.5005
R1757 AVSS_n564 AVSS_n155 8.5005
R1758 AVSS_n564 AVSS_n361 8.5005
R1759 AVSS_n564 AVSS_n360 8.5005
R1760 AVSS_n564 AVSS_n359 8.5005
R1761 AVSS_n564 AVSS_n358 8.5005
R1762 AVSS_n564 AVSS_n357 8.5005
R1763 AVSS_n564 AVSS_n356 8.5005
R1764 AVSS_n565 AVSS_n564 8.5005
R1765 AVSS_n442 AVSS_n26 8.5005
R1766 AVSS_n460 AVSS_n26 8.5005
R1767 AVSS_n465 AVSS_n26 8.5005
R1768 AVSS_n468 AVSS_n26 8.5005
R1769 AVSS_n436 AVSS_n26 8.5005
R1770 AVSS_n437 AVSS_n26 8.5005
R1771 AVSS_n432 AVSS_n26 8.5005
R1772 AVSS_n433 AVSS_n26 8.5005
R1773 AVSS_n434 AVSS_n26 8.5005
R1774 AVSS_n429 AVSS_n26 8.5005
R1775 AVSS_n430 AVSS_n26 8.5005
R1776 AVSS_n426 AVSS_n26 8.5005
R1777 AVSS_n636 AVSS_n635 8.48766
R1778 AVSS_n514 AVSS_n375 8.48362
R1779 AVSS_n325 AVSS_n324 8.48362
R1780 AVSS_n589 AVSS_n329 8.48362
R1781 AVSS_n616 AVSS_n222 8.48362
R1782 AVSS_n564 AVSS_n355 8.48362
R1783 AVSS_n763 AVSS_n23 8.48362
R1784 AVSS_n778 AVSS_n777 8.47111
R1785 AVSS_n782 AVSS_n781 8.47111
R1786 AVSS_n786 AVSS_n785 8.47111
R1787 AVSS_n790 AVSS_n789 8.47111
R1788 AVSS_n794 AVSS_n793 8.47111
R1789 AVSS_n807 AVSS_n806 8.47111
R1790 AVSS_n641 AVSS_n203 8.46995
R1791 AVSS_n643 AVSS_n642 8.46995
R1792 AVSS_n638 AVSS_n637 8.46995
R1793 AVSS_n655 AVSS_n180 8.46995
R1794 AVSS_n657 AVSS_n653 8.46995
R1795 AVSS_n554 AVSS_n526 8.46995
R1796 AVSS_n551 AVSS_n529 8.46995
R1797 AVSS_n534 AVSS_n533 8.46995
R1798 AVSS_n530 AVSS_n373 8.46995
R1799 AVSS_n512 AVSS_n511 8.46995
R1800 AVSS_n507 AVSS_n403 8.46995
R1801 AVSS_n499 AVSS_n411 8.46995
R1802 AVSS_n498 AVSS_n497 8.46995
R1803 AVSS_n627 AVSS_n209 8.46995
R1804 AVSS_n626 AVSS_n625 8.46995
R1805 AVSS_n254 AVSS_n253 8.46995
R1806 AVSS_n252 AVSS_n247 8.46995
R1807 AVSS_n251 AVSS_n250 8.46995
R1808 AVSS_n323 AVSS_n322 8.46995
R1809 AVSS_n292 AVSS_n291 8.46995
R1810 AVSS_n316 AVSS_n315 8.46995
R1811 AVSS_n314 AVSS_n313 8.46995
R1812 AVSS_n309 AVSS_n308 8.46995
R1813 AVSS_n300 AVSS_n297 8.46995
R1814 AVSS_n582 AVSS_n330 8.46995
R1815 AVSS_n580 AVSS_n334 8.46995
R1816 AVSS_n576 AVSS_n575 8.46995
R1817 AVSS_n567 AVSS_n335 8.46995
R1818 AVSS_n571 AVSS_n570 8.46995
R1819 AVSS_n569 AVSS_n568 8.46995
R1820 AVSS_n545 AVSS_n544 8.46995
R1821 AVSS_n609 AVSS_n261 8.46995
R1822 AVSS_n607 AVSS_n606 8.46995
R1823 AVSS_n601 AVSS_n600 8.46995
R1824 AVSS_n591 AVSS_n265 8.46995
R1825 AVSS_n594 AVSS_n593 8.46995
R1826 AVSS_n350 AVSS_n342 8.46995
R1827 AVSS_n348 AVSS_n347 8.46995
R1828 AVSS_n346 AVSS_n345 8.46995
R1829 AVSS_n476 AVSS_n422 8.46995
R1830 AVSS_n439 AVSS_n421 8.46995
R1831 AVSS_n474 AVSS_n469 8.46995
R1832 AVSS_n688 AVSS_n132 8.46995
R1833 AVSS_n690 AVSS_n689 8.46995
R1834 AVSS_n687 AVSS_n145 8.46995
R1835 AVSS_n682 AVSS_n681 8.46995
R1836 AVSS_n676 AVSS_n675 8.46995
R1837 AVSS_n672 AVSS_n671 8.46995
R1838 AVSS_n670 AVSS_n669 8.46995
R1839 AVSS_n89 AVSS_n74 8.46995
R1840 AVSS_n118 AVSS_n117 8.46995
R1841 AVSS_n119 AVSS_n116 8.46995
R1842 AVSS_n120 AVSS_n115 8.46995
R1843 AVSS_n121 AVSS_n114 8.46995
R1844 AVSS_n123 AVSS_n112 8.46995
R1845 AVSS_n126 AVSS_n109 8.46995
R1846 AVSS_n127 AVSS_n108 8.46995
R1847 AVSS_n128 AVSS_n107 8.46995
R1848 AVSS_n130 AVSS_n105 8.46995
R1849 AVSS_n727 AVSS_n726 8.46995
R1850 AVSS_n62 AVSS_n59 8.46995
R1851 AVSS_n720 AVSS_n73 8.46995
R1852 AVSS_n719 AVSS_n718 8.46995
R1853 AVSS_n713 AVSS_n712 8.46995
R1854 AVSS_n711 AVSS_n710 8.46995
R1855 AVSS_n709 AVSS_n708 8.46995
R1856 AVSS_n705 AVSS_n704 8.46995
R1857 AVSS_n703 AVSS_n702 8.46995
R1858 AVSS_n756 AVSS_n29 8.46995
R1859 AVSS_n757 AVSS_n28 8.46995
R1860 AVSS_n740 AVSS_n737 8.46995
R1861 AVSS_n741 AVSS_n736 8.46995
R1862 AVSS_n742 AVSS_n735 8.46995
R1863 AVSS_n743 AVSS_n734 8.46995
R1864 AVSS_n744 AVSS_n733 8.46995
R1865 AVSS_n746 AVSS_n731 8.46995
R1866 AVSS_n747 AVSS_n730 8.46995
R1867 AVSS_n490 AVSS_n420 8.46995
R1868 AVSS_n491 AVSS_n419 8.46995
R1869 AVSS_n418 AVSS_n417 8.46995
R1870 AVSS_n764 AVSS_n22 8.46995
R1871 AVSS_n765 AVSS_n21 8.46995
R1872 AVSS_n766 AVSS_n20 8.46995
R1873 AVSS_n680 AVSS_n679 8.4654
R1874 AVSS_n124 AVSS_n111 8.4654
R1875 AVSS_n556 AVSS_n555 8.45541
R1876 AVSS_n532 AVSS_n531 8.45541
R1877 AVSS_n510 AVSS_n509 8.45541
R1878 AVSS_n501 AVSS_n500 8.45541
R1879 AVSS_n473 AVSS_n472 8.45541
R1880 AVSS_n640 AVSS_n639 8.44274
R1881 AVSS_n318 AVSS_n317 8.44274
R1882 AVSS_n612 AVSS_n611 8.44274
R1883 AVSS_n563 AVSS_n149 6.87449
R1884 AVSS_n440 AVSS_n16 6.87449
R1885 AVSS_n661 AVSS_t44 6.70509
R1886 AVSS_n787 AVSS_n786 6.55454
R1887 AVSS_n661 AVSS_n184 6.09558
R1888 AVSS_n598 AVSS_n590 6.09558
R1889 AVSS_n692 AVSS_n133 6.09558
R1890 AVSS_n401 AVSS_n82 6.09558
R1891 AVSS_n400 AVSS_n84 6.09558
R1892 AVSS_n399 AVSS_n81 6.09558
R1893 AVSS_n398 AVSS_n85 6.09558
R1894 AVSS_n406 AVSS_n80 6.09558
R1895 AVSS_n370 AVSS_n150 6.02866
R1896 AVSS_n369 AVSS_n152 6.02866
R1897 AVSS_n362 AVSS_n150 6.02866
R1898 AVSS_n445 AVSS_n444 6.02866
R1899 AVSS_n449 AVSS_n448 6.02866
R1900 AVSS_n453 AVSS_n452 6.02866
R1901 AVSS_n457 AVSS_n456 6.02866
R1902 AVSS_n463 AVSS_n462 6.02866
R1903 AVSS_n369 AVSS_n151 6.02866
R1904 AVSS_n362 AVSS_n151 6.02866
R1905 AVSS_n370 AVSS_n149 6.02866
R1906 AVSS_n462 AVSS_n461 6.02866
R1907 AVSS_n458 AVSS_n457 6.02866
R1908 AVSS_n454 AVSS_n453 6.02866
R1909 AVSS_n450 AVSS_n449 6.02866
R1910 AVSS_n446 AVSS_n445 6.02866
R1911 AVSS_n661 AVSS_n660 5.66778
R1912 AVSS_n661 AVSS_n182 5.66778
R1913 AVSS_n256 AVSS_n246 5.66778
R1914 AVSS_n632 AVSS_n206 5.66778
R1915 AVSS_n632 AVSS_n205 5.66778
R1916 AVSS_n306 AVSS_n299 5.66778
R1917 AVSS_n587 AVSS_n332 5.66778
R1918 AVSS_n587 AVSS_n586 5.66778
R1919 AVSS_n574 AVSS_n573 5.66778
R1920 AVSS_n542 AVSS_n541 5.66778
R1921 AVSS_n260 AVSS_n200 5.66778
R1922 AVSS_n599 AVSS_n598 5.66778
R1923 AVSS_n598 AVSS_n597 5.66778
R1924 AVSS_n343 AVSS_n338 5.66778
R1925 AVSS_n351 AVSS_n343 5.66778
R1926 AVSS_n477 AVSS_n412 5.66778
R1927 AVSS_n692 AVSS_n83 5.66778
R1928 AVSS_n692 AVSS_n135 5.66778
R1929 AVSS_n692 AVSS_n143 5.66778
R1930 AVSS_n692 AVSS_n136 5.66778
R1931 AVSS_n692 AVSS_n139 5.66778
R1932 AVSS_n696 AVSS_n100 5.66778
R1933 AVSS_n696 AVSS_n103 5.66778
R1934 AVSS_n696 AVSS_n104 5.66778
R1935 AVSS_n724 AVSS_n723 5.66778
R1936 AVSS_n724 AVSS_n65 5.66778
R1937 AVSS_n724 AVSS_n71 5.66778
R1938 AVSS_n724 AVSS_n67 5.66778
R1939 AVSS_n752 AVSS_n54 5.66778
R1940 AVSS_n752 AVSS_n51 5.66778
R1941 AVSS_n752 AVSS_n46 5.66778
R1942 AVSS_n752 AVSS_n45 5.66778
R1943 AVSS_n495 AVSS_n494 5.66778
R1944 AVSS_n770 AVSS_n15 5.66778
R1945 AVSS_n646 AVSS_n645 5.66767
R1946 AVSS_n662 AVSS_n661 5.66767
R1947 AVSS_n559 AVSS_n558 5.66767
R1948 AVSS_n562 AVSS_n561 5.66767
R1949 AVSS_n513 AVSS_n133 5.66767
R1950 AVSS_n632 AVSS_n631 5.66767
R1951 AVSS_n320 AVSS_n290 5.66767
R1952 AVSS_n588 AVSS_n587 5.66767
R1953 AVSS_n598 AVSS_n223 5.66767
R1954 AVSS_n343 AVSS_n341 5.66767
R1955 AVSS_n483 AVSS_n482 5.66767
R1956 AVSS_n696 AVSS_n695 5.66767
R1957 AVSS_n693 AVSS_n692 5.66767
R1958 AVSS_n777 AVSS_n5 5.66717
R1959 AVSS_n781 AVSS_n4 5.66717
R1960 AVSS_n785 AVSS_n9 5.66717
R1961 AVSS_n789 AVSS_n3 5.66717
R1962 AVSS_n793 AVSS_n11 5.66717
R1963 AVSS_n806 AVSS_n805 5.66717
R1964 AVSS_n589 AVSS_n269 5.62486
R1965 AVSS_n616 AVSS_n220 5.62486
R1966 AVSS_n481 AVSS_n470 5.62486
R1967 AVSS_n656 AVSS_n654 5.61281
R1968 AVSS_n659 AVSS_n658 5.61281
R1969 AVSS_n622 AVSS_n621 5.61281
R1970 AVSS_n249 AVSS_n248 5.61281
R1971 AVSS_n302 AVSS_n301 5.61281
R1972 AVSS_n583 AVSS_n581 5.61281
R1973 AVSS_n585 AVSS_n584 5.61281
R1974 AVSS_n540 AVSS_n538 5.61281
R1975 AVSS_n614 AVSS_n613 5.61281
R1976 AVSS_n596 AVSS_n595 5.61281
R1977 AVSS_n353 AVSS_n352 5.61281
R1978 AVSS_n699 AVSS_n698 5.61281
R1979 AVSS_n686 AVSS_n685 5.61281
R1980 AVSS_n684 AVSS_n683 5.61281
R1981 AVSS_n678 AVSS_n677 5.61281
R1982 AVSS_n674 AVSS_n673 5.61281
R1983 AVSS_n668 AVSS_n667 5.61281
R1984 AVSS_n122 AVSS_n113 5.61281
R1985 AVSS_n125 AVSS_n110 5.61281
R1986 AVSS_n129 AVSS_n106 5.61281
R1987 AVSS_n754 AVSS_n38 5.61281
R1988 AVSS_n722 AVSS_n721 5.61281
R1989 AVSS_n717 AVSS_n716 5.61281
R1990 AVSS_n715 AVSS_n714 5.61281
R1991 AVSS_n707 AVSS_n706 5.61281
R1992 AVSS_n739 AVSS_n738 5.61281
R1993 AVSS_n745 AVSS_n732 5.61281
R1994 AVSS_n748 AVSS_n729 5.61281
R1995 AVSS_n750 AVSS_n749 5.61281
R1996 AVSS_n493 AVSS_n492 5.61281
R1997 AVSS_n768 AVSS_n767 5.61281
R1998 AVSS_n479 AVSS_n478 5.60001
R1999 AVSS_n624 AVSS_n623 5.58885
R2000 AVSS_n304 AVSS_n303 5.58885
R2001 AVSS_n801 AVSS_n800 5.16006
R2002 AVSS_t27 AVSS_n215 4.87657
R2003 AVSS_n320 AVSS_n240 4.87657
R2004 AVSS_n289 AVSS_n239 4.87657
R2005 AVSS_n288 AVSS_n238 4.87657
R2006 AVSS_n287 AVSS_n237 4.87657
R2007 AVSS_n236 AVSS_n184 4.87657
R2008 AVSS_n286 AVSS_t46 4.87657
R2009 AVSS_n522 AVSS_t32 4.87657
R2010 AVSS_t32 AVSS_n154 4.87657
R2011 AVSS_n256 AVSS_n212 4.25119
R2012 AVSS_n306 AVSS_n283 4.25119
R2013 AVSS_n752 AVSS_n751 4.25119
R2014 AVSS_n770 AVSS_n769 4.25119
R2015 AVSS_n573 AVSS_n268 4.251
R2016 AVSS_n543 AVSS_n542 4.251
R2017 AVSS_n615 AVSS_n200 4.251
R2018 AVSS_n480 AVSS_n412 4.251
R2019 AVSS_n725 AVSS_n724 4.251
R2020 AVSS_n495 AVSS_n413 4.251
R2021 AVSS_n310 AVSS_n296 4.17435
R2022 AVSS_n630 AVSS_n214 4.17416
R2023 AVSS_n578 AVSS_t51 4.02854
R2024 AVSS_n649 AVSS_n194 3.83153
R2025 AVSS_n505 AVSS_n408 3.83153
R2026 AVSS_n514 AVSS_n379 3.83153
R2027 AVSS_n514 AVSS_n385 3.83153
R2028 AVSS_n514 AVSS_n391 3.83153
R2029 AVSS_n514 AVSS_n397 3.83153
R2030 AVSS_n441 AVSS_n23 3.83153
R2031 AVSS_n443 AVSS_n18 3.83153
R2032 AVSS_n447 AVSS_n18 3.83153
R2033 AVSS_n451 AVSS_n18 3.83153
R2034 AVSS_n455 AVSS_n18 3.83153
R2035 AVSS_n459 AVSS_n18 3.83153
R2036 AVSS_n464 AVSS_n18 3.83153
R2037 AVSS_n343 AVSS_n270 3.65755
R2038 AVSS_n573 AVSS_n565 3.65755
R2039 AVSS_n536 AVSS_t33 3.49206
R2040 AVSS_n219 AVSS_n218 3.31185
R2041 AVSS_n620 AVSS_n218 3.30365
R2042 AVSS_n312 AVSS_n296 3.30365
R2043 AVSS_n664 AVSS_n663 3.3033
R2044 AVSS_n783 AVSS_n782 2.73454
R2045 AVSS_n647 AVSS_n202 2.7239
R2046 AVSS_n630 AVSS_n629 2.7239
R2047 AVSS_n579 AVSS_n267 2.71714
R2048 AVSS_n30 AVSS_t41 2.60572
R2049 AVSS_n75 AVSS_t39 2.60548
R2050 AVSS_n339 AVSS_t53 2.60106
R2051 AVSS_n558 AVSS_n361 2.43853
R2052 AVSS_n426 AVSS_n412 2.43853
R2053 AVSS_n430 AVSS_n427 2.43853
R2054 AVSS_n431 AVSS_n429 2.43853
R2055 AVSS_n434 AVSS_n425 2.43853
R2056 AVSS_n435 AVSS_n433 2.43853
R2057 AVSS_n666 AVSS_n665 2.38612
R2058 AVSS_n577 AVSS_n267 2.29924
R2059 AVSS_n537 AVSS_n371 2.29333
R2060 AVSS_n326 AVSS_n325 1.95372
R2061 AVSS_n562 AVSS_n371 1.88939
R2062 AVSS_n603 AVSS_t47 1.85823
R2063 AVSS_t48 AVSS_n201 1.82903
R2064 AVSS_n564 AVSS_n340 1.72277
R2065 AVSS_n481 AVSS_n475 1.70774
R2066 AVSS_n550 AVSS_n549 1.70393
R2067 AVSS_n486 AVSS_n485 1.70393
R2068 AVSS_n186 AVSS_t37 1.62511
R2069 AVSS_n589 AVSS_n271 1.50681
R2070 AVSS_n650 AVSS_n649 1.50314
R2071 AVSS_n560 AVSS_n519 1.50251
R2072 AVSS_n755 AVSS_n754 1.49316
R2073 AVSS_n698 AVSS_n78 1.4906
R2074 AVSS_n655 AVSS_n146 1.46583
R2075 AVSS_n354 AVSS_n337 1.39582
R2076 AVSS_n760 AVSS_n759 1.38941
R2077 AVSS_n761 AVSS_n25 1.37908
R2078 AVSS_n791 AVSS_n790 1.37204
R2079 AVSS_n409 AVSS_t43 1.36049
R2080 AVSS_n339 AVSS_n337 1.34601
R2081 AVSS_n516 AVSS_n515 1.33808
R2082 AVSS_n665 AVSS_n146 1.32108
R2083 AVSS_n562 AVSS_n148 1.30869
R2084 AVSS_n647 AVSS_n199 1.30819
R2085 AVSS_n495 AVSS_n26 1.30819
R2086 AVSS_n759 AVSS_n25 1.29917
R2087 AVSS_n761 AVSS_n760 1.29233
R2088 AVSS_n795 AVSS_n794 1.26704
R2089 AVSS_n553 AVSS_n552 1.25862
R2090 AVSS_n371 AVSS_n370 1.23717
R2091 AVSS_n371 AVSS_n369 1.23717
R2092 AVSS_n564 AVSS_n362 1.23717
R2093 AVSS_n445 AVSS_n26 1.23717
R2094 AVSS_n449 AVSS_n26 1.23717
R2095 AVSS_n453 AVSS_n26 1.23717
R2096 AVSS_n457 AVSS_n26 1.23717
R2097 AVSS_n462 AVSS_n26 1.23717
R2098 AVSS_n418 AVSS_n24 1.23269
R2099 AVSS_n779 AVSS_n778 1.22579
R2100 AVSS_n285 AVSS_n234 1.21952
R2101 AVSS_n284 AVSS_n233 1.21952
R2102 AVSS_n306 AVSS_n232 1.21952
R2103 AVSS_n587 AVSS_n229 1.21952
R2104 AVSS_n279 AVSS_n228 1.21952
R2105 AVSS_n278 AVSS_n227 1.21952
R2106 AVSS_n277 AVSS_n226 1.21952
R2107 AVSS_n276 AVSS_n225 1.21952
R2108 AVSS_n275 AVSS_n224 1.21952
R2109 AVSS_n762 AVSS_n24 1.21636
R2110 AVSS_n515 AVSS_n376 1.20474
R2111 AVSS_n489 AVSS_n18 1.20367
R2112 AVSS_n664 AVSS_n147 1.20123
R2113 AVSS_n604 AVSS_n264 1.19852
R2114 AVSS_n618 AVSS_n617 1.16524
R2115 AVSS_n617 AVSS_n221 1.15986
R2116 AVSS_n602 AVSS_n264 1.07833
R2117 AVSS_n535 AVSS_n371 1.07523
R2118 AVSS_n563 AVSS_n562 1.05846
R2119 AVSS_n770 AVSS_n16 1.05846
R2120 AVSS_n749 AVSS_n728 1.04247
R2121 AVSS_n767 AVSS_n19 1.02546
R2122 AVSS AVSS_n808 1.00986
R2123 AVSS_n728 AVSS_n727 0.989816
R2124 AVSS_n409 AVSS_n405 0.976171
R2125 AVSS_n263 AVSS_n188 0.965107
R2126 AVSS_n186 AVSS_n147 0.962068
R2127 AVSS_n488 AVSS_n19 0.94822
R2128 AVSS_n405 AVSS_n403 0.947416
R2129 AVSS_n688 AVSS_n131 0.946957
R2130 AVSS_n131 AVSS_n130 0.938939
R2131 AVSS_n546 AVSS_n545 0.92376
R2132 AVSS_n499 AVSS_n410 0.893699
R2133 AVSS_n505 AVSS_n410 0.880723
R2134 AVSS_n187 AVSS_n186 0.879004
R2135 AVSS_n651 AVSS_n188 0.87872
R2136 AVSS_n546 AVSS_n371 0.8746
R2137 AVSS_n694 AVSS_n131 0.86135
R2138 AVSS_n602 AVSS_n601 0.817386
R2139 AVSS_n652 AVSS_n187 0.815143
R2140 AVSS_n187 AVSS_n185 0.794361
R2141 AVSS_n505 AVSS_n405 0.794361
R2142 AVSS_n603 AVSS_n602 0.787178
R2143 AVSS_n19 AVSS_n18 0.783195
R2144 AVSS_n728 AVSS_n58 0.781759
R2145 AVSS_n490 AVSS_n489 0.779095
R2146 AVSS_n547 AVSS_n546 0.775399
R2147 AVSS_n547 AVSS_n535 0.761552
R2148 AVSS_n536 AVSS_n535 0.745448
R2149 AVSS_n604 AVSS_n603 0.734127
R2150 AVSS_n554 AVSS_n519 0.693252
R2151 AVSS_n651 AVSS_n650 0.6911
R2152 AVSS_n410 AVSS_n409 0.690398
R2153 AVSS_n756 AVSS_n755 0.688074
R2154 AVSS_n489 AVSS_n488 0.6825
R2155 AVSS_n328 AVSS_n271 0.665037
R2156 AVSS_n552 AVSS_n271 0.663686
R2157 AVSS_n185 AVSS_n147 0.656278
R2158 AVSS_n647 AVSS_n188 0.647014
R2159 AVSS_n475 AVSS_n474 0.642496
R2160 AVSS_n551 AVSS_n550 0.63611
R2161 AVSS_n486 AVSS_n422 0.63611
R2162 AVSS_n605 AVSS_n604 0.634703
R2163 AVSS_n780 AVSS_n779 0.63175
R2164 AVSS_n475 AVSS_n471 0.628252
R2165 AVSS_n346 AVSS_n340 0.619337
R2166 AVSS_n784 AVSS_n783 0.61425
R2167 AVSS_n272 AVSS_t36 0.610008
R2168 AVSS_n755 AVSS_n30 0.606355
R2169 AVSS_n517 AVSS_n516 0.601833
R2170 AVSS_n605 AVSS_n263 0.598625
R2171 AVSS_n759 AVSS_n758 0.59175
R2172 AVSS_n78 AVSS_n75 0.591351
R2173 AVSS_n326 AVSS_n282 0.580907
R2174 AVSS_n666 AVSS_n78 0.568619
R2175 AVSS_n340 AVSS_n339 0.561704
R2176 AVSS_n652 AVSS_n651 0.5615
R2177 AVSS_n538 AVSS_n537 0.560785
R2178 AVSS_n519 AVSS_n518 0.558535
R2179 AVSS_n518 AVSS_n517 0.5505
R2180 AVSS_n488 AVSS_n487 0.529875
R2181 AVSS_n354 AVSS_n221 0.5285
R2182 AVSS_n550 AVSS_n548 0.507096
R2183 AVSS_n487 AVSS_n486 0.507096
R2184 AVSS_n577 AVSS_n576 0.506107
R2185 AVSS_n619 AVSS_n618 0.4955
R2186 AVSS_n788 AVSS_n787 0.4905
R2187 AVSS_n792 AVSS_n791 0.4905
R2188 AVSS_n795 AVSS_n2 0.4905
R2189 AVSS_n584 AVSS_n583 0.484678
R2190 AVSS_n650 AVSS_n0 0.481324
R2191 AVSS_n665 AVSS_n664 0.456304
R2192 AVSS_n327 AVSS_n326 0.455409
R2193 AVSS_n629 AVSS_n627 0.449724
R2194 AVSS_n641 AVSS_n202 0.449467
R2195 AVSS_n701 AVSS_n700 0.447833
R2196 AVSS_n617 AVSS_n616 0.445055
R2197 AVSS_n537 AVSS_n536 0.44461
R2198 AVSS_n622 AVSS_n620 0.442531
R2199 AVSS_n580 AVSS_n579 0.439966
R2200 AVSS_n578 AVSS_n577 0.4318
R2201 AVSS_n263 AVSS_n202 0.422886
R2202 AVSS_n657 AVSS_n656 0.422698
R2203 AVSS_n492 AVSS_n491 0.422358
R2204 AVSS_n595 AVSS_n265 0.422358
R2205 AVSS_n620 AVSS_n619 0.415367
R2206 AVSS_n303 AVSS_n302 0.41057
R2207 AVSS_n624 AVSS_n622 0.41057
R2208 AVSS_n717 AVSS_n715 0.393011
R2209 AVSS_n253 AVSS_n219 0.391377
R2210 AVSS_n303 AVSS_n297 0.384402
R2211 AVSS_n626 AVSS_n624 0.384402
R2212 AVSS_n314 AVSS_n312 0.380211
R2213 AVSS_n579 AVSS_n578 0.379293
R2214 AVSS_n478 AVSS_n470 0.375457
R2215 AVSS_n749 AVSS_n748 0.374678
R2216 AVSS_n686 AVSS_n684 0.374678
R2217 AVSS_n24 AVSS_n23 0.372198
R2218 AVSS_n545 AVSS_n538 0.371024
R2219 AVSS_n328 AVSS_n327 0.367167
R2220 AVSS_n613 AVSS_n612 0.367121
R2221 AVSS_n766 AVSS_n765 0.360378
R2222 AVSS_n347 AVSS_n342 0.360378
R2223 AVSS_n570 AVSS_n335 0.360378
R2224 AVSS_n252 AVSS_n251 0.360378
R2225 AVSS_n613 AVSS_n220 0.356277
R2226 AVSS_n282 AVSS_n281 0.356167
R2227 AVSS_n478 AVSS_n422 0.3512
R2228 AVSS_n311 AVSS_n310 0.350281
R2229 AVSS_n628 AVSS_n214 0.349895
R2230 AVSS_n629 AVSS_n628 0.336479
R2231 AVSS_n680 AVSS_n678 0.321453
R2232 AVSS_n125 AVSS_n124 0.321453
R2233 AVSS_n471 AVSS_n376 0.3195
R2234 AVSS_n310 AVSS_n309 0.318618
R2235 AVSS_n740 AVSS_n739 0.312698
R2236 AVSS_n746 AVSS_n745 0.312698
R2237 AVSS_n492 AVSS_n418 0.312698
R2238 AVSS_n707 AVSS_n705 0.312698
R2239 AVSS_n715 AVSS_n713 0.312698
R2240 AVSS_n721 AVSS_n720 0.312698
R2241 AVSS_n674 AVSS_n672 0.312698
R2242 AVSS_n678 AVSS_n676 0.312698
R2243 AVSS_n684 AVSS_n682 0.312698
R2244 AVSS_n123 AVSS_n122 0.312698
R2245 AVSS_n126 AVSS_n125 0.312698
R2246 AVSS_n130 AVSS_n129 0.312698
R2247 AVSS_n353 AVSS_n342 0.312698
R2248 AVSS_n595 AVSS_n594 0.312698
R2249 AVSS_n584 AVSS_n580 0.312698
R2250 AVSS_n658 AVSS_n657 0.312358
R2251 AVSS_n656 AVSS_n655 0.312358
R2252 AVSS_n745 AVSS_n744 0.312358
R2253 AVSS_n748 AVSS_n747 0.312358
R2254 AVSS_n767 AVSS_n766 0.312358
R2255 AVSS_n709 AVSS_n707 0.312358
R2256 AVSS_n719 AVSS_n717 0.312358
R2257 AVSS_n721 AVSS_n59 0.312358
R2258 AVSS_n670 AVSS_n668 0.312358
R2259 AVSS_n676 AVSS_n674 0.312358
R2260 AVSS_n687 AVSS_n686 0.312358
R2261 AVSS_n122 AVSS_n121 0.312358
R2262 AVSS_n129 AVSS_n128 0.312358
R2263 AVSS_n583 AVSS_n582 0.312358
R2264 AVSS_n251 AVSS_n249 0.312358
R2265 AVSS_n642 AVSS_n640 0.304801
R2266 AVSS_n317 AVSS_n291 0.304801
R2267 AVSS_n640 AVSS_n638 0.304801
R2268 AVSS_n612 AVSS_n261 0.304801
R2269 AVSS_n317 AVSS_n316 0.304801
R2270 AVSS_n569 AVSS_n269 0.294297
R2271 AVSS_n312 AVSS_n311 0.2852
R2272 AVSS_n355 AVSS_n353 0.285014
R2273 AVSS_n473 AVSS_n421 0.279447
R2274 AVSS_n474 AVSS_n473 0.279447
R2275 AVSS_n534 AVSS_n532 0.279447
R2276 AVSS_n532 AVSS_n530 0.279447
R2277 AVSS_n555 AVSS_n554 0.279447
R2278 AVSS_n510 AVSS_n403 0.279447
R2279 AVSS_n511 AVSS_n510 0.279447
R2280 AVSS_n500 AVSS_n499 0.279447
R2281 AVSS_n500 AVSS_n498 0.279447
R2282 AVSS_n619 AVSS_n219 0.269968
R2283 AVSS_n744 AVSS_n743 0.268711
R2284 AVSS_n762 AVSS_n761 0.2645
R2285 AVSS_n682 AVSS_n680 0.259473
R2286 AVSS_n124 AVSS_n123 0.259473
R2287 AVSS_n642 AVSS_n641 0.250378
R2288 AVSS_n757 AVSS_n756 0.250378
R2289 AVSS_n741 AVSS_n740 0.250378
R2290 AVSS_n742 AVSS_n741 0.250378
R2291 AVSS_n743 AVSS_n742 0.250378
R2292 AVSS_n747 AVSS_n746 0.250378
R2293 AVSS_n765 AVSS_n764 0.250378
R2294 AVSS_n491 AVSS_n490 0.250378
R2295 AVSS_n705 AVSS_n703 0.250378
R2296 AVSS_n711 AVSS_n709 0.250378
R2297 AVSS_n713 AVSS_n711 0.250378
R2298 AVSS_n720 AVSS_n719 0.250378
R2299 AVSS_n727 AVSS_n59 0.250378
R2300 AVSS_n672 AVSS_n670 0.250378
R2301 AVSS_n689 AVSS_n687 0.250378
R2302 AVSS_n689 AVSS_n688 0.250378
R2303 AVSS_n118 AVSS_n74 0.250378
R2304 AVSS_n119 AVSS_n118 0.250378
R2305 AVSS_n120 AVSS_n119 0.250378
R2306 AVSS_n121 AVSS_n120 0.250378
R2307 AVSS_n127 AVSS_n126 0.250378
R2308 AVSS_n128 AVSS_n127 0.250378
R2309 AVSS_n347 AVSS_n346 0.250378
R2310 AVSS_n606 AVSS_n261 0.250378
R2311 AVSS_n601 AVSS_n265 0.250378
R2312 AVSS_n576 AVSS_n335 0.250378
R2313 AVSS_n570 AVSS_n569 0.250378
R2314 AVSS_n316 AVSS_n314 0.250378
R2315 AVSS_n323 AVSS_n291 0.250378
R2316 AVSS_n309 AVSS_n297 0.250378
R2317 AVSS_n627 AVSS_n626 0.250378
R2318 AVSS_n253 AVSS_n252 0.250378
R2319 AVSS_n302 AVSS_n280 0.250092
R2320 AVSS_n249 AVSS_n210 0.250092
R2321 AVSS_n739 AVSS_n27 0.249752
R2322 AVSS_n699 AVSS_n75 0.242759
R2323 AVSS_n38 AVSS_n30 0.242419
R2324 AVSS_n594 AVSS_n222 0.223034
R2325 AVSS_n764 AVSS_n763 0.223034
R2326 AVSS_n582 AVSS_n329 0.223034
R2327 AVSS_n324 AVSS_n323 0.223034
R2328 AVSS_n511 AVSS_n375 0.223034
R2329 AVSS_n515 AVSS_n514 0.220511
R2330 AVSS_n564 AVSS_n563 0.217868
R2331 AVSS_n26 AVSS_n16 0.217868
R2332 AVSS_n638 AVSS_n636 0.208659
R2333 AVSS_n555 AVSS_n553 0.198508
R2334 AVSS_n658 AVSS_n652 0.195092
R2335 AVSS_n668 AVSS_n666 0.195092
R2336 AVSS_n530 AVSS_n374 0.187772
R2337 AVSS_n498 AVSS_n377 0.187772
R2338 AVSS_n281 AVSS_n214 0.186728
R2339 AVSS_n564 AVSS_n337 0.157398
R2340 AVSS_n548 AVSS_n547 0.1545
R2341 AVSS_n487 AVSS_n421 0.132772
R2342 AVSS_n703 AVSS_n701 0.132772
R2343 AVSS_n700 AVSS_n74 0.132772
R2344 AVSS_n606 AVSS_n605 0.132772
R2345 AVSS_n548 AVSS_n534 0.132772
R2346 AVSS_n26 AVSS_n25 0.130662
R2347 AVSS_n760 AVSS_n26 0.129765
R2348 AVSS_n778 AVSS_n775 0.125789
R2349 AVSS_n782 AVSS_n774 0.125789
R2350 AVSS_n786 AVSS_n773 0.125789
R2351 AVSS_n790 AVSS_n772 0.125789
R2352 AVSS_n794 AVSS_n771 0.125789
R2353 AVSS_n807 AVSS_n1 0.125789
R2354 AVSS_n701 AVSS_n38 0.125425
R2355 AVSS_n700 AVSS_n699 0.125086
R2356 AVSS_n758 AVSS_n757 0.107106
R2357 AVSS_n663 AVSS_n146 0.0897938
R2358 AVSS_n552 AVSS_n269 0.089169
R2359 AVSS_n618 AVSS_n220 0.089169
R2360 AVSS_n471 AVSS_n470 0.089169
R2361 AVSS_n553 AVSS_n551 0.081439
R2362 AVSS_n758 AVSS_n27 0.0811667
R2363 AVSS_n518 AVSS_n374 0.0701667
R2364 AVSS_n327 AVSS_n280 0.0701667
R2365 AVSS_n281 AVSS_n210 0.0701667
R2366 AVSS_n377 AVSS_n376 0.0701667
R2367 AVSS_n776 AVSS_n775 0.0555
R2368 AVSS_n780 AVSS_n774 0.0555
R2369 AVSS_n784 AVSS_n773 0.0555
R2370 AVSS_n788 AVSS_n772 0.0555
R2371 AVSS_n792 AVSS_n771 0.0555
R2372 AVSS_n2 AVSS_n1 0.0555
R2373 AVSS_n636 AVSS_n0 0.0496724
R2374 AVSS_n222 AVSS_n221 0.0357621
R2375 AVSS_n763 AVSS_n762 0.0357621
R2376 AVSS_n355 AVSS_n354 0.0357621
R2377 AVSS_n329 AVSS_n328 0.0357621
R2378 AVSS_n324 AVSS_n282 0.0357621
R2379 AVSS_n516 AVSS_n375 0.0357621
R2380 AVSS_n420 AVSS_n413 0.00175
R2381 AVSS_n726 AVSS_n725 0.00175
R2382 AVSS_n480 AVSS_n479 0.00175
R2383 AVSS_n615 AVSS_n614 0.00175
R2384 AVSS_n544 AVSS_n543 0.00175
R2385 AVSS_n568 AVSS_n268 0.00175
R2386 AVSS_n660 AVSS_n185 0.00166667
R2387 AVSS_n653 AVSS_n182 0.00166667
R2388 AVSS_n254 AVSS_n246 0.00166667
R2389 AVSS_n494 AVSS_n417 0.00166667
R2390 AVSS_n22 AVSS_n15 0.00166667
R2391 AVSS_n704 AVSS_n67 0.00166667
R2392 AVSS_n712 AVSS_n71 0.00166667
R2393 AVSS_n714 AVSS_n65 0.00166667
R2394 AVSS_n723 AVSS_n73 0.00166667
R2395 AVSS_n738 AVSS_n54 0.00166667
R2396 AVSS_n737 AVSS_n51 0.00166667
R2397 AVSS_n731 AVSS_n46 0.00166667
R2398 AVSS_n750 AVSS_n45 0.00166667
R2399 AVSS_n698 AVSS_n83 0.00166667
R2400 AVSS_n671 AVSS_n139 0.00166667
R2401 AVSS_n675 AVSS_n136 0.00166667
R2402 AVSS_n681 AVSS_n143 0.00166667
R2403 AVSS_n683 AVSS_n135 0.00166667
R2404 AVSS_n112 AVSS_n100 0.00166667
R2405 AVSS_n109 AVSS_n103 0.00166667
R2406 AVSS_n105 AVSS_n104 0.00166667
R2407 AVSS_n477 AVSS_n476 0.00166667
R2408 AVSS_n345 AVSS_n338 0.00166667
R2409 AVSS_n351 AVSS_n350 0.00166667
R2410 AVSS_n611 AVSS_n260 0.00166667
R2411 AVSS_n600 AVSS_n599 0.00166667
R2412 AVSS_n597 AVSS_n593 0.00166667
R2413 AVSS_n541 AVSS_n371 0.00166667
R2414 AVSS_n586 AVSS_n334 0.00166667
R2415 AVSS_n585 AVSS_n332 0.00166667
R2416 AVSS_n575 AVSS_n574 0.00166667
R2417 AVSS_n301 AVSS_n299 0.00166667
R2418 AVSS_n218 AVSS_n206 0.00166667
R2419 AVSS_n621 AVSS_n205 0.00166667
R2420 AVSS_n769 AVSS_n18 0.00162501
R2421 AVSS_n751 AVSS_n58 0.00162501
R2422 AVSS_n325 AVSS_n283 0.00162501
R2423 AVSS_n630 AVSS_n212 0.00162501
R2424 AVSS_n248 AVSS_n212 0.00137498
R2425 AVSS_n301 AVSS_n283 0.00137498
R2426 AVSS_n751 AVSS_n750 0.00137498
R2427 AVSS_n769 AVSS_n768 0.00137498
R2428 AVSS_n654 AVSS_n182 0.00133332
R2429 AVSS_n660 AVSS_n659 0.00133332
R2430 AVSS_n623 AVSS_n205 0.00133332
R2431 AVSS_n621 AVSS_n206 0.00133332
R2432 AVSS_n304 AVSS_n299 0.00133332
R2433 AVSS_n574 AVSS_n267 0.00133332
R2434 AVSS_n581 AVSS_n332 0.00133332
R2435 AVSS_n586 AVSS_n585 0.00133332
R2436 AVSS_n541 AVSS_n540 0.00133332
R2437 AVSS_n599 AVSS_n264 0.00133332
R2438 AVSS_n614 AVSS_n260 0.00133332
R2439 AVSS_n597 AVSS_n596 0.00133332
R2440 AVSS_n352 AVSS_n351 0.00133332
R2441 AVSS_n564 AVSS_n338 0.00133332
R2442 AVSS_n479 AVSS_n477 0.00133332
R2443 AVSS_n685 AVSS_n135 0.00133332
R2444 AVSS_n683 AVSS_n143 0.00133332
R2445 AVSS_n677 AVSS_n136 0.00133332
R2446 AVSS_n673 AVSS_n139 0.00133332
R2447 AVSS_n667 AVSS_n83 0.00133332
R2448 AVSS_n113 AVSS_n100 0.00133332
R2449 AVSS_n110 AVSS_n103 0.00133332
R2450 AVSS_n106 AVSS_n104 0.00133332
R2451 AVSS_n723 AVSS_n722 0.00133332
R2452 AVSS_n716 AVSS_n65 0.00133332
R2453 AVSS_n714 AVSS_n71 0.00133332
R2454 AVSS_n706 AVSS_n67 0.00133332
R2455 AVSS_n54 AVSS_n28 0.00133332
R2456 AVSS_n738 AVSS_n51 0.00133332
R2457 AVSS_n732 AVSS_n46 0.00133332
R2458 AVSS_n729 AVSS_n45 0.00133332
R2459 AVSS_n23 AVSS_n15 0.00133332
R2460 AVSS_n494 AVSS_n493 0.00133332
R2461 AVSS_n246 AVSS_n218 0.00133332
R2462 AVSS_n589 AVSS_n268 0.00124998
R2463 AVSS_n543 AVSS_n371 0.00124998
R2464 AVSS_n616 AVSS_n615 0.00124998
R2465 AVSS_n481 AVSS_n480 0.00124998
R2466 AVSS_n725 AVSS_n58 0.00124998
R2467 AVSS_n413 AVSS_n18 0.00124998
R2468 AVSS_n635 AVSS_n189 0.001
R2469 AVSS_n644 AVSS_n203 0.001
R2470 AVSS_n643 AVSS_n634 0.001
R2471 AVSS_n637 AVSS_n204 0.001
R2472 AVSS_n637 AVSS_n633 0.001
R2473 AVSS_n647 AVSS_n190 0.001
R2474 AVSS_n647 AVSS_n646 0.001
R2475 AVSS_n649 AVSS_n189 0.001
R2476 AVSS_n635 AVSS_n633 0.001
R2477 AVSS_n639 AVSS_n204 0.001
R2478 AVSS_n639 AVSS_n634 0.001
R2479 AVSS_n644 AVSS_n643 0.001
R2480 AVSS_n646 AVSS_n203 0.001
R2481 AVSS_n649 AVSS_n190 0.001
R2482 AVSS_n654 AVSS_n181 0.001
R2483 AVSS_n653 AVSS_n183 0.001
R2484 AVSS_n663 AVSS_n662 0.001
R2485 AVSS_n659 AVSS_n183 0.001
R2486 AVSS_n181 AVSS_n180 0.001
R2487 AVSS_n662 AVSS_n180 0.001
R2488 AVSS_n549 AVSS_n364 0.001
R2489 AVSS_n549 AVSS_n528 0.001
R2490 AVSS_n556 AVSS_n527 0.001
R2491 AVSS_n557 AVSS_n556 0.001
R2492 AVSS_n531 AVSS_n372 0.001
R2493 AVSS_n531 AVSS_n363 0.001
R2494 AVSS_n561 AVSS_n560 0.001
R2495 AVSS_n560 AVSS_n559 0.001
R2496 AVSS_n505 AVSS_n504 0.001
R2497 AVSS_n506 AVSS_n505 0.001
R2498 AVSS_n509 AVSS_n402 0.001
R2499 AVSS_n509 AVSS_n508 0.001
R2500 AVSS_n502 AVSS_n501 0.001
R2501 AVSS_n501 AVSS_n496 0.001
R2502 AVSS_n497 AVSS_n378 0.001
R2503 AVSS_n514 AVSS_n513 0.001
R2504 AVSS_n209 AVSS_n208 0.001
R2505 AVSS_n625 AVSS_n207 0.001
R2506 AVSS_n255 AVSS_n254 0.001
R2507 AVSS_n250 AVSS_n245 0.001
R2508 AVSS_n248 AVSS_n244 0.001
R2509 AVSS_n631 AVSS_n630 0.001
R2510 AVSS_n296 AVSS_n293 0.001
R2511 AVSS_n322 AVSS_n321 0.001
R2512 AVSS_n319 AVSS_n292 0.001
R2513 AVSS_n318 AVSS_n295 0.001
R2514 AVSS_n315 AVSS_n294 0.001
R2515 AVSS_n308 AVSS_n307 0.001
R2516 AVSS_n300 AVSS_n298 0.001
R2517 AVSS_n305 AVSS_n304 0.001
R2518 AVSS_n325 AVSS_n290 0.001
R2519 AVSS_n588 AVSS_n330 0.001
R2520 AVSS_n581 AVSS_n331 0.001
R2521 AVSS_n334 AVSS_n333 0.001
R2522 AVSS_n567 AVSS_n336 0.001
R2523 AVSS_n572 AVSS_n571 0.001
R2524 AVSS_n568 AVSS_n566 0.001
R2525 AVSS_n544 AVSS_n539 0.001
R2526 AVSS_n610 AVSS_n609 0.001
R2527 AVSS_n608 AVSS_n607 0.001
R2528 AVSS_n607 AVSS_n262 0.001
R2529 AVSS_n600 AVSS_n266 0.001
R2530 AVSS_n596 AVSS_n592 0.001
R2531 AVSS_n593 AVSS_n223 0.001
R2532 AVSS_n352 AVSS_n341 0.001
R2533 AVSS_n350 AVSS_n349 0.001
R2534 AVSS_n348 AVSS_n344 0.001
R2535 AVSS_n663 AVSS_n148 0.001
R2536 AVSS_n485 AVSS_n484 0.001
R2537 AVSS_n485 AVSS_n428 0.001
R2538 AVSS_n467 AVSS_n439 0.001
R2539 AVSS_n472 AVSS_n466 0.001
R2540 AVSS_n482 AVSS_n481 0.001
R2541 AVSS_n693 AVSS_n132 0.001
R2542 AVSS_n690 AVSS_n134 0.001
R2543 AVSS_n691 AVSS_n690 0.001
R2544 AVSS_n145 AVSS_n144 0.001
R2545 AVSS_n681 AVSS_n142 0.001
R2546 AVSS_n679 AVSS_n141 0.001
R2547 AVSS_n673 AVSS_n140 0.001
R2548 AVSS_n671 AVSS_n138 0.001
R2549 AVSS_n669 AVSS_n137 0.001
R2550 AVSS_n697 AVSS_n89 0.001
R2551 AVSS_n117 AVSS_n97 0.001
R2552 AVSS_n116 AVSS_n96 0.001
R2553 AVSS_n116 AVSS_n99 0.001
R2554 AVSS_n114 AVSS_n95 0.001
R2555 AVSS_n113 AVSS_n94 0.001
R2556 AVSS_n111 AVSS_n101 0.001
R2557 AVSS_n110 AVSS_n102 0.001
R2558 AVSS_n108 AVSS_n93 0.001
R2559 AVSS_n107 AVSS_n92 0.001
R2560 AVSS_n106 AVSS_n91 0.001
R2561 AVSS_n695 AVSS_n694 0.001
R2562 AVSS_n726 AVSS_n60 0.001
R2563 AVSS_n63 AVSS_n62 0.001
R2564 AVSS_n73 AVSS_n72 0.001
R2565 AVSS_n716 AVSS_n64 0.001
R2566 AVSS_n710 AVSS_n66 0.001
R2567 AVSS_n710 AVSS_n70 0.001
R2568 AVSS_n708 AVSS_n69 0.001
R2569 AVSS_n704 AVSS_n68 0.001
R2570 AVSS_n702 AVSS_n37 0.001
R2571 AVSS_n753 AVSS_n29 0.001
R2572 AVSS_n52 AVSS_n28 0.001
R2573 AVSS_n736 AVSS_n50 0.001
R2574 AVSS_n735 AVSS_n49 0.001
R2575 AVSS_n735 AVSS_n55 0.001
R2576 AVSS_n733 AVSS_n48 0.001
R2577 AVSS_n732 AVSS_n47 0.001
R2578 AVSS_n730 AVSS_n56 0.001
R2579 AVSS_n729 AVSS_n57 0.001
R2580 AVSS_n420 AVSS_n414 0.001
R2581 AVSS_n419 AVSS_n415 0.001
R2582 AVSS_n417 AVSS_n416 0.001
R2583 AVSS_n21 AVSS_n14 0.001
R2584 AVSS_n21 AVSS_n17 0.001
R2585 AVSS_n768 AVSS_n13 0.001
R2586 AVSS_n416 AVSS_n23 0.001
R2587 AVSS_n493 AVSS_n415 0.001
R2588 AVSS_n419 AVSS_n414 0.001
R2589 AVSS_n22 AVSS_n14 0.001
R2590 AVSS_n20 AVSS_n17 0.001
R2591 AVSS_n20 AVSS_n13 0.001
R2592 AVSS_n754 AVSS_n37 0.001
R2593 AVSS_n702 AVSS_n68 0.001
R2594 AVSS_n706 AVSS_n69 0.001
R2595 AVSS_n708 AVSS_n70 0.001
R2596 AVSS_n712 AVSS_n66 0.001
R2597 AVSS_n718 AVSS_n64 0.001
R2598 AVSS_n718 AVSS_n72 0.001
R2599 AVSS_n722 AVSS_n63 0.001
R2600 AVSS_n62 AVSS_n60 0.001
R2601 AVSS_n754 AVSS_n753 0.001
R2602 AVSS_n52 AVSS_n29 0.001
R2603 AVSS_n737 AVSS_n50 0.001
R2604 AVSS_n736 AVSS_n49 0.001
R2605 AVSS_n734 AVSS_n55 0.001
R2606 AVSS_n734 AVSS_n48 0.001
R2607 AVSS_n733 AVSS_n47 0.001
R2608 AVSS_n731 AVSS_n56 0.001
R2609 AVSS_n730 AVSS_n57 0.001
R2610 AVSS_n667 AVSS_n137 0.001
R2611 AVSS_n669 AVSS_n138 0.001
R2612 AVSS_n675 AVSS_n140 0.001
R2613 AVSS_n677 AVSS_n141 0.001
R2614 AVSS_n679 AVSS_n142 0.001
R2615 AVSS_n685 AVSS_n144 0.001
R2616 AVSS_n691 AVSS_n145 0.001
R2617 AVSS_n134 AVSS_n132 0.001
R2618 AVSS_n694 AVSS_n693 0.001
R2619 AVSS_n698 AVSS_n697 0.001
R2620 AVSS_n97 AVSS_n89 0.001
R2621 AVSS_n117 AVSS_n96 0.001
R2622 AVSS_n115 AVSS_n99 0.001
R2623 AVSS_n115 AVSS_n95 0.001
R2624 AVSS_n114 AVSS_n94 0.001
R2625 AVSS_n112 AVSS_n101 0.001
R2626 AVSS_n111 AVSS_n102 0.001
R2627 AVSS_n109 AVSS_n93 0.001
R2628 AVSS_n108 AVSS_n92 0.001
R2629 AVSS_n107 AVSS_n91 0.001
R2630 AVSS_n695 AVSS_n105 0.001
R2631 AVSS_n476 AVSS_n428 0.001
R2632 AVSS_n484 AVSS_n439 0.001
R2633 AVSS_n472 AVSS_n467 0.001
R2634 AVSS_n469 AVSS_n466 0.001
R2635 AVSS_n482 AVSS_n469 0.001
R2636 AVSS_n185 AVSS_n148 0.001
R2637 AVSS_n345 AVSS_n344 0.001
R2638 AVSS_n349 AVSS_n348 0.001
R2639 AVSS_n564 AVSS_n341 0.001
R2640 AVSS_n264 AVSS_n262 0.001
R2641 AVSS_n609 AVSS_n608 0.001
R2642 AVSS_n611 AVSS_n610 0.001
R2643 AVSS_n591 AVSS_n266 0.001
R2644 AVSS_n592 AVSS_n591 0.001
R2645 AVSS_n616 AVSS_n223 0.001
R2646 AVSS_n540 AVSS_n539 0.001
R2647 AVSS_n333 AVSS_n267 0.001
R2648 AVSS_n331 AVSS_n330 0.001
R2649 AVSS_n589 AVSS_n588 0.001
R2650 AVSS_n575 AVSS_n336 0.001
R2651 AVSS_n572 AVSS_n567 0.001
R2652 AVSS_n571 AVSS_n566 0.001
R2653 AVSS_n313 AVSS_n293 0.001
R2654 AVSS_n313 AVSS_n294 0.001
R2655 AVSS_n315 AVSS_n295 0.001
R2656 AVSS_n319 AVSS_n318 0.001
R2657 AVSS_n321 AVSS_n292 0.001
R2658 AVSS_n322 AVSS_n290 0.001
R2659 AVSS_n307 AVSS_n296 0.001
R2660 AVSS_n308 AVSS_n298 0.001
R2661 AVSS_n305 AVSS_n300 0.001
R2662 AVSS_n623 AVSS_n207 0.001
R2663 AVSS_n625 AVSS_n208 0.001
R2664 AVSS_n631 AVSS_n209 0.001
R2665 AVSS_n255 AVSS_n247 0.001
R2666 AVSS_n247 AVSS_n245 0.001
R2667 AVSS_n250 AVSS_n244 0.001
R2668 AVSS_n507 AVSS_n506 0.001
R2669 AVSS_n508 AVSS_n507 0.001
R2670 AVSS_n512 AVSS_n402 0.001
R2671 AVSS_n513 AVSS_n512 0.001
R2672 AVSS_n504 AVSS_n411 0.001
R2673 AVSS_n502 AVSS_n411 0.001
R2674 AVSS_n497 AVSS_n496 0.001
R2675 AVSS_n514 AVSS_n378 0.001
R2676 AVSS_n529 AVSS_n528 0.001
R2677 AVSS_n557 AVSS_n529 0.001
R2678 AVSS_n527 AVSS_n526 0.001
R2679 AVSS_n559 AVSS_n526 0.001
R2680 AVSS_n533 AVSS_n364 0.001
R2681 AVSS_n533 AVSS_n372 0.001
R2682 AVSS_n373 AVSS_n363 0.001
R2683 AVSS_n561 AVSS_n373 0.001
C0 AVDD pn2 1.18142f
C1 S2 pn13 0.48256f
C2 pn5 pn20 0.04412f
C3 pn12 pn28 0.57521f
C4 pn6 pn8 0.10851f
C5 pn24 pn28 0.19957f
C6 pn22 pn5 0.46679f
C7 pn13 a_n4978_3451_ 0.17196f
C8 pn6 pn1 0.67514f
C9 pn30 pn28 0.0288f
C10 pn3 pn5 0.76119f
C11 pn30 pn12 2.40691f
C12 pn4 pn5 2.27021f
C13 pn6 I_BIAS 0.18368f
C14 pn30 pn24 2.92399f
C15 pn4 pn3 0.45979f
C16 a_n3044_4188_ pn5 0.20416f
C17 a_n3044_4188_ pn22 0.26159f
C18 pn28 pn13 0.28864f
C19 pn10 AVDD 5.28473f
C20 a_n3643_n9034_ pn7 0.13861f
C21 I_BIAS pn9 0.01526f
C22 S5 a_n3044_4748_ 0.22971f
C23 a_n3044_4188_ pn3 0.25617f
C24 pn12 pn13 0.1856f
C25 pn27 AVDD 6.27803f
C26 a_n3044_4748_ a_n3044_4468_ 1.17654f
C27 pn13 a_n10333_n2089_ 0.04968f
C28 a_n3643_n9034_ pn2 0.0609f
C29 a_n3044_4188_ pn4 0.01316f
C30 pn30 S1 0.05441f
C31 pn24 pn13 1.73471f
C32 V_OUT2 AVDD 2.30455f
C33 pn13 a_n9685_3451_ 0.04583f
C34 pn30 pn13 0.42063f
C35 pn29 AVDD 0.70879f
C36 pn19 a_n9685_3451_ 0.01344f
C37 pn16 pn13 0.01621f
C38 a_n8004_3451_ AVDD 0.01308f
C39 pn15 pn13 0.07109f
C40 pn6 AVDD 2.04699f
C41 pn28 pn11 0.10314f
C42 pn21 pn13 0.32634f
C43 AVDD pn20 0.0359f
C44 pn28 pn26 1.1511f
C45 pn17 S1 0.07862f
C46 AVDD pn5 0.09572f
C47 pn16 S5 0.07878f
C48 pn24 pn11 0.02725f
C49 pn28 V_CM 0.3573f
C50 pn17 pn13 0.05126f
C51 AVDD pn22 0.03448f
C52 pn15 S5 0.06011f
C53 pn24 pn26 0.52777f
C54 pn12 V_CM 0.56665f
C55 pn13 S1 0.24177f
C56 AVDD pn3 0.04637f
C57 pn28 pn7 0.04234f
C58 pn12 pn25 0.02718f
C59 pn24 V_CM 1.39878f
C60 pn19 S1 0.10057f
C61 AVDD pn4 0.05776f
C62 pn12 pn7 1.59468f
C63 pn30 V_CM 0.10604f
C64 pn28 pn2 0.59982f
C65 pn19 pn13 0.07725f
C66 S0 S1 0.47212f
C67 pn30 pn25 0.02269f
C68 S0 pn13 0.27056f
C69 I_BIAS AVDD 0.02179f
C70 pn30 pn7 0.03972f
C71 pn23 pn22 0.02561f
C72 S0 pn19 0.07621f
C73 S5 pn13 0.53287f
C74 S4 pn5 0.096f
C75 pn29 a_n3643_n9034_ 0.036f
C76 S4 pn22 0.01463f
C77 S2 a_n8004_3451_ 0.05745f
C78 pn14 pn22 0.01065f
C79 S3 pn5 0.2212f
C80 S5 a_n3044_4468_ 0.14571f
C81 S3 pn22 0.05282f
C82 S2 pn20 0.01763f
C83 S2 pn5 0.71867f
C84 a_n4978_3451_ pn5 0.1755f
C85 pn10 pn28 0.46747f
C86 a_n4978_3451_ pn22 0.08325f
C87 pn10 pn12 0.3042f
C88 pn27 pn28 0.16354f
C89 pn1 a_n3643_n9034_ 0.0275f
C90 pn26 pn11 0.20624f
C91 pn10 pn24 0.1344f
C92 V_OUT2 pn28 0.07765f
C93 pn27 pn12 0.52315f
C94 V_CM pn11 0.01993f
C95 S3 a_n3044_4188_ 0.01421f
C96 pn10 pn30 0.03181f
C97 I_BIAS a_n3643_n9034_ 0.01527f
C98 pn27 pn24 0.11688f
C99 pn29 pn28 1.06987f
C100 V_CM pn26 1.68139f
C101 pn27 pn30 0.04374f
C102 V_OUT2 pn24 0.29706f
C103 a_n3044_4748_ pn5 0.04536f
C104 pn6 pn28 0.06846f
C105 pn29 pn24 0.82491f
C106 pn2 pn11 0.42393f
C107 pn7 pn26 1.07882f
C108 pn25 V_CM 0.01565f
C109 V_IN2 a_n10333_n2089_ 0.04968f
C110 a_n3044_4748_ pn22 0.01325f
C111 pn6 pn12 1.33154f
C112 pn2 pn26 0.3585f
C113 pn7 V_CM 0.04431f
C114 a_n3044_4748_ pn3 0.01602f
C115 a_n3044_4188_ a_n4978_3451_ 0.1345f
C116 pn2 V_CM 0.02242f
C117 a_n3044_4748_ pn4 0.02044f
C118 pn6 pn30 0.44685f
C119 a_n9685_3451_ pn20 0.024f
C120 S4 AVDD 0.95484f
C121 pn2 pn7 0.13716f
C122 pn21 a_n8004_3451_ 0.02425f
C123 a_n9685_3451_ pn5 0.07357f
C124 pn14 AVDD 0.46516f
C125 pn27 pn13 0.03986f
C126 S3 AVDD 0.21684f
C127 pn28 pn9 0.1093f
C128 pn17 a_n8004_3451_ 0.01195f
C129 V_OUT2 pn13 0.01327f
C130 pn18 AVDD 0.41824f
C131 pn21 pn5 0.03213f
C132 pn29 pn13 1.99073f
C133 S2 AVDD 0.2399f
C134 pn12 I_BIAS 0.3852f
C135 pn16 pn3 0.0127f
C136 pn17 pn20 0.01136f
C137 pn13 a_n8004_3451_ 0.08845f
C138 V_IN2 pn13 0.02443f
C139 pn16 pn4 0.0183f
C140 pn15 pn3 0.02484f
C141 S1 pn20 0.01635f
C142 pn6 pn13 0.01973f
C143 pn30 I_BIAS 0.63956f
C144 a_n4978_3451_ AVDD 0.01197f
C145 pn10 pn11 0.01193f
C146 pn13 pn20 0.35357f
C147 pn27 pn11 0.73924f
C148 pn10 pn26 0.01692f
C149 pn14 S4 0.09127f
C150 pn13 pn5 1.16105f
C151 pn10 V_CM 0.14897f
C152 pn27 pn26 0.52945f
C153 V_OUT2 pn11 0.22442f
C154 S3 S4 4.71192f
C155 pn13 pn22 0.32072f
C156 pn19 pn5 0.02022f
C157 pn10 pn25 0.17186f
C158 pn29 pn11 0.11326f
C159 pn27 V_CM 0.29697f
C160 V_OUT2 pn26 1.44764f
C161 pn18 S4 0.01426f
C162 S3 pn14 0.084f
C163 pn13 pn3 0.28573f
C164 S0 pn5 0.01443f
C165 V_OUT2 V_CM 0.123f
C166 pn10 pn7 0.18634f
C167 pn29 pn26 0.31876f
C168 S5 pn5 1.76492f
C169 pn13 pn4 0.18577f
C170 a_n3044_4468_ pn5 0.07866f
C171 pn10 pn2 0.30114f
C172 pn29 V_CM 0.45405f
C173 pn6 pn11 0.39181f
C174 pn18 S3 0.02683f
C175 S5 pn22 0.29311f
C176 a_n3044_4468_ pn22 0.03272f
C177 pn27 pn2 1.4573f
C178 V_OUT2 pn7 0.02504f
C179 V_IN2 V_CM 0.02999f
C180 pn6 pn26 0.34986f
C181 S2 S3 2.9899f
C182 S4 a_n4978_3451_ 0.01997f
C183 S5 pn3 0.14361f
C184 a_n3044_4468_ pn3 0.05954f
C185 V_OUT2 pn2 0.89516f
C186 pn6 V_CM 0.13481f
C187 pn29 pn7 1.06048f
C188 pn28 AVDD 5.10986f
C189 S2 pn18 0.08461f
C190 S5 pn4 0.13884f
C191 pn6 pn25 0.0148f
C192 pn29 pn2 0.20503f
C193 pn27 a_1131_n7353_ 0.0438f
C194 pn12 AVDD 19.1691f
C195 S3 a_n4978_3451_ 0.07379f
C196 pn6 pn7 0.19451f
C197 pn24 AVDD 11.0694f
C198 a_n3044_4748_ pn23 0.02317f
C199 pn18 a_n4978_3451_ 0.01262f
C200 a_n9685_3451_ AVDD 0.018f
C201 pn30 AVDD 46.8659f
C202 pn16 AVDD 0.46548f
C203 S5 a_n3044_4188_ 0.13296f
C204 a_n3044_4468_ a_n3044_4188_ 1.17654f
C205 pn6 a_1131_n7353_ 0.01072f
C206 pn15 AVDD 0.46357f
C207 pn21 AVDD 0.03983f
C208 pn1 pn7 0.01807f
C209 pn17 AVDD 0.49488f
C210 pn9 pn7 0.01521f
C211 pn27 pn10 0.57012f
C212 S4 pn24 0.014f
C213 S1 AVDD 0.52854f
C214 I_BIAS pn7 0.3157f
C215 pn9 pn2 0.09267f
C216 pn8 a_1131_n7353_ 0.06289f
C217 S4 pn30 0.17608f
C218 I_BIAS pn2 0.14684f
C219 V_OUT2 pn10 0.12863f
C220 pn13 AVDD 9.55871f
C221 pn29 pn10 0.27056f
C222 V_OUT2 pn27 1.35215f
C223 pn19 AVDD 0.44304f
C224 S3 pn30 0.01639f
C225 S4 pn15 0.07968f
C226 pn29 pn27 0.20728f
C227 S0 AVDD 0.21608f
C228 V_OUT2 a_7746_452_ 0.01853f
C229 pn6 pn10 0.01743f
C230 S5 AVDD 0.19094f
C231 S2 a_n9685_3451_ 0.01977f
C232 S2 pn30 0.02074f
C233 pn6 pn27 0.81654f
C234 S3 pn21 0.01722f
C235 pn6 V_OUT2 0.02167f
C236 AVDD pn11 6.00111f
C237 pn18 pn21 0.01044f
C238 pn6 pn29 0.54154f
C239 AVDD pn26 0.83763f
C240 S4 pn13 0.25122f
C241 S2 pn21 0.029f
C242 a_7746_452_ pn5 0.01807f
C243 AVDD V_CM 7.25207f
C244 S5 pn23 0.04204f
C245 pn14 pn13 0.065f
C246 pn27 pn8 0.16069f
C247 a_n8004_3451_ pn20 0.02758f
C248 a_n3044_4468_ pn23 0.02317f
C249 pn17 S2 0.0161f
C250 AVDD pn25 1.80953f
C251 S3 pn13 0.62043f
C252 pn21 a_n4978_3451_ 0.02602f
C253 V_OUT2 pn8 0.97386f
C254 a_n8004_3451_ pn5 0.08729f
C255 pn10 pn9 0.01014f
C256 AVDD pn7 0.81214f
C257 pn18 pn13 0.04558f
C258 S4 S5 3.7668f
C259 pn10 I_BIAS 0.10035f
C260 pn8 AVSS 6.70653f
C261 pn1 AVSS 8.74284f
C262 I_BIAS AVSS 9.7144f
C263 pn26 AVSS 9.79169f
C264 V_CM AVSS 2.28848f
C265 pn25 AVSS 0.11377f
C266 pn2 AVSS 3.95269f
C267 pn27 AVSS 9.24403f
C268 V_OUT2 AVSS 16.39344f
C269 pn29 AVSS 8.00736f
C270 V_IN2 AVSS 0.72253f
C271 pn28 AVSS 5.90261f
C272 pn24 AVSS 5.54099f
C273 pn30 AVSS 7.01794f
C274 S4 AVSS 9.90956f
C275 S3 AVSS 8.63651f
C276 S2 AVSS 5.67639f
C277 S1 AVSS 2.79018f
C278 pn13 AVSS 9.88341f
C279 S0 AVSS 1.68991f
C280 S5 AVSS 9.59493f
C281 pn21 AVSS 1.4877f
C282 pn20 AVSS 1.06263f
C283 pn5 AVSS 6.01547f
C284 pn22 AVSS 5.73529f
C285 pn3 AVSS 3.08416f
C286 pn4 AVSS 1.92405f
C287 pn23 AVSS 3.07416f
C288 AVDD AVSS 1.19358f
C289 AVSS_t17 AVSS 0.06274f
C290 AVSS_t41 AVSS 0.53044f
C291 AVSS_t39 AVSS 0.52099f
C292 AVSS_t37 AVSS 6.04481f
C293 AVSS_t47 AVSS 0.25442f
C294 AVSS_t45 AVSS 0.10831f
C295 AVSS_t51 AVSS 0.0931f
C296 AVSS_t53 AVSS 0.13412f
C297 AVSS_t2 AVSS 1.08502f
C298 AVSS_t43 AVSS 0.28779f
C299 AVSS_t33 AVSS 0.49258f
C300 AVSS_t49 AVSS 0.08082f
C301 AVSS_t13 AVSS 0.08366f
C302 AVDD_n0 AVSS 0.01079f
C303 AVDD_n1 AVSS 0.0111f
C304 AVDD_n2 AVSS 0.0111f
C305 AVDD_n3 AVSS 0.0111f
C306 AVDD_n4 AVSS 0.0111f
C307 AVDD_n5 AVSS 0.0111f
C308 AVDD_n6 AVSS 0.01281f
C309 AVDD_n7 AVSS 0.01281f
C310 AVDD_n8 AVSS 0.0111f
C311 AVDD_n9 AVSS 0.0111f
C312 AVDD_n10 AVSS 0.0111f
C313 AVDD_n11 AVSS 0.01665f
C314 AVDD_n12 AVSS 0.30925f
C315 AVDD_t28 AVSS 8.27999f
C316 AVDD_n26 AVSS 0.5395f
C317 AVDD_n28 AVSS 0.26175f
C318 AVDD_n29 AVSS 0.17026f
C319 AVDD_n30 AVSS 0.61467f
C320 AVDD_n32 AVSS 0.61467f
C321 AVDD_n33 AVSS 0.61467f
C322 AVDD_t15 AVSS 1.40109f
C323 AVDD_t16 AVSS 0.52331f
C324 AVDD_n37 AVSS 0.09155f
C325 AVDD_n41 AVSS 0.61467f
C326 AVDD_n42 AVSS 0.61467f
C327 AVDD_n43 AVSS 1.22934f
C328 AVDD_t43 AVSS 0.72314f
C329 AVDD_n44 AVSS 0.61467f
C330 AVDD_t8 AVSS 0.88133f
C331 AVDD_n45 AVSS 0.61467f
C332 AVDD_n46 AVSS 0.61467f
C333 AVDD_n47 AVSS 0.61467f
C334 AVDD_n48 AVSS 0.61467f
C335 AVDD_n49 AVSS 0.61467f
C336 AVDD_n50 AVSS 0.61467f
C337 AVDD_n51 AVSS 0.61467f
C338 AVDD_t6 AVSS 1.70843f
C339 AVDD_n53 AVSS 0.61467f
C340 AVDD_n55 AVSS 0.61467f
C341 AVDD_n56 AVSS 0.61467f
C342 AVDD_n57 AVSS 1.22934f
C343 AVDD_n59 AVSS 0.61467f
C344 AVDD_t13 AVSS 0.61467f
C345 AVDD_t35 AVSS 0.61467f
C346 AVDD_n62 AVSS 0.61467f
C347 AVDD_n64 AVSS 0.61467f
C348 AVDD_t54 AVSS 0.61467f
C349 AVDD_t37 AVSS 1.22934f
C350 AVDD_n66 AVSS 0.61467f
C351 AVDD_t39 AVSS 4.58292f
C352 AVDD_n67 AVSS 0.61467f
C353 AVDD_n68 AVSS 0.61467f
C354 AVDD_t41 AVSS 1.84402f
C355 AVDD_n69 AVSS 0.57399f
C356 AVDD_n70 AVSS 0.61467f
C357 AVDD_n71 AVSS 0.5062f
C358 AVDD_n72 AVSS 0.61467f
C359 AVDD_n73 AVSS 0.61467f
C360 AVDD_t44 AVSS 1.42199f
C361 AVDD_t42 AVSS 1.42199f
C362 AVDD_t40 AVSS 1.42197f
C363 AVDD_t38 AVSS 1.42198f
C364 AVDD_t36 AVSS 1.42198f
C365 AVDD_t32 AVSS 1.42198f
C366 AVDD_t31 AVSS 1.42197f
C367 AVDD_t29 AVSS 1.44041f
C368 AVDD_n75 AVSS 0.07009f
C369 AVDD_n76 AVSS 0.05019f
C370 AVDD_n77 AVSS 0.0502f
C371 AVDD_n78 AVSS 0.05019f
C372 AVDD_n79 AVSS 0.0502f
C373 AVDD_n80 AVSS 0.05019f
C374 AVDD_n81 AVSS 0.04267f
C375 AVDD_n82 AVSS 0.03548f
C376 AVDD_n83 AVSS 0.04468f
C377 AVDD_n84 AVSS 0.2203f
C378 AVDD_n85 AVSS 0.01069f
C379 AVDD_n86 AVSS 0.0949f
C380 AVDD_n97 AVSS 0.02478f
C381 AVDD_n98 AVSS 0.02316f
C382 AVDD_n99 AVSS 0.18637f
C383 AVDD_t55 AVSS 0.40818f
C384 AVDD_n100 AVSS 0.04458f
C385 AVDD_n101 AVSS 0.01438f
C386 AVDD_n102 AVSS 0.07221f
C387 AVDD_n103 AVSS 0.07289f
C388 AVDD_n104 AVSS 0.10758f
C389 AVDD_n105 AVSS 0.07534f
C390 AVDD_n106 AVSS 0.08024f
C391 AVDD_n107 AVSS 0.01226f
C392 AVDD_n109 AVSS 0.37109f
C393 AVDD_n111 AVSS 0.08126f
C394 AVDD_n112 AVSS 0.06378f
C395 AVDD_n113 AVSS 0.03719f
C396 AVDD_t11 AVSS 4.50624f
C397 AVDD_t12 AVSS 0.14704f
C398 AVDD_t18 AVSS 0.11226f
C399 AVDD_n123 AVSS 0.0594f
C400 AVDD_n124 AVSS 0.0501f
C401 AVDD_n125 AVSS 0.09654f
C402 AVDD_n126 AVSS 0.09804f
C403 AVDD_n127 AVSS 0.0634f
C404 AVDD_n128 AVSS 0.68866f
C405 AVDD_n129 AVSS 0.12459f
C406 AVDD_n130 AVSS 0.47814f
C407 AVDD_t63 AVSS 1.88741f
C408 AVDD_n131 AVSS 0.04353f
C409 AVDD_t64 AVSS 1.22565f
C410 AVDD_n132 AVSS 0.11243f
C411 AVDD_t59 AVSS 0.61467f
C412 AVDD_n139 AVSS 0.61467f
C413 AVDD_t60 AVSS 1.22934f
C414 AVDD_t62 AVSS 0.61467f
C415 AVDD_t45 AVSS 0.61467f
C416 AVDD_n143 AVSS 0.01587f
C417 AVDD_n146 AVSS 0.61467f
C418 AVDD_t53 AVSS 0.70507f
C419 AVDD_n149 AVSS 1.22934f
C420 AVDD_n150 AVSS 0.94009f
C421 AVDD_n151 AVSS 0.61467f
C422 AVDD_n152 AVSS 0.61467f
C423 AVDD_n153 AVSS 0.04471f
C424 AVDD_n154 AVSS 0.61467f
C425 AVDD_t56 AVSS 0.61467f
C426 AVDD_n155 AVSS 0.61467f
C427 AVDD_n156 AVSS 0.61467f
C428 AVDD_n158 AVSS 0.61467f
C429 AVDD_n159 AVSS 0.61467f
C430 AVDD_n160 AVSS 0.61467f
C431 AVDD_n161 AVSS 0.61467f
C432 AVDD_t33 AVSS 1.22934f
C433 AVDD_n163 AVSS 0.61467f
C434 AVDD_n164 AVSS 0.73218f
C435 AVDD_n166 AVSS 0.61467f
C436 AVDD_n167 AVSS 0.61467f
C437 AVDD_t26 AVSS 1.22934f
C438 AVDD_n169 AVSS 0.32598f
C439 AVDD_n170 AVSS 0.09026f
C440 AVDD_n171 AVSS 0.24269f
C441 AVDD_n179 AVSS 0.33878f
C442 AVDD_n185 AVSS 0.04561f
C443 AVDD_n186 AVSS 0.0111f
C444 AVDD_n187 AVSS 0.0111f
C445 AVDD_n188 AVSS 0.0111f
C446 AVDD_n189 AVSS 0.0111f
C447 AVDD_n190 AVSS 0.0111f
C448 AVDD_n191 AVSS 0.04184f
C449 AVDD_n192 AVSS 0.0111f
C450 AVDD_n193 AVSS 0.0111f
C451 AVDD_n194 AVSS 0.0111f
C452 AVDD_n195 AVSS 0.0111f
C453 AVDD_n196 AVSS 0.01087f
C454 AVDD_n197 AVSS 0.0111f
C455 AVDD_n201 AVSS 0.01185f
C456 AVDD_n202 AVSS 0.0111f
C457 AVDD_n205 AVSS 0.0111f
C458 AVDD_n206 AVSS 0.0111f
C459 AVDD_n209 AVSS 0.01296f
C460 AVDD_n210 AVSS 0.01665f
C461 AVDD_n213 AVSS 1.84402f
C462 AVDD_n215 AVSS 1.22934f
C463 AVDD_n217 AVSS 1.22934f
C464 AVDD_n219 AVSS 0.0111f
C465 AVDD_n220 AVSS 0.01294f
C466 AVDD_n221 AVSS 0.0111f
C467 AVDD_n222 AVSS 0.0111f
C468 AVDD_n224 AVSS 1.22934f
C469 AVDD_n226 AVSS 0.97624f
C470 AVDD_n228 AVSS 1.22934f
C471 AVDD_n230 AVSS 0.0111f
C472 AVDD_n231 AVSS 0.01185f
C473 AVDD_n232 AVSS 0.01156f
C474 AVDD_n233 AVSS 0.01306f
C475 AVDD_t21 AVSS 1.69939f
C476 AVDD_n236 AVSS 1.22934f
C477 AVDD_n238 AVSS 1.22934f
C478 AVDD_n240 AVSS 0.0111f
C479 AVDD_n241 AVSS 0.0111f
C480 AVDD_n242 AVSS 0.0111f
C481 AVDD_n243 AVSS 0.0111f
C482 AVDD_n244 AVSS 0.0111f
C483 AVDD_n246 AVSS 1.22934f
C484 AVDD_n248 AVSS 1.22934f
C485 AVDD_n250 AVSS 1.22934f
C486 AVDD_n252 AVSS 0.0111f
C487 AVDD_n253 AVSS 0.05941f
C488 AVDD_n254 AVSS 0.1035f
C489 AVDD_n255 AVSS 0.05787f
C490 AVDD_n256 AVSS 0.10776f
C491 AVDD_n257 AVSS 0.07654f
C492 AVDD_n258 AVSS 0.06463f
C493 AVDD_n259 AVSS 3.99558f
C494 AVDD_n262 AVSS 0.45725f
C495 AVDD_t58 AVSS 0.14093f
C496 AVDD_t61 AVSS 0.1402f
C497 AVDD_t57 AVSS 1.09689f
C498 AVDD_n263 AVSS 0.08584f
C499 AVDD_n264 AVSS 0.08192f
C500 AVDD_n265 AVSS 0.01737f
C501 AVDD_n266 AVSS 0.1033f
C502 AVDD_n267 AVSS 0.03357f
C503 AVDD_n269 AVSS 0.08889f
C504 AVDD_n270 AVSS 0.08474f
C505 AVDD_n271 AVSS 0.0614f
C506 AVDD_n272 AVSS 0.08704f
C507 AVDD_n273 AVSS 0.02172f
C508 AVDD_n276 AVSS 0.26175f
C509 AVDD_t47 AVSS 9.23232f
C510 AVDD_t52 AVSS 1.4394f
C511 AVDD_t51 AVSS 1.42198f
C512 AVDD_t50 AVSS 1.42198f
C513 AVDD_t49 AVSS 1.42198f
C514 AVDD_t48 AVSS 1.42198f
C515 AVDD_t27 AVSS 1.42197f
C516 AVDD_t46 AVSS 1.42198f
C517 AVDD_t34 AVSS 1.44041f
C518 AVDD_n278 AVSS 0.07009f
C519 AVDD_n279 AVSS 0.05021f
C520 AVDD_n280 AVSS 0.0502f
C521 AVDD_n281 AVSS 0.0502f
C522 AVDD_n282 AVSS 0.05019f
C523 AVDD_n283 AVSS 0.0502f
C524 AVDD_n284 AVSS 0.04267f
C525 AVDD_n285 AVSS 0.08065f
C526 AVDD_n287 AVSS 0.57051f
C527 AVDD_n288 AVSS 1.53668f
C528 AVDD_n289 AVSS 0.47814f
C529 AVDD_n290 AVSS 0.19416f
C530 AVDD_n291 AVSS 0.10632f
C531 AVDD_n292 AVSS 0.09181f
C532 AVDD_n293 AVSS 0.02889f
C533 AVDD_n294 AVSS 0.10383f
C534 AVDD_n295 AVSS 0.06952f
C535 AVDD_n296 AVSS 0.11711f
C536 AVDD_n297 AVSS 0.12483f
C537 AVDD_n298 AVSS 0.4053f
C538 AVDD_n299 AVSS 0.12156f
C539 AVDD_n300 AVSS 0.10057f
C540 AVDD_n301 AVSS 0.29608f
C541 AVDD_n302 AVSS 0.65961f
C542 AVDD_n304 AVSS 3.85074f
C543 AVDD_n305 AVSS 0.50425f
C544 AVDD_n306 AVSS 0.03594f
C545 AVDD_n314 AVSS 0.38904f
C546 AVDD_t7 AVSS 1.45808f
C547 AVDD_n315 AVSS 0.09346f
C548 AVDD_n316 AVSS 0.04536f
C549 AVDD_t14 AVSS 2.83466f
C550 AVDD_n318 AVSS 0.10472f
C551 AVDD_n319 AVSS 0.38989f
C552 AVDD_n320 AVSS 0.07782f
C553 AVDD_n321 AVSS 0.0887f
C554 AVDD_n322 AVSS 0.08023f
C555 AVDD_n323 AVSS 0.08504f
C556 AVDD_t9 AVSS 2.21989f
C557 AVDD_t10 AVSS 0.16379f
C558 AVDD_n324 AVSS 0.07084f
C559 AVDD_n325 AVSS 0.06714f
C560 AVDD_n326 AVSS 0.01523f
C561 AVDD_n327 AVSS 0.07684f
C562 AVDD_n328 AVSS 0.15009f
C563 AVDD_n329 AVSS 0.11719f
C564 AVDD_n330 AVSS 0.06193f
C565 AVDD_n331 AVSS 0.08954f
C566 AVDD_n332 AVSS 0.06939f
C567 AVDD_n333 AVSS 0.09994f
C568 AVDD_n334 AVSS 0.02034f
C569 AVDD_n335 AVSS 0.47064f
C570 AVDD_n336 AVSS 1.22934f
C571 AVDD_n337 AVSS 0.31398f
C572 AVDD_t30 AVSS 2.15135f
C573 AVDD_n339 AVSS 1.22934f
C574 AVDD_n340 AVSS 0.10542f
C575 AVDD_n341 AVSS 0.10645f
C576 AVDD_n342 AVSS 0.04173f
C577 AVDD_n343 AVSS 0.01294f
C578 AVDD_n344 AVSS 0.0111f
C579 AVDD_n345 AVSS 0.0111f
C580 AVDD_n346 AVSS 0.01281f
C581 AVDD_n347 AVSS 0.01281f
C582 AVDD_n348 AVSS 0.0111f
C583 AVDD_n349 AVSS 0.0111f
C584 AVDD_n350 AVSS 0.0111f
C585 AVDD_n351 AVSS 0.0111f
C586 AVDD_n352 AVSS 0.01091f
C587 AVDD_n353 AVSS 0.07546f
C588 AVDD_n354 AVSS 0.06902f
C589 AVDD_t1 AVSS 0.06294f
C590 AVDD_n355 AVSS 0.03863f
C591 AVDD_t0 AVSS 0.91469f
C592 AVDD_n356 AVSS 0.02353f
C593 AVDD_n357 AVSS 0.05103f
C594 AVDD_n358 AVSS 0.05621f
C595 AVDD_t25 AVSS 0.07951f
C596 AVDD_n359 AVSS 0.0321f
C597 AVDD_t24 AVSS 0.73729f
C598 AVDD_n361 AVSS 0.02353f
C599 AVDD_n362 AVSS 0.05465f
C600 AVDD_t5 AVSS 0.12579f
C601 AVDD_t4 AVSS 0.71404f
C602 AVDD_n363 AVSS 0.14416f
C603 AVDD_t19 AVSS 0.67142f
C604 AVDD_t20 AVSS 0.12953f
C605 AVDD_n364 AVSS 0.15002f
C606 AVDD_t22 AVSS 0.65988f
C607 AVDD_t23 AVSS 0.11896f
C608 AVDD_n365 AVSS 0.15002f
C609 AVDD_t2 AVSS 0.66565f
C610 AVDD_t3 AVSS 0.02249f
C611 AVDD_n366 AVSS 0.18353f
C612 AVDD_n367 AVSS 1.97424f
C613 AVDD_n368 AVSS 1.17964f
C614 AVDD_n369 AVSS 1.33921f
C615 AVDD_n370 AVSS 0.766f
C616 AVDD_n371 AVSS 0.43259f
C617 AVDD_n372 AVSS 0.19432f
C618 pn23_t0 AVSS 3.21f
C619 pn4_t0 AVSS 0.40638f
C620 pn4_t1 AVSS 4.18256f
C621 pn4_n0 AVSS 2.08727f
C622 pn3_t0 AVSS 2.74039f
C623 pn3_t1 AVSS 3.1174f
C624 pn3_n0 AVSS 1.03375f
C625 pn3_t2 AVSS 0.36355f
C626 pn3_n1 AVSS 0.97031f
C627 pn22_t2 AVSS 0.03615f
C628 pn22_t1 AVSS 0.37382f
C629 pn22_n0 AVSS 0.10113f
C630 pn22_t0 AVSS 1.75737f
C631 pn22_n1 AVSS 1.30479f
C632 pn5_t2 AVSS 0.40362f
C633 pn5_t1 AVSS 3.14324f
C634 pn5_t0 AVSS 0.45513f
C635 pn5_n0 AVSS 5.17583f
C636 pn5_n1 AVSS 0.15673f
C637 pn20_t1 AVSS 0.39153f
C638 pn20_t2 AVSS 0.03213f
C639 pn20_n0 AVSS 0.16018f
C640 pn20_t0 AVSS 0.90984f
C641 pn20_n1 AVSS 0.25844f
C642 pn21_t2 AVSS 0.42402f
C643 pn21_t1 AVSS 0.0408f
C644 pn21_n0 AVSS 0.15753f
C645 pn21_t0 AVSS 1.76743f
C646 pn21_n1 AVSS 0.24539f
C647 S5_n0 AVSS 0.37773f
C648 S5_n1 AVSS 2.78459f
C649 S0_n0 AVSS 0.41411f
C650 pn19_t1 AVSS 0.10321f
C651 pn19_t0 AVSS 0.03999f
C652 pn19_n0 AVSS 0.55402f
C653 pn13_n0 AVSS 0.08693f
C654 pn13_n1 AVSS 0.03464f
C655 pn13_n2 AVSS 0.03488f
C656 pn13_n3 AVSS 0.03466f
C657 pn13_n4 AVSS 0.02529f
C658 pn13_n5 AVSS 0.01896f
C659 pn13_n6 AVSS 0.02519f
C660 pn13_n7 AVSS 0.03515f
C661 pn13_n8 AVSS 0.03514f
C662 pn13_n9 AVSS 0.03488f
C663 pn13_n10 AVSS 1.7493f
C664 pn13_t0 AVSS 0.02742f
C665 pn13_t11 AVSS 0.39684f
C666 pn13_n11 AVSS 0.48717f
C667 pn13_t6 AVSS 0.04233f
C668 pn13_t10 AVSS 0.36639f
C669 pn13_n12 AVSS 0.47439f
C670 pn13_n13 AVSS 1.3041f
C671 pn13_t5 AVSS 0.03842f
C672 pn13_t4 AVSS 0.3767f
C673 pn13_n14 AVSS 0.47439f
C674 pn13_n15 AVSS 1.49378f
C675 pn13_t2 AVSS 0.03835f
C676 pn13_t7 AVSS 0.4161f
C677 pn13_n16 AVSS 0.48904f
C678 pn13_n17 AVSS 1.70009f
C679 pn13_t9 AVSS 0.02979f
C680 pn13_t8 AVSS 0.37828f
C681 pn13_n18 AVSS 0.50858f
C682 pn13_n19 AVSS 1.35447f
C683 pn13_t1 AVSS 0.08421f
C684 pn13_t3 AVSS 0.38842f
C685 pn13_n20 AVSS 0.33373f
C686 pn13_n21 AVSS 0.96146f
C687 pn13_n22 AVSS 1.40956f
C688 S1_n0 AVSS 0.42582f
C689 pn17_t0 AVSS 0.11535f
C690 pn17_t1 AVSS 0.03718f
C691 pn17_n0 AVSS 0.50178f
C692 S2_n0 AVSS 0.90676f
C693 pn18_t0 AVSS 0.15406f
C694 pn18_t1 AVSS 0.0326f
C695 pn18_n0 AVSS 0.47007f
C696 S3_n0 AVSS 2.76564f
C697 pn14_t1 AVSS 0.1663f
C698 pn14_t0 AVSS 0.03817f
C699 pn14_n0 AVSS 0.55481f
C700 S4_n0 AVSS 3.44035f
C701 pn15_t1 AVSS 0.15404f
C702 pn15_t0 AVSS 0.03709f
C703 pn15_n0 AVSS 0.53907f
C704 pn16_t1 AVSS 0.04865f
C705 pn16_t0 AVSS 0.09408f
C706 pn16_n0 AVSS 0.45552f
C707 pn30_t11 AVSS 1.71923f
C708 pn30_t1 AVSS 1.71923f
C709 pn30_t7 AVSS 1.71922f
C710 pn30_t5 AVSS 1.71921f
C711 pn30_t13 AVSS 1.71922f
C712 pn30_t9 AVSS 1.71922f
C713 pn30_t3 AVSS 1.76826f
C714 pn30_n0 AVSS 0.1859f
C715 pn30_n1 AVSS 0.13323f
C716 pn30_n2 AVSS 0.13324f
C717 pn30_n3 AVSS 0.13323f
C718 pn30_n4 AVSS 0.13323f
C719 pn30_n5 AVSS 0.17321f
C720 pn30_t15 AVSS 3.54694f
C721 pn30_n6 AVSS 2.34441f
C722 pn30_n7 AVSS 0.2734f
C723 pn30_n8 AVSS 0.16702f
C724 pn30_n9 AVSS 0.16702f
C725 pn30_n10 AVSS 0.16702f
C726 pn30_n11 AVSS 0.16702f
C727 pn30_n12 AVSS 0.16522f
C728 pn30_n13 AVSS 0.89479f
C729 pn30_n14 AVSS 0.89469f
C730 pn30_n15 AVSS 0.16509f
C731 pn30_n16 AVSS 0.16702f
C732 pn30_n17 AVSS 0.16702f
C733 pn30_n18 AVSS 0.16702f
C734 pn30_n19 AVSS 0.16702f
C735 pn30_n20 AVSS 0.14951f
C736 pn30_n21 AVSS 0.07489f
C737 pn30_n22 AVSS 0.09414f
C738 pn30_n23 AVSS 0.1416f
C739 pn24_t11 AVSS 0.87133f
C740 pn24_t1 AVSS 4.12963f
C741 pn24_t0 AVSS 0.86846f
C742 pn24_t2 AVSS 0.86848f
C743 pn24_n0 AVSS 0.44633f
C744 pn24_n1 AVSS 0.48198f
C745 pn24_t5 AVSS 2.08697f
C746 pn24_t4 AVSS 2.087f
C747 pn24_t8 AVSS 2.087f
C748 pn24_t10 AVSS 2.08697f
C749 pn24_t9 AVSS 2.087f
C750 pn24_t3 AVSS 2.08701f
C751 pn24_t7 AVSS 2.19124f
C752 pn24_n2 AVSS 0.3293f
C753 pn24_n3 AVSS 0.23601f
C754 pn24_n4 AVSS 0.23605f
C755 pn24_n5 AVSS 0.23602f
C756 pn24_n6 AVSS 0.23602f
C757 pn24_n7 AVSS 0.22119f
C758 pn24_t6 AVSS 2.09568f
C759 pn24_n8 AVSS 0.87461f
C760 pn24_n9 AVSS 3.08698f
C761 pn24_t12 AVSS 0.8122f
C762 pn24_n10 AVSS 0.93685f
C763 pn12_n0 AVSS 0.04842f
C764 pn12_n1 AVSS 0.11673f
C765 pn12_n2 AVSS 1.88358f
C766 pn12_t2 AVSS 0.83188f
C767 pn12_t1 AVSS 0.61183f
C768 pn12_n3 AVSS 0.69271f
C769 pn12_n4 AVSS 2.39188f
C770 pn12_n5 AVSS 1.10748f
C771 pn12_n6 AVSS 0.3016f
C772 pn12_n7 AVSS 0.02598f
C773 pn12_n8 AVSS 0.04903f
C774 pn28_t1 AVSS 0.1291f
C775 pn28_n0 AVSS 0.80127f
C776 pn28_n1 AVSS 6.26948f
C777 pn6_t1 AVSS 5.38872f
C778 pn6_n0 AVSS 1.46662f
C779 pn6_t0 AVSS 3.15424f
C780 pn6_n1 AVSS 2.41717f
C781 pn6_n2 AVSS 0.10105f
C782 V_IN2_t0 AVSS 0.4528f
C783 pn29_t0 AVSS 0.6534f
C784 pn29_t1 AVSS 2.0498f
C785 pn29_t2 AVSS 1.09518f
C786 pn29_n0 AVSS 2.00168f
C787 pn29_n1 AVSS 2.61778f
C788 V_OUT2_t3 AVSS 0.18094f
C789 V_OUT2_t2 AVSS 1.11999f
C790 V_OUT2_n0 AVSS 0.62958f
C791 V_OUT2_t1 AVSS 0.54428f
C792 V_OUT2_n1 AVSS 1.53377f
C793 V_OUT2_t0 AVSS 0.85547f
C794 V_OUT2_n2 AVSS 4.38445f
C795 pn27_t1 AVSS 1.50914f
C796 pn27_t0 AVSS 0.36791f
C797 pn27_n0 AVSS 1.29264f
C798 pn27_t4 AVSS 0.72727f
C799 pn27_n1 AVSS 0.71769f
C800 pn27_t3 AVSS 2.73022f
C801 pn27_n2 AVSS 1.60198f
C802 pn27_t2 AVSS 1.01976f
C803 pn27_n3 AVSS 0.98568f
C804 pn27_n4 AVSS 2.15674f
C805 pn10_t1 AVSS 0.57254f
C806 pn10_n0 AVSS 5.22615f
C807 pn10_t0 AVSS 1.26009f
C808 pn10_n1 AVSS 0.32342f
C809 pn2_t0 AVSS 1.88444f
C810 pn2_t1 AVSS 0.45923f
C811 pn2_n0 AVSS 0.39724f
C812 pn2_n1 AVSS 3.14406f
C813 pn7_t2 AVSS 6.20316f
C814 pn7_n0 AVSS 0.56196f
C815 pn7_t1 AVSS 0.17033f
C816 pn7_t0 AVSS 4.55127f
C817 pn7_n1 AVSS 0.7649f
C818 pn7_n2 AVSS 0.61049f
C819 pn7_n3 AVSS 0.10959f
C820 pn25_t0 AVSS 1.2112f
C821 pn25_t2 AVSS 0.59659f
C822 pn25_n0 AVSS 0.75992f
C823 pn25_n1 AVSS 0.31707f
C824 V_CM_n0 AVSS 0.11349f
C825 V_CM_n1 AVSS 0.04692f
C826 V_CM_n2 AVSS 0.1661f
C827 V_CM_n3 AVSS 0.04761f
C828 V_CM_n4 AVSS 0.04663f
C829 V_CM_n5 AVSS 2.13746f
C830 pn26_t1 AVSS 0.59434f
C831 pn26_t2 AVSS 0.92494f
C832 pn26_t0 AVSS 1.09692f
C833 pn26_n0 AVSS 1.61414f
C834 pn26_n1 AVSS 4.8125f
C835 pn11_t0 AVSS 2.08481f
C836 pn11_t2 AVSS 1.56124f
C837 pn11_n0 AVSS 1.22802f
C838 pn11_n1 AVSS 0.69608f
C839 I_BIAS_n0 AVSS 0.08556f
C840 I_BIAS_t1 AVSS 0.08905f
C841 I_BIAS_n2 AVSS 0.02011f
C842 I_BIAS_n3 AVSS 0.01335f
C843 I_BIAS_n4 AVSS 0.12276f
C844 pn9_t0 AVSS 0.11779f
C845 pn9_t1 AVSS 0.52381f
C846 pn9_n0 AVSS 0.11377f
C847 pn1_t0 AVSS 1.3088f
XCM_1 pn8 V_OUT2 cap_cmomi w=10.200u l=8.650u mmin=1 mmax=4 feed=double subblock=0 m=1
XCM_2 pn8 V_OUT2 cap_cmomi w=10.200u l=8.650u mmin=1 mmax=4 feed=double subblock=0 m=1
XCM_3 pn8 V_OUT2 cap_cmomi w=10.200u l=8.650u mmin=1 mmax=4 feed=double subblock=0 m=1
XCM_4 pn8 V_OUT2 cap_cmomi w=10.200u l=8.650u mmin=1 mmax=4 feed=double subblock=0 m=1
XCM_5 pn26 V_OUT2 cap_cmomi w=26.160u l=25.560u mmin=1 mmax=4 feed=double subblock=0 m=1
.ends gain_network
