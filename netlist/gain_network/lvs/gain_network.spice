** sch_path: /foss/designs/sg13cmos5l_spma_ip__instramp/xschem/gain_network/gain_network.sch
.subckt gain_network S4 S5 S0 S2 S1 S3 AVDD V_CM V_IN2 V_OUT2 I_BIAS AVSS
*.PININFO I_BIAS:I V_IN2:I V_CM:I AVSS:I AVDD:I V_OUT2:O S5:I S4:I S3:I S2:I S1:I S0:I
x13 net8 S5 AVDD AVSS sg13cmos5l_inv_1
x12 net9 S4 AVDD AVSS sg13cmos5l_inv_1
x11 net10 S3 AVDD AVSS sg13cmos5l_inv_1
x10 net11 S2 AVDD AVSS sg13cmos5l_inv_1
x9 net12 S1 AVDD AVSS sg13cmos5l_inv_1
x8 net13 S0 AVDD AVSS sg13cmos5l_inv_1
x7 net7 AVSS AVDD S5 net8 net6 tgate l=0.13e-6 wn=0.18e-6 wp=0.54e-6
x6 net7 AVSS AVDD S4 net9 net5 tgate l=0.13e-6 wn=0.18e-6 wp=0.54e-6
x5 net7 AVSS AVDD S3 net10 net4 tgate l=0.13e-6 wn=0.18e-6 wp=0.54e-6
x4 net7 AVSS AVDD S2 net11 net3 tgate l=0.13e-6 wn=0.2e-6 wp=0.6e-6
x3 net7 AVSS AVDD S1 net12 net2 tgate l=0.13e-6 wn=0.3e-6 wp=0.9e-6
x2 net7 AVSS AVDD S0 net13 net1 tgate l=0.13e-6 wn=0.4e-6 wp=1.2e-6
RR6 net5 net4 160k $SUB=AVSS $[rhigh] w=0.5e-6 l=54e-6 b=0
RR5 net4 net3 80k $SUB=AVSS $[rhigh] w=0.5e-6 l=26.95e-6 b=0
x1 AVDD V_CM net7 V_OUT2 I_BIAS AVSS gain_ota
RR1 net7 V_IN2 20.01k $SUB=AVSS $[rhigh] w=0.5e-6 l=6.66e-6 b=0
RR2 V_OUT2 net1 9.781k $SUB=AVSS $[rhigh] w=0.5e-6 l=3.2e-6 b=0
RR3 net1 net2 20.01k $SUB=AVSS $[rhigh] w=0.5e-6 l=6.66e-6 b=0
RR4 net2 net3 40k $SUB=AVSS $[rhigh] w=0.5e-6 l=13.42e-6 b=0
RR7 net14 net5 160k $SUB=AVSS $[rhigh] w=0.5e-6 l=54e-6 b=0
RR8 net6 net14 160k $SUB=AVSS $[rhigh] w=0.5e-6 l=54e-6 b=0
.ends

* expanding   symbol:  sg13cmos5l_stdcells/sg13cmos5l_inv_1.sym # of pins=2
** sym_path: /foss/designs/IHP-Open-PDK/ihp-sg13cmos5l/libs.tech/xschem/sg13cmos5l_stdcells/sg13cmos5l_inv_1.sym
** sch_path: /foss/designs/IHP-Open-PDK/ihp-sg13cmos5l/libs.ref/sg13cmos5l_stdcell/sch/xschem/sg13cmos5l_inv_1.sch
.subckt sg13cmos5l_inv_1 Y A VDD VSS

*.PININFO Y:O A:I
MM1 Y A VSS VSS sg13_lv_nmos w=740.00n l=130.00n ng=1
MM2 Y A VDD VDD sg13_lv_pmos w=1.12u l=130.00n ng=1
.ends

* expanding   symbol:  tgate.sym # of pins=6
** sym_path: /foss/designs/sg13cmos5l_spma_ip__instramp/xschem/tgate/tgate.sym
** sch_path: /foss/designs/sg13cmos5l_spma_ip__instramp/xschem/tgate/tgate.sch
.subckt tgate IN AVSS AVDD EN ENB OUT  l=0.13e-6 wn=1e-6 wp=3e-6
*.PININFO AVDD:B AVSS:B IN:B OUT:B EN:I ENB:I
MM1 IN EN OUT AVSS sg13_lv_nmos w=wn l=l ng=1
MM2 OUT ENB IN AVDD sg13_lv_pmos w=wp l=l ng=1
.ends

* expanding   symbol:  gain_ota.sym # of pins=6
** sym_path: /foss/designs/sg13cmos5l_spma_ip__instramp/xschem/gain_ota/gain_ota.sym
** sch_path: /foss/designs/sg13cmos5l_spma_ip__instramp/xschem/gain_ota/gain_ota.sch
.subckt gain_ota VDD V_inp V_inn V_out I_bias VSS
*.PININFO V_inn:I VDD:I VSS:I V_out:O I_bias:I V_inp:I
MM1 F1 V_inn net6 VDD sg13_lv_pmos w=26.56u l=2u ng=4
MM2 F2 V_inp net6 VDD sg13_lv_pmos w=26.56u l=2u ng=4
MM3 net5 net5 VDD VDD sg13_lv_pmos w=7.33u l=2u ng=1
MM4 N_A net5 VDD VDD sg13_lv_pmos w=7.33u l=2u ng=1
MM7 F1 V_bn2 VSS VSS sg13_lv_nmos w=9.21u l=2u ng=1
MM8 F2 V_bn2 VSS VSS sg13_lv_nmos w=9.21u l=2u ng=1
MM_tail net6 V_btail VDD VDD sg13_lv_pmos w=7.46u l=2u ng=1 m=8
MM_ctrlp N_B V_ctrlp N_A VDD sg13_lv_pmos w=2.20u l=0.50u ng=1
MM_outp V_out N_A VDD VDD sg13_lv_pmos w=22.20u l=0.5u ng=4
MM_ctrln N_A V_ctrln N_B VSS sg13_lv_nmos w=0.84u l=0.5u ng=1
MM_outn V_out N_B VSS VSS sg13_lv_nmos w=8.4u l=0.5u ng=1
MM5 net5 V_bn1 F1 VSS sg13_lv_nmos w=6.41u l=2u ng=1
MM6 N_A V_bn1 F2 VSS sg13_lv_nmos w=6.41u l=2u ng=1
MM_mp1 net1 net1 VDD VDD sg13_lv_pmos w=2.30u l=2u ng=1
MM_mn1 net1 I_bias VSS VSS sg13_lv_nmos w=0.87u l=2u ng=1
MM_refn I_bias I_bias VSS VSS sg13_lv_nmos w=0.87u l=2u ng=1
MM_mp2 V_bn1 net1 VDD VDD sg13_lv_pmos w=11.50u l=2u ng=2
MM_mp3 V_bn2 net1 VDD VDD sg13_lv_pmos w=23u l=2u ng=4
MM_bn1 V_bn1 V_bn1 net2 VSS sg13_lv_nmos w=1.60u l=2u ng=1
MM_bn2 V_bn2 V_bn2 VSS VSS sg13_lv_nmos w=9.21u l=2u ng=1
MM_mn2 V_btail I_bias VSS VSS sg13_lv_nmos w=6u l=2u ng=1
MM_rep_tail V_btail V_btail VDD VDD sg13_lv_pmos w=7.46u l=2u ng=1 m=8
MM_mn4 N_B I_bias VSS VSS sg13_lv_nmos w=3.2u l=2u ng=1
RR1 net2 VSS 44.67k $SUB=VSS $[rhigh] w=0.5e-6 l=15e-6 b=0
MM_mp4 V_ctrln net1 VDD VDD sg13_lv_pmos w=4.60u l=2u ng=1
MM_rep_ctrln V_ctrln V_ctrln net3 VSS sg13_lv_nmos w=0.84u l=0.5u ng=1
MM_rep_outn net3 net3 VSS VSS sg13_lv_nmos w=2.10u l=0.5u ng=1
MM_mn3 V_ctrlp I_bias VSS VSS sg13_lv_nmos w=1.74u l=2u ng=1
MM_rep_outp net4 net4 VDD VDD sg13_lv_pmos w=5.55u l=0.5u ng=1
MM_rep_ctrlp V_ctrlp V_ctrlp net4 VDD sg13_lv_pmos w=2.20u l=0.50u ng=1
MM_mp5 N_A net1 VDD VDD sg13_lv_pmos w=9.21u l=2u ng=1
RR2 N_A net7 12.15k $SUB=VSS $[rhigh] w=0.5e-6 l=4e-6 b=0
CC3_1 V_out F2 cap_cmomi w=25e-6 l=25e-6 m=1
CC4_1 net7 V_out cap_cmomi w=8.5e-6 l=8.5e-6 m=1
CC4_2 net7 V_out cap_cmomi w=8.5e-6 l=8.5e-6 m=1
CC4_3 net7 V_out cap_cmomi w=8.5e-6 l=8.5e-6 m=1
CC4_4 net7 V_out cap_cmomi w=8.5e-6 l=8.5e-6 m=1
.ends
