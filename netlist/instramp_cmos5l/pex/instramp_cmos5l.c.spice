** post-layout netlist of instramp_cmos5l: kpex -> ngspice by scripts/pex_netlist.py (source: /foss/designs/sg13cmos5l_spma_ip__instramp/runs/pex/instramp_cmos5l/kpex/instramp_cmos5l__instramp_cmos5l/instramp_cmos5l_k25d_pex_netlist.spice)
.subckt instramp_cmos5l VSS VDD IBIAS VINN VOUT VINP CM
XM_1 n735 n734 VSS VSS sg13_lv_nmos L=5U W=5U AS=1.8P AD=0.95P PS=10.72U PD=5.38U rfmode=0
XM_2 VSS n734 n735 VSS sg13_lv_nmos L=5U W=5U AS=0.95P AD=1.7P PS=5.38U PD=10.68U rfmode=0
XM_3 n423 n423 VSS VSS sg13_lv_nmos L=5U W=5U AS=1.7P AD=0.95P PS=10.68U PD=5.38U rfmode=0
XM_4 VSS n423 n423 VSS sg13_lv_nmos L=5U W=5U AS=0.95P AD=1.8P PS=5.38U PD=10.72U rfmode=0
XM_5 n424 n423 VSS VSS sg13_lv_nmos L=5U W=5U AS=1.8P AD=0.95P PS=10.72U PD=5.38U rfmode=0
XM_6 VSS n423 n424 VSS sg13_lv_nmos L=5U W=5U AS=0.95P AD=1.7P PS=5.38U PD=10.68U rfmode=0
XM_7 n76 n75 VSS VSS sg13_lv_nmos L=5U W=5U AS=1.8P AD=0.95P PS=10.72U PD=5.38U rfmode=0
XM_8 VSS n75 n76 VSS sg13_lv_nmos L=5U W=5U AS=0.95P AD=1.7P PS=5.38U PD=10.68U rfmode=0
XM_9 n75 n75 VSS VSS sg13_lv_nmos L=5U W=5U AS=1.7P AD=0.95P PS=10.68U PD=5.38U rfmode=0
XM_10 VSS n75 n75 VSS sg13_lv_nmos L=5U W=5U AS=0.95P AD=1.8P PS=5.38U PD=10.72U rfmode=0
XM_11 n77 n76 VSS VSS sg13_lv_nmos L=3U W=5U AS=1.8P AD=0.95P PS=10.72U PD=5.38U rfmode=0
XM_12 VSS n76 n77 VSS sg13_lv_nmos L=3U W=5U AS=0.95P AD=0.95P PS=5.38U PD=5.38U rfmode=0
XM_13 n77 n76 VSS VSS sg13_lv_nmos L=3U W=5U AS=0.95P AD=0.95P PS=5.38U PD=5.38U rfmode=0
XM_14 VSS n76 n77 VSS sg13_lv_nmos L=3U W=5U AS=0.95P AD=1.7P PS=5.38U PD=10.68U rfmode=0
XM_15 VOUT n424 VSS VSS sg13_lv_nmos L=3U W=5U AS=1.8P AD=0.95P PS=10.72U PD=5.38U rfmode=0
XM_16 VSS n424 VOUT VSS sg13_lv_nmos L=3U W=5U AS=0.95P AD=0.95P PS=5.38U PD=5.38U rfmode=0
XM_17 VOUT n424 VSS VSS sg13_lv_nmos L=3U W=5U AS=0.95P AD=0.95P PS=5.38U PD=5.38U rfmode=0
XM_18 VSS n424 VOUT VSS sg13_lv_nmos L=3U W=5U AS=0.95P AD=1.7P PS=5.38U PD=10.68U rfmode=0
XM_19 n736 n735 VSS VSS sg13_lv_nmos L=3U W=5U AS=1.8P AD=0.95P PS=10.72U PD=5.38U rfmode=0
XM_20 VSS n735 n736 VSS sg13_lv_nmos L=3U W=5U AS=0.95P AD=0.95P PS=5.38U PD=5.38U rfmode=0
XM_21 n736 n735 VSS VSS sg13_lv_nmos L=3U W=5U AS=0.95P AD=0.95P PS=5.38U PD=5.38U rfmode=0
XM_22 VSS n735 n736 VSS sg13_lv_nmos L=3U W=5U AS=0.95P AD=1.7P PS=5.38U PD=10.68U rfmode=0
XM_23 n734 n734 VSS VSS sg13_lv_nmos L=5U W=5U AS=1.7P AD=0.95P PS=10.68U PD=5.38U rfmode=0
XM_24 VSS n734 n734 VSS sg13_lv_nmos L=5U W=5U AS=0.95P AD=1.8P PS=5.38U PD=10.72U rfmode=0
XM_25 n75 n73 n153 VDD sg13_lv_pmos L=3U W=5U AS=1.7P AD=0.95P PS=10.68U PD=5.38U rfmode=0
XM_26 n153 n73 n75 VDD sg13_lv_pmos L=3U W=5U AS=0.95P AD=0.95P PS=5.38U PD=5.38U rfmode=0
XM_27 n75 n73 n153 VDD sg13_lv_pmos L=3U W=5U AS=0.95P AD=0.95P PS=5.38U PD=5.38U rfmode=0
XM_28 n153 n73 n75 VDD sg13_lv_pmos L=3U W=5U AS=0.95P AD=1.7P PS=5.38U PD=10.68U rfmode=0
XM_29 n76 VINP n153 VDD sg13_lv_pmos L=3U W=5U AS=1.7P AD=0.95P PS=10.68U PD=5.38U rfmode=0
XM_30 n153 VINP n76 VDD sg13_lv_pmos L=3U W=5U AS=0.95P AD=0.95P PS=5.38U PD=5.38U rfmode=0
XM_31 n76 VINP n153 VDD sg13_lv_pmos L=3U W=5U AS=0.95P AD=0.95P PS=5.38U PD=5.38U rfmode=0
XM_32 n153 VINP n76 VDD sg13_lv_pmos L=3U W=5U AS=0.95P AD=1.7P PS=5.38U PD=10.68U rfmode=0
XM_33 VDD IBIAS IBIAS VDD sg13_lv_pmos L=0.15U W=0.15U AS=0.1005P AD=0.1545P PS=1.34U PD=1.7U rfmode=0
XM_34 VDD IBIAS n153 VDD sg13_lv_pmos L=0.15U W=0.15U AS=0.1005P AD=0.1545P PS=1.34U PD=1.7U rfmode=0
XM_35 VDD IBIAS n153 VDD sg13_lv_pmos L=0.15U W=0.15U AS=0.1005P AD=0.1545P PS=1.34U PD=1.7U rfmode=0
XM_36 VDD IBIAS n153 VDD sg13_lv_pmos L=0.15U W=0.15U AS=0.1005P AD=0.1545P PS=1.34U PD=1.7U rfmode=0
XM_37 VDD IBIAS n153 VDD sg13_lv_pmos L=0.15U W=0.15U AS=0.1005P AD=0.1545P PS=1.34U PD=1.7U rfmode=0
XM_38 VDD IBIAS n77 VDD sg13_lv_pmos L=0.15U W=0.15U AS=0.1005P AD=0.1545P PS=1.34U PD=1.7U rfmode=0
XM_39 VDD IBIAS n77 VDD sg13_lv_pmos L=0.15U W=0.15U AS=0.1005P AD=0.1545P PS=1.34U PD=1.7U rfmode=0
XM_40 VDD IBIAS n77 VDD sg13_lv_pmos L=0.15U W=0.15U AS=0.1005P AD=0.1545P PS=1.34U PD=1.7U rfmode=0
XM_41 VDD IBIAS n77 VDD sg13_lv_pmos L=0.15U W=0.15U AS=0.1005P AD=0.1545P PS=1.34U PD=1.7U rfmode=0
XM_42 VDD IBIAS n77 VDD sg13_lv_pmos L=0.15U W=0.15U AS=0.1005P AD=0.1545P PS=1.34U PD=1.7U rfmode=0
XM_43 VDD IBIAS n77 VDD sg13_lv_pmos L=0.15U W=0.15U AS=0.1005P AD=0.1545P PS=1.34U PD=1.7U rfmode=0
XM_44 VDD IBIAS n77 VDD sg13_lv_pmos L=0.15U W=0.15U AS=0.1005P AD=0.1545P PS=1.34U PD=1.7U rfmode=0
XM_45 VDD IBIAS n77 VDD sg13_lv_pmos L=0.15U W=0.15U AS=0.1005P AD=0.1545P PS=1.34U PD=1.7U rfmode=0
XM_46 IBIAS IBIAS VDD VDD sg13_lv_pmos L=0.15U W=0.15U AS=0.1545P AD=0.1005P PS=1.7U PD=1.34U rfmode=0
XM_47 n417 IBIAS VDD VDD sg13_lv_pmos L=0.15U W=0.15U AS=0.1545P AD=0.1005P PS=1.7U PD=1.34U rfmode=0
XM_48 n417 IBIAS VDD VDD sg13_lv_pmos L=0.15U W=0.15U AS=0.1545P AD=0.1005P PS=1.7U PD=1.34U rfmode=0
XM_49 n417 IBIAS VDD VDD sg13_lv_pmos L=0.15U W=0.15U AS=0.1545P AD=0.1005P PS=1.7U PD=1.34U rfmode=0
XM_50 n417 IBIAS VDD VDD sg13_lv_pmos L=0.15U W=0.15U AS=0.1545P AD=0.1005P PS=1.7U PD=1.34U rfmode=0
XM_51 VOUT IBIAS VDD VDD sg13_lv_pmos L=0.15U W=0.15U AS=0.1545P AD=0.1005P PS=1.7U PD=1.34U rfmode=0
XM_52 VOUT IBIAS VDD VDD sg13_lv_pmos L=0.15U W=0.15U AS=0.1545P AD=0.1005P PS=1.7U PD=1.34U rfmode=0
XM_53 VOUT IBIAS VDD VDD sg13_lv_pmos L=0.15U W=0.15U AS=0.1545P AD=0.1005P PS=1.7U PD=1.34U rfmode=0
XM_54 VOUT IBIAS VDD VDD sg13_lv_pmos L=0.15U W=0.15U AS=0.1545P AD=0.1005P PS=1.7U PD=1.34U rfmode=0
XM_55 VOUT IBIAS VDD VDD sg13_lv_pmos L=0.15U W=0.15U AS=0.1545P AD=0.1005P PS=1.7U PD=1.34U rfmode=0
XM_56 VOUT IBIAS VDD VDD sg13_lv_pmos L=0.15U W=0.15U AS=0.1545P AD=0.1005P PS=1.7U PD=1.34U rfmode=0
XM_57 VOUT IBIAS VDD VDD sg13_lv_pmos L=0.15U W=0.15U AS=0.1545P AD=0.1005P PS=1.7U PD=1.34U rfmode=0
XM_58 VOUT IBIAS VDD VDD sg13_lv_pmos L=0.15U W=0.15U AS=0.1545P AD=0.1005P PS=1.7U PD=1.34U rfmode=0
XM_59 n423 n426 n417 VDD sg13_lv_pmos L=3U W=5U AS=1.7P AD=0.95P PS=10.68U PD=5.38U rfmode=0
XM_60 n417 n426 n423 VDD sg13_lv_pmos L=3U W=5U AS=0.95P AD=0.95P PS=5.38U PD=5.38U rfmode=0
XM_61 n423 n426 n417 VDD sg13_lv_pmos L=3U W=5U AS=0.95P AD=0.95P PS=5.38U PD=5.38U rfmode=0
XM_62 n417 n426 n423 VDD sg13_lv_pmos L=3U W=5U AS=0.95P AD=1.7P PS=5.38U PD=10.68U rfmode=0
XM_63 n424 n4 n417 VDD sg13_lv_pmos L=3U W=5U AS=1.7P AD=0.95P PS=10.68U PD=5.38U rfmode=0
XM_64 n417 n4 n424 VDD sg13_lv_pmos L=3U W=5U AS=0.95P AD=0.95P PS=5.38U PD=5.38U rfmode=0
XM_65 n424 n4 n417 VDD sg13_lv_pmos L=3U W=5U AS=0.95P AD=0.95P PS=5.38U PD=5.38U rfmode=0
XM_66 n417 n4 n424 VDD sg13_lv_pmos L=3U W=5U AS=0.95P AD=1.7P PS=5.38U PD=10.68U rfmode=0
XM_67 n734 n732 n812 VDD sg13_lv_pmos L=3U W=5U AS=1.7P AD=0.95P PS=10.68U PD=5.38U rfmode=0
XM_68 n812 n732 n734 VDD sg13_lv_pmos L=3U W=5U AS=0.95P AD=0.95P PS=5.38U PD=5.38U rfmode=0
XM_69 n734 n732 n812 VDD sg13_lv_pmos L=3U W=5U AS=0.95P AD=0.95P PS=5.38U PD=5.38U rfmode=0
XM_70 n812 n732 n734 VDD sg13_lv_pmos L=3U W=5U AS=0.95P AD=1.7P PS=5.38U PD=10.68U rfmode=0
XM_71 n735 VINN n812 VDD sg13_lv_pmos L=3U W=5U AS=1.7P AD=0.95P PS=10.68U PD=5.38U rfmode=0
XM_72 n812 VINN n735 VDD sg13_lv_pmos L=3U W=5U AS=0.95P AD=0.95P PS=5.38U PD=5.38U rfmode=0
XM_73 n735 VINN n812 VDD sg13_lv_pmos L=3U W=5U AS=0.95P AD=0.95P PS=5.38U PD=5.38U rfmode=0
XM_74 n812 VINN n735 VDD sg13_lv_pmos L=3U W=5U AS=0.95P AD=1.7P PS=5.38U PD=10.68U rfmode=0
XM_75 VDD IBIAS IBIAS VDD sg13_lv_pmos L=0.15U W=0.15U AS=0.1005P AD=0.1545P PS=1.34U PD=1.7U rfmode=0
XM_76 VDD IBIAS n812 VDD sg13_lv_pmos L=0.15U W=0.15U AS=0.1005P AD=0.1545P PS=1.34U PD=1.7U rfmode=0
XM_77 VDD IBIAS n812 VDD sg13_lv_pmos L=0.15U W=0.15U AS=0.1005P AD=0.1545P PS=1.34U PD=1.7U rfmode=0
XM_78 VDD IBIAS n812 VDD sg13_lv_pmos L=0.15U W=0.15U AS=0.1005P AD=0.1545P PS=1.34U PD=1.7U rfmode=0
XM_79 VDD IBIAS n812 VDD sg13_lv_pmos L=0.15U W=0.15U AS=0.1005P AD=0.1545P PS=1.34U PD=1.7U rfmode=0
XM_80 VDD IBIAS n736 VDD sg13_lv_pmos L=0.15U W=0.15U AS=0.1005P AD=0.1545P PS=1.34U PD=1.7U rfmode=0
XM_81 VDD IBIAS n736 VDD sg13_lv_pmos L=0.15U W=0.15U AS=0.1005P AD=0.1545P PS=1.34U PD=1.7U rfmode=0
XM_82 VDD IBIAS n736 VDD sg13_lv_pmos L=0.15U W=0.15U AS=0.1005P AD=0.1545P PS=1.34U PD=1.7U rfmode=0
XM_83 VDD IBIAS n736 VDD sg13_lv_pmos L=0.15U W=0.15U AS=0.1005P AD=0.1545P PS=1.34U PD=1.7U rfmode=0
XM_84 VDD IBIAS n736 VDD sg13_lv_pmos L=0.15U W=0.15U AS=0.1005P AD=0.1545P PS=1.34U PD=1.7U rfmode=0
XM_85 VDD IBIAS n736 VDD sg13_lv_pmos L=0.15U W=0.15U AS=0.1005P AD=0.1545P PS=1.34U PD=1.7U rfmode=0
XM_86 VDD IBIAS n736 VDD sg13_lv_pmos L=0.15U W=0.15U AS=0.1005P AD=0.1545P PS=1.34U PD=1.7U rfmode=0
XM_87 VDD IBIAS n736 VDD sg13_lv_pmos L=0.15U W=0.15U AS=0.1005P AD=0.1545P PS=1.34U PD=1.7U rfmode=0
XR_88 n335 n424 VSS rhigh w=0.5u l=1.95u ps=0 b=0 m=1
XR_89 n77 n73 VSS rhigh w=0.5u l=2.0u ps=0 b=0 m=1
XR_90 n4 CM VSS rhigh w=0.5u l=17.84u ps=0 b=0 m=1
XR_91 n426 n736 VSS rhigh w=0.5u l=2.0u ps=0 b=0 m=1
XR_92 VOUT n426 VSS rhigh w=0.5u l=17.84u ps=0 b=0 m=1
XR_93 n736 n732 VSS rhigh w=0.5u l=2.0u ps=0 b=0 m=1
XR_94 n4 n77 VSS rhigh w=0.5u l=2.0u ps=0 b=0 m=1
XR_95 n76 n246 VSS rhigh w=0.5u l=1.95u ps=0 b=0 m=1
XR_96 n735 n904 VSS rhigh w=0.5u l=1.95u ps=0 b=0 m=1
XC_97 n335 VOUT cap_cmomi w=15e-6 l=15e-6 mmin=1 mmax=4 feed=double subblock=0 m=1
XC_98 n335 VOUT cap_cmomi w=15e-6 l=15e-6 mmin=1 mmax=4 feed=double subblock=0 m=1
XC_99 VOUT n335 cap_cmomi w=15e-6 l=15e-6 mmin=1 mmax=4 feed=double subblock=0 m=1
XC_100 n335 VOUT cap_cmomi w=15e-6 l=15e-6 mmin=1 mmax=4 feed=double subblock=0 m=1
XC_101 VOUT n335 cap_cmomi w=15e-6 l=15e-6 mmin=1 mmax=4 feed=double subblock=0 m=1
XC_102 n335 VOUT cap_cmomi w=15e-6 l=15e-6 mmin=1 mmax=4 feed=double subblock=0 m=1
XC_103 VOUT n335 cap_cmomi w=15e-6 l=15e-6 mmin=1 mmax=4 feed=double subblock=0 m=1
XC_104 VOUT n335 cap_cmomi w=15e-6 l=15e-6 mmin=1 mmax=4 feed=double subblock=0 m=1
XC_105 n335 VOUT cap_cmomi w=15e-6 l=15e-6 mmin=1 mmax=4 feed=double subblock=0 m=1
XC_106 n77 n246 cap_cmomi w=15e-6 l=15e-6 mmin=1 mmax=4 feed=double subblock=0 m=1
XC_107 n77 n246 cap_cmomi w=15e-6 l=15e-6 mmin=1 mmax=4 feed=double subblock=0 m=1
XC_108 n246 n77 cap_cmomi w=15e-6 l=15e-6 mmin=1 mmax=4 feed=double subblock=0 m=1
XC_109 n77 n246 cap_cmomi w=15e-6 l=15e-6 mmin=1 mmax=4 feed=double subblock=0 m=1
XC_110 n246 n77 cap_cmomi w=15e-6 l=15e-6 mmin=1 mmax=4 feed=double subblock=0 m=1
XC_111 n77 n246 cap_cmomi w=15e-6 l=15e-6 mmin=1 mmax=4 feed=double subblock=0 m=1
XC_112 n246 n77 cap_cmomi w=15e-6 l=15e-6 mmin=1 mmax=4 feed=double subblock=0 m=1
XC_113 n246 n77 cap_cmomi w=15e-6 l=15e-6 mmin=1 mmax=4 feed=double subblock=0 m=1
XC_114 n77 n246 cap_cmomi w=15e-6 l=15e-6 mmin=1 mmax=4 feed=double subblock=0 m=1
XC_115 n736 n904 cap_cmomi w=15e-6 l=15e-6 mmin=1 mmax=4 feed=double subblock=0 m=1
XC_116 n736 n904 cap_cmomi w=15e-6 l=15e-6 mmin=1 mmax=4 feed=double subblock=0 m=1
XC_117 n904 n736 cap_cmomi w=15e-6 l=15e-6 mmin=1 mmax=4 feed=double subblock=0 m=1
XC_118 n736 n904 cap_cmomi w=15e-6 l=15e-6 mmin=1 mmax=4 feed=double subblock=0 m=1
XC_119 n904 n736 cap_cmomi w=15e-6 l=15e-6 mmin=1 mmax=4 feed=double subblock=0 m=1
XC_120 n736 n904 cap_cmomi w=15e-6 l=15e-6 mmin=1 mmax=4 feed=double subblock=0 m=1
XC_121 n904 n736 cap_cmomi w=15e-6 l=15e-6 mmin=1 mmax=4 feed=double subblock=0 m=1
XC_122 n904 n736 cap_cmomi w=15e-6 l=15e-6 mmin=1 mmax=4 feed=double subblock=0 m=1
XC_123 n736 n904 cap_cmomi w=15e-6 l=15e-6 mmin=1 mmax=4 feed=double subblock=0 m=1
Cext_1 n153 n246 34.1439a
Cext_2 n153 n4 15.2762a
Cext_3 n153 n73 1.39193f
Cext_4 n153 n75 131.46a
Cext_5 n153 n76 147.701a
Cext_6 n153 n77 223.132a
Cext_7 n153 IBIAS 263.943a
Cext_8 n153 VDD 246.295a
Cext_9 n153 VINP 1.37763f
Cext_10 n153 VSS 2.33263f
Cext_11 n246 n4 30.8462a
Cext_12 n246 n76 28.0876a
Cext_13 n246 n77 962.45a
Cext_14 n246 VDD 5.67793f
Cext_15 n246 VINP 73.5058a
Cext_16 n246 VSS 2.13836f
Cext_17 n246 VSS 7.47724f
Cext_18 n335 n4 73.5058a
Cext_19 n335 n417 34.1439a
Cext_20 n335 n424 28.0876a
Cext_21 n335 n426 83.1417a
Cext_22 n335 VDD 5.67793f
Cext_23 n335 VOUT 528.057a
Cext_24 n335 VSS 2.13836f
Cext_25 n335 VSS 7.55217f
Cext_26 n4 n417 1.40898f
Cext_27 n4 n423 360.757a
Cext_28 n4 n424 2.01243f
Cext_29 n4 n426 678.58a
Cext_30 n4 n73 350.778a
Cext_31 n4 n75 10.3212a
Cext_32 n4 n77 4.61531f
Cext_33 n4 CM 1.23796a
Cext_34 n4 IBIAS 843.041a
Cext_35 n4 VDD 953.669a
Cext_36 n4 VINP 80.6156a
Cext_37 n4 VOUT 33.3628a
Cext_38 n4 VSS 10.3377f
Cext_39 n4 VSS 21.3935f
Cext_40 n417 n423 131.46a
Cext_41 n417 n424 147.701a
Cext_42 n417 n426 1.39193f
Cext_43 n417 IBIAS 278.094a
Cext_44 n417 VDD 260.491a
Cext_45 n417 VOUT 223.132a
Cext_46 n417 VSS 2.33263f
Cext_47 n423 n424 821.414a
Cext_48 n423 n426 2.15584f
Cext_49 n423 IBIAS 61.2214a
Cext_50 n423 VDD 68.8933a
Cext_51 n423 VOUT 15.0233a
Cext_52 n423 VSS 4.03288f
Cext_53 n423 VSS 18.06f
Cext_54 n424 n426 0.178189a
Cext_55 n424 IBIAS 0.597256a
Cext_56 n424 VDD 7.75179a
Cext_57 n424 VOUT 3.90042f
Cext_58 n424 VSS 2.4148f
Cext_59 n424 VSS 13.0574f
Cext_60 n426 n736 4.41489f
Cext_61 n426 n904 30.8091a
Cext_62 n426 CM 4.62607a
Cext_63 n426 IBIAS 1.02876f
Cext_64 n426 VDD 330.34a
Cext_65 n426 VSS 9.93788f
Cext_66 n426 VSS 18.1167f
Cext_67 n73 n75 2.1542f
Cext_68 n73 n76 0.178189a
Cext_69 n73 n77 20.4067a
Cext_70 n73 IBIAS 235.595a
Cext_71 n73 VDD 206.39a
Cext_72 n73 VINP 454.895a
Cext_73 n73 VSS 35.6699a
Cext_74 n73 VSS 11.9294f
Cext_75 n732 n734 2.1545f
Cext_76 n732 n735 0.178189a
Cext_77 n732 n736 20.4067a
Cext_78 n732 n812 1.39193f
Cext_79 n732 IBIAS 655.306a
Cext_80 n732 VDD 301.649a
Cext_81 n732 VINN 454.184a
Cext_82 n732 VSS 35.79a
Cext_83 n732 VSS 11.9176f
Cext_84 n734 n735 821.414a
Cext_85 n734 n736 15.0233a
Cext_86 n734 n812 131.46a
Cext_87 n734 IBIAS 16.7433a
Cext_88 n734 VDD 68.5362a
Cext_89 n734 VINN 356.728a
Cext_90 n734 VSS 4.03283f
Cext_91 n734 VSS 18.0703f
Cext_92 n735 n736 3.90042f
Cext_93 n735 n812 147.701a
Cext_94 n735 n904 28.0876a
Cext_95 n735 IBIAS 0.597256a
Cext_96 n735 VDD 7.75179a
Cext_97 n735 VINN 2.01243f
Cext_98 n735 VSS 2.4148f
Cext_99 n735 VSS 13.0574f
Cext_100 n736 n812 223.132a
Cext_101 n736 n904 962.576a
Cext_102 n736 IBIAS 291.441a
Cext_103 n736 VDD 352.625a
Cext_104 n736 VINN 33.3628a
Cext_105 n736 VSS 10.0149f
Cext_106 n736 VSS 15.2309f
Cext_107 n75 n76 821.414a
Cext_108 n75 n77 15.0233a
Cext_109 n75 IBIAS 5.34089a
Cext_110 n75 VDD 5.27408a
Cext_111 n75 VINP 356.728a
Cext_112 n75 VSS 4.03283f
Cext_113 n75 VSS 18.0703f
Cext_114 n76 n77 3.90042f
Cext_115 n76 IBIAS 0.597256a
Cext_116 n76 VDD 7.75179a
Cext_117 n76 VINP 2.01243f
Cext_118 n76 VSS 2.4148f
Cext_119 n76 VSS 13.0574f
Cext_120 n77 IBIAS 41.3938a
Cext_121 n77 VDD 328.698a
Cext_122 n77 VINP 33.3628a
Cext_123 n77 VSS 10.511f
Cext_124 n77 VSS 15.2394f
Cext_125 n812 n904 34.1439a
Cext_126 n812 IBIAS 280.431a
Cext_127 n812 VDD 260.491a
Cext_128 n812 VINN 1.37763f
Cext_129 n812 VSS 2.33263f
Cext_130 n904 VDD 5.67793f
Cext_131 n904 VINN 73.5058a
Cext_132 n904 VSS 1.92915f
Cext_133 n904 VSS 7.82928f
Cext_134 CM IBIAS 98.6496a
Cext_135 CM VDD 250.562a
Cext_136 CM VSS 586.417a
Cext_137 IBIAS VDD 3.35323f
Cext_138 IBIAS VINN 96.9048a
Cext_139 IBIAS VINP 17.0577a
Cext_140 IBIAS VOUT 41.3938a
Cext_141 IBIAS VSS 81.6486a
Cext_142 IBIAS VSS 10.9702f
Cext_143 VDD VINN 376.888a
Cext_144 VDD VINP 281.597a
Cext_145 VDD VOUT 328.698a
Cext_146 VDD VSS 186.342a
Cext_147 VDD VSS 36.4831f
Cext_148 VINN VSS 6.53905a
Cext_149 VINN VSS 12.5959f
Cext_150 VINP VSS 6.53905a
Cext_151 VINP VSS 12.5973f
Cext_152 VOUT VSS 803.049a
Cext_153 VOUT VSS 9.25812f
Cext_154 VSS VSS 50.9771f
.ends instramp_cmos5l
