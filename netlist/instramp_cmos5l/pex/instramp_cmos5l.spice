** post-layout RC netlist of instramp_cmos5l: Magic extresist -> ngspice by scripts/pex_netlist.py --magic (source: /foss/designs/sg13cmos5l_spma_ip__instramp/runs/pex/instramp_cmos5l/magic/raw.spice)
.subckt instramp_cmos5l VSS VDD IBIAS VINN VOUT VINP CM
X0 VDD_t1 IBIAS_t4 IBIAS_t5 VDD_t0 sg13_lv_pmos ad=0.3345p pd=2.9u as=0.1005p ps=1.34u w=0.15u l=0.15u
X1 pn15_t0 IBIAS_t0 VDD_t19 VDD_t15 sg13_lv_pmos ad=0.1005p pd=1.34u as=0.3345p ps=2.9u w=0.15u l=0.15u
X2 VDD_t2 IBIAS_t4 pn17_t5 VDD_t0 sg13_lv_pmos ad=0.3345p pd=2.9u as=0.1005p ps=1.34u w=0.15u l=0.15u
X3 pn10_t0 pn11_t0 pn17_t3 VDD_t0 sg13_lv_pmos ad=0.95p pd=5.38u as=0.95p ps=5.38u w=5u l=3u
X4 VDD_t11 IBIAS_t4 pn9_t3 VDD_t6 sg13_lv_pmos ad=0.3345p pd=2.9u as=0.1005p ps=1.34u w=0.15u l=0.15u
X5 pn11 pn9 VSS_t11 rhigh l=2u w=0.5u ps=0 b=0 m=1
X6 VDD_t40 IBIAS_t2 pn1_t7 VDD_t31 sg13_lv_pmos ad=0.3345p pd=2.9u as=0.1005p ps=1.34u w=0.15u l=0.15u
X7 VDD_t14 IBIAS_t4 pn9_t7 VDD_t6 sg13_lv_pmos ad=0.3345p pd=2.9u as=0.1005p ps=1.34u w=0.15u l=0.15u
X8 pn17_t3 pn11_t0 pn10_t1 VDD_t0 sg13_lv_pmos ad=0.95p pd=5.38u as=0.95p ps=5.38u w=5u l=3u
X9 pn9_t0 pn18_t3 VSS_t13 VSS_t12 sg13_lv_nmos ad=0.95p pd=5.38u as=3.6p ps=11.44u w=5u l=3u
X10 VDD_t36 IBIAS_t2 pn13_t3 VDD_t29 sg13_lv_pmos ad=0.3345p pd=2.9u as=0.1005p ps=1.34u w=0.15u l=0.15u
X11 pn18_t0 pn10_t4 VSS_t7 VSS_t6 sg13_lv_nmos ad=0.95p pd=5.38u as=3.6p ps=11.44u w=5u l=5u
X12 VSS_t16 pn18_t3 pn9_t1 VSS_t12 sg13_lv_nmos ad=1.7p pd=10.68u as=0.95p ps=5.38u w=5u l=3u
X13 pn16_t2 pn5_t1 pn15_t5 VDD_t15 sg13_lv_pmos ad=0.95p pd=5.38u as=0.95p ps=5.38u w=5u l=3u
X14 VDD_t8 IBIAS_t4 pn9_t9 VDD_t6 sg13_lv_pmos ad=0.3345p pd=2.9u as=0.1005p ps=1.34u w=0.15u l=0.15u
X15 pn10_t1 pn11_t0 pn17 VDD_t0 sg13_lv_pmos ad=0.95p pd=5.38u as=1.7p ps=10.68u w=5u l=3u
X16 pn15_t6 pn5_t1 pn16_t2 VDD_t15 sg13_lv_pmos ad=1.7p pd=10.68u as=0.95p ps=5.38u w=5u l=3u
X17 pn16_t1 pn7 VSS_t38 rhigh l=1.95u w=0.5u ps=0 b=0 m=1
X18 VDD_t7 IBIAS_t4 pn9_t5 VDD_t6 sg13_lv_pmos ad=0.3345p pd=2.9u as=0.1005p ps=1.34u w=0.15u l=0.15u
X19 pn15_t5 pn5_t1 pn16 VDD_t15 sg13_lv_pmos ad=0.95p pd=5.38u as=0.95p ps=5.38u w=5u l=3u
X20 pn14 VINP_t0 pn13_t6 VDD_t31 sg13_lv_pmos ad=0.95p pd=5.38u as=1.7p ps=10.68u w=5u l=3u
X21 pn4 pn14_t2 VSS_t17 rhigh l=1.95u w=0.5u ps=0 b=0 m=1
X22 VOUT_t4 IBIAS_t0 VDD_t25 VDD_t15 sg13_lv_pmos ad=0.1005p pd=1.34u as=0.3345p ps=2.9u w=0.15u l=0.15u
X23 VSS_t36 pn8_t4 pn16_t0 VSS_t8 sg13_lv_nmos ad=1.7p pd=10.68u as=0.95p ps=5.38u w=5u l=5u
X24 pn15_t1 IBIAS_t0 VDD_t20 VDD_t15 sg13_lv_pmos ad=0.1005p pd=1.34u as=0.3345p ps=2.9u w=0.15u l=0.15u
X25 VDD_t41 IBIAS_t2 pn1_t5 VDD_t31 sg13_lv_pmos ad=0.3345p pd=2.9u as=0.1005p ps=1.34u w=0.15u l=0.15u
X26 pn14_t0 pn2_t4 VSS_t23 VSS_t22 sg13_lv_nmos ad=0.95p pd=5.38u as=3.6p ps=11.44u w=5u l=5u
X27 VSS_t41 pn14_t3 pn1_t9 VSS_t39 sg13_lv_nmos ad=0.95p pd=5.38u as=0.95p ps=5.38u w=5u l=3u
X28 VOUT_t8 pn16_t3 VSS_t29 VSS_t28 sg13_lv_nmos ad=0.95p pd=5.38u as=3.6p ps=11.44u w=5u l=3u
X29 VDD_t38 IBIAS_t2 pn1_t0 VDD_t31 sg13_lv_pmos ad=0.3345p pd=2.9u as=0.1005p ps=1.34u w=0.15u l=0.15u
X30 pn2_t0 pn3_t0 pn13 VDD_t29 sg13_lv_pmos ad=0.95p pd=5.38u as=1.7p ps=10.68u w=5u l=3u
X31 pn2_t2 pn2 VSS_t19 VSS_t18 sg13_lv_nmos ad=0.95p pd=5.38u as=1.7p ps=10.68u w=5u l=5u
X32 VDD_t3 IBIAS_t4 pn17_t7 VDD_t0 sg13_lv_pmos ad=0.3345p pd=2.9u as=0.1005p ps=1.34u w=0.15u l=0.15u
X33 pn9_t1 pn18_t3 VSS_t14 VSS_t12 sg13_lv_nmos ad=0.95p pd=5.38u as=0.95p ps=5.38u w=5u l=3u
X34 VSS_t32 pn16_t3 VOUT_t9 VSS_t28 sg13_lv_nmos ad=1.7p pd=10.68u as=0.95p ps=5.38u w=5u l=3u
X35 pn16 pn5_t1 pn15_t4 VDD_t15 sg13_lv_pmos ad=0.95p pd=5.38u as=1.7p ps=10.68u w=5u l=3u
X36 VDD_t33 IBIAS_t2 pn13_t0 VDD_t29 sg13_lv_pmos ad=0.3345p pd=2.9u as=0.1005p ps=1.34u w=0.15u l=0.15u
X37 pn3 pn1 VSS_t1 rhigh l=2u w=0.5u ps=0 b=0 m=1
X38 pn1_t8 pn5_t0 VSS_t0 rhigh l=2u w=0.5u ps=0 b=0 m=1
X39 VDD_t12 IBIAS_t4 pn9_t6 VDD_t6 sg13_lv_pmos ad=0.3345p pd=2.9u as=0.1005p ps=1.34u w=0.15u l=0.15u
X40 VSS_t14 pn18_t3 pn9_t0 VSS_t12 sg13_lv_nmos ad=0.95p pd=5.38u as=0.95p ps=5.38u w=5u l=3u
X41 pn8_t0 pn8 VSS_t33 VSS_t2 sg13_lv_nmos ad=0.95p pd=5.38u as=1.7p ps=10.68u w=5u l=5u
X42 VSS_t5 pn10 pn10_t2 VSS_t4 sg13_lv_nmos ad=3.6p pd=11.44u as=0.95p ps=5.38u w=5u l=5u
X43 pn13_t7 VINP_t0 pn14 VDD_t31 sg13_lv_pmos ad=0.95p pd=5.38u as=0.95p ps=5.38u w=5u l=3u
X44 VDD_t9 IBIAS_t4 pn9_t8 VDD_t6 sg13_lv_pmos ad=0.3345p pd=2.9u as=0.1005p ps=1.34u w=0.15u l=0.15u
X45 VOUT_t5 IBIAS_t0 VDD_t26 VDD_t15 sg13_lv_pmos ad=0.1005p pd=1.34u as=0.3345p ps=2.9u w=0.15u l=0.15u
X46 VDD_t37 IBIAS_t2 pn1_t2 VDD_t31 sg13_lv_pmos ad=0.3345p pd=2.9u as=0.1005p ps=1.34u w=0.15u l=0.15u
X47 pn2_t1 pn3_t0 pn13_t4 VDD_t29 sg13_lv_pmos ad=0.95p pd=5.38u as=0.95p ps=5.38u w=5u l=3u
X48 VOUT_t0 IBIAS_t0 VDD_t22 VDD_t15 sg13_lv_pmos ad=0.1005p pd=1.34u as=0.3345p ps=2.9u w=0.15u l=0.15u
X49 VOUT_t9 pn16_t3 VSS_t30 VSS_t28 sg13_lv_nmos ad=0.95p pd=5.38u as=0.95p ps=5.38u w=5u l=3u
X50 pn15_t8 pn6 pn8_t3 VDD_t15 sg13_lv_pmos ad=1.7p pd=10.68u as=0.95p ps=5.38u w=5u l=3u
X51 pn15_t3 IBIAS_t0 VDD_t17 VDD_t15 sg13_lv_pmos ad=0.1005p pd=1.34u as=0.3345p ps=2.9u w=0.15u l=0.15u
X52 VDD_t32 IBIAS_t2 pn1_t4 VDD_t31 sg13_lv_pmos ad=0.3345p pd=2.9u as=0.1005p ps=1.34u w=0.15u l=0.15u
X53 VDD_t42 IBIAS_t2 pn1_t3 VDD_t31 sg13_lv_pmos ad=0.3345p pd=2.9u as=0.1005p ps=1.34u w=0.15u l=0.15u
X54 pn13_t4 pn3_t0 pn2_t0 VDD_t29 sg13_lv_pmos ad=0.95p pd=5.38u as=0.95p ps=5.38u w=5u l=3u
X55 VSS_t25 pn2_t4 pn14_t0 VSS_t24 sg13_lv_nmos ad=1.7p pd=10.68u as=0.95p ps=5.38u w=5u l=5u
X56 pn1_t10 pn14_t3 VSS_t41 VSS_t39 sg13_lv_nmos ad=0.95p pd=5.38u as=0.95p ps=5.38u w=5u l=3u
X57 pn18_t1 VINN_t0 pn17_t1 VDD_t6 sg13_lv_pmos ad=0.95p pd=5.38u as=0.95p ps=5.38u w=5u l=3u
X58 VSS_t30 pn16_t3 VOUT_t8 VSS_t28 sg13_lv_nmos ad=0.95p pd=5.38u as=0.95p ps=5.38u w=5u l=3u
X59 pn8_t3 pn6 pn15_t7 VDD_t15 sg13_lv_pmos ad=0.95p pd=5.38u as=0.95p ps=5.38u w=5u l=3u
X60 VDD_t34 IBIAS_t2 pn13_t1 VDD_t29 sg13_lv_pmos ad=0.3345p pd=2.9u as=0.1005p ps=1.34u w=0.15u l=0.15u
X61 pn13_t8 VINP_t0 pn14_t1 VDD_t31 sg13_lv_pmos ad=1.7p pd=10.68u as=0.95p ps=5.38u w=5u l=3u
X62 VSS_t21 pn2 pn2_t2 VSS_t20 sg13_lv_nmos ad=3.6p pd=11.44u as=0.95p ps=5.38u w=5u l=5u
X63 VDD_t4 IBIAS_t4 pn17_t6 VDD_t0 sg13_lv_pmos ad=0.3345p pd=2.9u as=0.1005p ps=1.34u w=0.15u l=0.15u
X64 pn17_t2 VINN_t0 pn18_t1 VDD_t6 sg13_lv_pmos ad=1.7p pd=10.68u as=0.95p ps=5.38u w=5u l=3u
X65 pn15_t7 pn6 pn8_t2 VDD_t15 sg13_lv_pmos ad=0.95p pd=5.38u as=0.95p ps=5.38u w=5u l=3u
X66 pn1_t9 pn14_t3 VSS_t40 VSS_t39 sg13_lv_nmos ad=0.95p pd=5.38u as=3.6p ps=11.44u w=5u l=3u
X67 pn17_t1 VINN_t0 pn18 VDD_t6 sg13_lv_pmos ad=0.95p pd=5.38u as=0.95p ps=5.38u w=5u l=3u
X68 VOUT_t1 IBIAS_t0 VDD_t21 VDD_t15 sg13_lv_pmos ad=0.1005p pd=1.34u as=0.3345p ps=2.9u w=0.15u l=0.15u
X69 VSS_t9 pn10_t4 pn18_t0 VSS_t8 sg13_lv_nmos ad=1.7p pd=10.68u as=0.95p ps=5.38u w=5u l=5u
X70 pn16_t0 pn8_t4 VSS_t35 VSS_t6 sg13_lv_nmos ad=0.95p pd=5.38u as=3.6p ps=11.44u w=5u l=5u
X71 CM_t0 pn5 VSS_t37 rhigh l=17.84u w=0.5u ps=0 b=0 m=1
X72 pn8_t2 pn6 pn15 VDD_t15 sg13_lv_pmos ad=0.95p pd=5.38u as=1.7p ps=10.68u w=5u l=3u
X73 pn14_t1 VINP_t0 pn13_t7 VDD_t31 sg13_lv_pmos ad=0.95p pd=5.38u as=0.95p ps=5.38u w=5u l=3u
X74 VOUT_t7 IBIAS_t0 VDD_t23 VDD_t15 sg13_lv_pmos ad=0.1005p pd=1.34u as=0.3345p ps=2.9u w=0.15u l=0.15u
X75 VOUT_t3 IBIAS_t0 VDD_t27 VDD_t15 sg13_lv_pmos ad=0.1005p pd=1.34u as=0.3345p ps=2.9u w=0.15u l=0.15u
X76 VDD_t30 IBIAS_t2 IBIAS_t3 VDD_t29 sg13_lv_pmos ad=0.3345p pd=2.9u as=0.1005p ps=1.34u w=0.15u l=0.15u
X77 VDD_t10 IBIAS_t4 pn9_t10 VDD_t6 sg13_lv_pmos ad=0.3345p pd=2.9u as=0.1005p ps=1.34u w=0.15u l=0.15u
X78 pn13_t5 pn3_t0 pn2_t1 VDD_t29 sg13_lv_pmos ad=1.7p pd=10.68u as=0.95p ps=5.38u w=5u l=3u
X79 VDD_t13 IBIAS_t4 pn9_t4 VDD_t6 sg13_lv_pmos ad=0.3345p pd=2.9u as=0.1005p ps=1.34u w=0.15u l=0.15u
X80 pn15_t2 IBIAS_t0 VDD_t18 VDD_t15 sg13_lv_pmos ad=0.1005p pd=1.34u as=0.3345p ps=2.9u w=0.15u l=0.15u
X81 VDD_t43 IBIAS_t2 pn1_t6 VDD_t31 sg13_lv_pmos ad=0.3345p pd=2.9u as=0.1005p ps=1.34u w=0.15u l=0.15u
X82 pn18 VINN_t0 pn17_t0 VDD_t6 sg13_lv_pmos ad=0.95p pd=5.38u as=1.7p ps=10.68u w=5u l=3u
X83 VDD_t39 IBIAS_t2 pn1_t1 VDD_t31 sg13_lv_pmos ad=0.3345p pd=2.9u as=0.1005p ps=1.34u w=0.15u l=0.15u
X84 pn10_t2 pn10 VSS_t3 VSS_t2 sg13_lv_nmos ad=0.95p pd=5.38u as=1.7p ps=10.68u w=5u l=5u
X85 pn9_t2 pn6_t0 VSS_t26 rhigh l=2u w=0.5u ps=0 b=0 m=1
X86 VDD_t35 IBIAS_t2 pn13_t2 VDD_t29 sg13_lv_pmos ad=0.3345p pd=2.9u as=0.1005p ps=1.34u w=0.15u l=0.15u
X87 IBIAS_t1 IBIAS_t0 VDD_t16 VDD_t15 sg13_lv_pmos ad=0.1005p pd=1.34u as=0.3345p ps=2.9u w=0.15u l=0.15u
X88 VSS_t43 pn14_t3 pn1_t10 VSS_t39 sg13_lv_nmos ad=1.7p pd=10.68u as=0.95p ps=5.38u w=5u l=3u
X89 VDD_t5 IBIAS_t4 pn17_t8 VDD_t0 sg13_lv_pmos ad=0.3345p pd=2.9u as=0.1005p ps=1.34u w=0.15u l=0.15u
X90 pn12 pn18_t2 VSS_t10 rhigh l=1.95u w=0.5u ps=0 b=0 m=1
X91 pn6_t1 VOUT_t10 VSS_t27 rhigh l=17.84u w=0.5u ps=0 b=0 m=1
X92 pn17_t4 pn11_t0 pn10_t0 VDD_t0 sg13_lv_pmos ad=1.7p pd=10.68u as=0.95p ps=5.38u w=5u l=3u
X93 VSS_t34 pn8 pn8_t0 VSS_t4 sg13_lv_nmos ad=3.6p pd=11.44u as=0.95p ps=5.38u w=5u l=5u
X94 VOUT_t2 IBIAS_t0 VDD_t24 VDD_t15 sg13_lv_pmos ad=0.1005p pd=1.34u as=0.3345p ps=2.9u w=0.15u l=0.15u
X95 VOUT_t6 IBIAS_t0 VDD_t28 VDD_t15 sg13_lv_pmos ad=0.1005p pd=1.34u as=0.3345p ps=2.9u w=0.15u l=0.15u
R0 pn20 pn20_t0 2720
R1 pn19 pn19_t0 2720
R2 pn21 pn21_t0 2652
R3 pn14_n0 pn14_t2 20.2699
R4 pn14_n0 pn14_t3 14.7473
R5 pn14_n1 pn14_t0 12.3773
R6 pn14_n2 pn14_n1 10.4592
R7 pn14 pn14_n2 5.69745
R8 pn14_n2 pn14_t1 3.79904
R9 pn14_n1 pn14_n0 2.6427
R10 pn2_n1 pn2_n0 20.4994
R11 pn2_n2 pn2 15.0005
R12 pn2_n3 pn2 7.46905
R13 pn2_n2 pn2_t4 7.05784
R14 pn2_n0 pn2_t1 5.69694
R15 pn2_n6 pn2 4.9422
R16 pn2_n7 pn2_n6 4.13405
R17 pn2_n0 pn2_t0 3.80064
R18 pn2_n4 pn2 3.66876
R19 pn2_n1 pn2_t2 2.38122
R20 pn2_n5 pn2_n1 1.21595
R21 pn2_n4 pn2_n3 0.388852
R22 pn2_n5 pn2_n4 0.274959
R23 pn2_n3 pn2_n2 0.196893
R24 pn2_n6 pn2_n5 0.192983
R25 pn2_n7 pn2 0.00162886
R26 pn2_n7 pn2 0.00137113
R27 VINP VINP_t0 25.5958
R28 pn3 pn3_t0 28.9838
R29 pn1 pn1_n9 45.066
R30 pn1_n9 pn1_t8 20.3087
R31 pn1_n0 pn1_t2 17.3511
R32 pn1_n0 pn1_t0 17.0005
R33 pn1_n1 pn1_t4 17.0005
R34 pn1_n2 pn1_t1 17.0005
R35 pn1_n3 pn1_t7 17.0005
R36 pn1_n4 pn1_t5 17.0005
R37 pn1_n5 pn1_t3 17.0005
R38 pn1_n6 pn1_t6 17.0005
R39 pn1_n7 pn1_n6 10.7841
R40 pn1_n9 pn1_n8 6.66575
R41 pn1_n8 pn1_t10 3.07795
R42 pn1_n7 pn1_t9 2.48468
R43 pn1_n8 pn1_n7 0.606387
R44 pn1_n1 pn1_n0 0.351125
R45 pn1_n2 pn1_n1 0.351125
R46 pn1_n3 pn1_n2 0.351125
R47 pn1_n4 pn1_n3 0.351125
R48 pn1_n5 pn1_n4 0.351125
R49 pn1_n6 pn1_n5 0.351125
R50 pn13_n6 pn13_t0 17.0005
R51 pn13_n5 pn13_t1 17.0005
R52 pn13_n4 pn13_t2 17.0005
R53 pn13_n3 pn13_t3 17.0005
R54 pn13 pn13_n7 7.13857
R55 pn13_n0 pn13_t8 7.13519
R56 pn13_n1 pn13_n0 4.648
R57 pn13_n7 pn13_t4 2.48841
R58 pn13_n2 pn13_t5 2.48783
R59 pn13_n0 pn13_t7 2.48774
R60 pn13_n1 pn13_t6 2.48732
R61 pn13_n2 pn13_n1 2.31737
R62 pn13_n7 pn13_n6 2.29383
R63 pn13_n3 pn13_n2 1.14571
R64 pn13_n6 pn13_n5 0.043
R65 pn13_n5 pn13_n4 0.043
R66 pn13_n4 pn13_n3 0.043
R67 pn23 pn23_t0 2652
R68 pn15_n6 pn15_t3 17.0005
R69 pn15_n5 pn15_t2 17.0005
R70 pn15_n4 pn15_t0 17.0005
R71 pn15_n3 pn15_t1 17.0005
R72 pn15_n0 pn15_t6 7.13169
R73 pn15 pn15_n7 7.13167
R74 pn15_n1 pn15_n0 4.648
R75 pn15_n0 pn15_t5 2.48425
R76 pn15_n1 pn15_t4 2.48423
R77 pn15_n2 pn15_t8 2.4841
R78 pn15_n7 pn15_t7 2.48301
R79 pn15_n2 pn15_n1 2.31737
R80 pn15_n7 pn15_n6 2.29383
R81 pn15_n3 pn15_n2 1.14571
R82 pn15_n6 pn15_n5 0.043
R83 pn15_n5 pn15_n4 0.043
R84 pn15_n4 pn15_n3 0.043
R85 pn5_n0 pn5_t0 48.6233
R86 pn5 pn5_n0 19.5288
R87 pn5_n0 pn5_t1 16.9994
R88 pn22 pn22_t0 24262.4
R89 CM CM_t0 20.0548
R90 pn24 pn24_t0 24262.4
R91 VOUT_n9 VOUT_t10 19.5476
R92 VOUT_n0 VOUT_t1 17.3511
R93 VOUT_n0 VOUT_t0 17.0005
R94 VOUT_n1 VOUT_t7 17.0005
R95 VOUT_n2 VOUT_t2 17.0005
R96 VOUT_n3 VOUT_t4 17.0005
R97 VOUT_n4 VOUT_t5 17.0005
R98 VOUT_n5 VOUT_t3 17.0005
R99 VOUT_n6 VOUT_t6 17.0005
R100 VOUT_n7 VOUT_n6 10.7841
R101 VOUT_n9 VOUT_n8 6.71396
R102 VOUT_n8 VOUT_t9 3.07364
R103 VOUT_n7 VOUT_t8 2.48164
R104 VOUT_n8 VOUT_n7 0.606387
R105 VOUT_n1 VOUT_n0 0.351125
R106 VOUT_n2 VOUT_n1 0.351125
R107 VOUT_n3 VOUT_n2 0.351125
R108 VOUT_n4 VOUT_n3 0.351125
R109 VOUT_n5 VOUT_n4 0.351125
R110 VOUT_n6 VOUT_n5 0.351125
R111 VOUT VOUT_n9 0.0979204
R112 pn16_n0 pn16_t1 20.2699
R113 pn16_n0 pn16_t3 14.7473
R114 pn16_n1 pn16_t0 12.374
R115 pn16_n2 pn16_n1 10.4592
R116 pn16 pn16_n2 5.70435
R117 pn16_n2 pn16_t2 3.80329
R118 pn16_n1 pn16_n0 2.6427
R119 pn8_n4 pn8_n3 20.4994
R120 pn8 pn8_n2 15.0005
R121 pn8 pn8_n1 7.46905
R122 pn8_n2 pn8_t4 7.05784
R123 pn8_n3 pn8_t3 5.701
R124 pn8_n3 pn8_t2 3.8045
R125 pn8 pn8_n0 3.66876
R126 pn8 pn8_n5 2.44426
R127 pn8_n4 pn8_t0 2.37709
R128 pn8_n5 pn8_n4 1.21595
R129 pn8_n1 pn8_n0 0.388852
R130 pn8_n5 pn8_n0 0.274959
R131 pn8_n2 pn8_n1 0.196893
R132 pn6 pn6_n0 43.8865
R133 pn6_n0 pn6_t0 20.9105
R134 pn6_n0 pn6_t1 19.5272
R135 pn26 pn26_t0 2720
R136 pn25 pn25_t0 2720
R137 pn27 pn27_t0 2652
R138 pn18_n0 pn18_t2 20.2699
R139 pn18_n0 pn18_t3 14.7473
R140 pn18_n1 pn18_t0 12.3773
R141 pn18_n2 pn18_n1 10.4592
R142 pn18 pn18_n2 5.69745
R143 pn18_n2 pn18_t1 3.79885
R144 pn18_n1 pn18_n0 2.6427
R145 pn10_n1 pn10_n0 20.4994
R146 pn10_n2 pn10 15.0005
R147 pn10_n3 pn10 7.46905
R148 pn10_n2 pn10_t4 7.05784
R149 pn10_n0 pn10_t0 5.69755
R150 pn10_n6 pn10 4.9422
R151 pn10_n7 pn10_n6 4.13405
R152 pn10_n0 pn10_t1 3.80066
R153 pn10_n4 pn10 3.66876
R154 pn10_n1 pn10_t2 2.38117
R155 pn10_n5 pn10_n1 1.21595
R156 pn10_n4 pn10_n3 0.388852
R157 pn10_n5 pn10_n4 0.274959
R158 pn10_n3 pn10_n2 0.196893
R159 pn10_n6 pn10_n5 0.192983
R160 pn10_n7 pn10 0.00162886
R161 pn10_n7 pn10 0.00137113
R162 VINN VINN_t0 25.5958
R163 pn11 pn11_t0 28.982
R164 pn9 pn9_n9 45.065
R165 pn9_n9 pn9_t2 20.3101
R166 pn9_n0 pn9_t5 17.3511
R167 pn9_n0 pn9_t9 17.0005
R168 pn9_n1 pn9_t8 17.0005
R169 pn9_n2 pn9_t10 17.0005
R170 pn9_n3 pn9_t3 17.0005
R171 pn9_n4 pn9_t6 17.0005
R172 pn9_n5 pn9_t4 17.0005
R173 pn9_n6 pn9_t7 17.0005
R174 pn9_n7 pn9_n6 10.7841
R175 pn9_n9 pn9_n8 6.66575
R176 pn9_n8 pn9_t1 3.07846
R177 pn9_n7 pn9_t0 2.485
R178 pn9_n8 pn9_n7 0.606387
R179 pn9_n1 pn9_n0 0.351125
R180 pn9_n2 pn9_n1 0.351125
R181 pn9_n3 pn9_n2 0.351125
R182 pn9_n4 pn9_n3 0.351125
R183 pn9_n5 pn9_n4 0.351125
R184 pn9_n6 pn9_n5 0.351125
R185 pn17_n6 pn17_t5 17.0005
R186 pn17_n5 pn17_t7 17.0005
R187 pn17_n4 pn17_t6 17.0005
R188 pn17_n3 pn17_t8 17.0005
R189 pn17 pn17_n7 7.13857
R190 pn17_n0 pn17_t2 7.13423
R191 pn17_n1 pn17_n0 4.648
R192 pn17_n7 pn17_t3 2.48791
R193 pn17_n1 pn17_t0 2.48791
R194 pn17_n2 pn17_t4 2.48773
R195 pn17_n0 pn17_t1 2.48713
R196 pn17_n2 pn17_n1 2.31737
R197 pn17_n7 pn17_n6 2.29383
R198 pn17_n3 pn17_n2 1.14571
R199 pn17_n6 pn17_n5 0.043
R200 pn17_n5 pn17_n4 0.043
R201 pn17_n4 pn17_n3 0.043
R202 IBIAS_n3 IBIAS_n1 32.2265
R203 IBIAS_n3 IBIAS_n2 29.9906
R204 IBIAS_n4 IBIAS_n0 21.6306
R205 IBIAS_n1 IBIAS_t3 17.2776
R206 IBIAS_n2 IBIAS_t1 17.2776
R207 IBIAS_n0 IBIAS_t5 17.2776
R208 IBIAS_n4 IBIAS_n3 11.4991
R209 IBIAS_n1 IBIAS_t2 5.34468
R210 IBIAS_n2 IBIAS_t0 5.3439
R211 IBIAS_n0 IBIAS_t4 5.3439
R212 IBIAS IBIAS_n4 1.19658
R213 VDD_t1 VDD_t0 17.0005
R214 VDD_t2 VDD_t0 17.0005
R215 VDD_t3 VDD_t0 17.0005
R216 VDD_t4 VDD_t0 17.0005
R217 VDD_t5 VDD_t0 17.0005
R218 VDD_t6 VDD_t7 17.0005
R219 VDD_t6 VDD_t8 17.0005
R220 VDD_t6 VDD_t9 17.0005
R221 VDD_t6 VDD_t10 17.0005
R222 VDD_t6 VDD_t11 17.0005
R223 VDD_t6 VDD_t12 17.0005
R224 VDD_t6 VDD_t13 17.0005
R225 VDD_t6 VDD_t14 17.0005
R226 VDD_t16 VDD_t15 17.0005
R227 VDD_t17 VDD_t15 17.0005
R228 VDD_t18 VDD_t15 17.0005
R229 VDD_t19 VDD_t15 17.0005
R230 VDD_t20 VDD_t15 17.0005
R231 VDD_t21 VDD_t15 17.0005
R232 VDD_t22 VDD_t15 17.0005
R233 VDD_t23 VDD_t15 17.0005
R234 VDD_t24 VDD_t15 17.0005
R235 VDD_t25 VDD_t15 17.0005
R236 VDD_t26 VDD_t15 17.0005
R237 VDD_t27 VDD_t15 17.0005
R238 VDD_t28 VDD_t15 17.0005
R239 VDD_t30 VDD_t29 17.0005
R240 VDD_t33 VDD_t29 17.0005
R241 VDD_t34 VDD_t29 17.0005
R242 VDD_t35 VDD_t29 17.0005
R243 VDD_t36 VDD_t29 17.0005
R244 VDD_t31 VDD_t37 17.0005
R245 VDD_t31 VDD_t38 17.0005
R246 VDD_t31 VDD_t32 17.0005
R247 VDD_t31 VDD_t39 17.0005
R248 VDD_t31 VDD_t40 17.0005
R249 VDD_t31 VDD_t41 17.0005
R250 VDD_t31 VDD_t42 17.0005
R251 VDD_t31 VDD_t43 17.0005
R252 VDD_n42 VDD_t1 8.79188
R253 VDD_n9 VDD_t16 8.79188
R254 VDD_n23 VDD_t30 8.79188
R255 VDD_n36 VDD_t14 8.56018
R256 VDD_n1 VDD_t28 8.56018
R257 VDD_n17 VDD_t43 8.56018
R258 VDD_n42 VDD_t2 8.5005
R259 VDD_n43 VDD_t3 8.5005
R260 VDD_n44 VDD_t4 8.5005
R261 VDD_n45 VDD_t5 8.5005
R262 VDD_t7 VDD_n49 8.5005
R263 VDD_n41 VDD_t8 8.5005
R264 VDD_n40 VDD_t9 8.5005
R265 VDD_n39 VDD_t10 8.5005
R266 VDD_n38 VDD_t11 8.5005
R267 VDD_n37 VDD_t12 8.5005
R268 VDD_n36 VDD_t13 8.5005
R269 VDD_n9 VDD_t17 8.5005
R270 VDD_n10 VDD_t18 8.5005
R271 VDD_n11 VDD_t19 8.5005
R272 VDD_n12 VDD_t20 8.5005
R273 VDD_n7 VDD_t21 8.5005
R274 VDD_n6 VDD_t22 8.5005
R275 VDD_n5 VDD_t23 8.5005
R276 VDD_n4 VDD_t24 8.5005
R277 VDD_n3 VDD_t25 8.5005
R278 VDD_n2 VDD_t26 8.5005
R279 VDD_n1 VDD_t27 8.5005
R280 VDD_n23 VDD_t33 8.5005
R281 VDD_n24 VDD_t34 8.5005
R282 VDD_n25 VDD_t35 8.5005
R283 VDD_n26 VDD_t36 8.5005
R284 VDD_t37 VDD_n30 8.5005
R285 VDD_n22 VDD_t38 8.5005
R286 VDD_n21 VDD_t32 8.5005
R287 VDD_n20 VDD_t39 8.5005
R288 VDD_n19 VDD_t40 8.5005
R289 VDD_n18 VDD_t41 8.5005
R290 VDD_n17 VDD_t42 8.5005
R291 VDD_n52 VDD_n33 4.03717
R292 VDD_n50 VDD_t6 2.87903
R293 VDD_n51 VDD_t0 2.68773
R294 VDD_n31 VDD_t15 2.68579
R295 VDD_n31 VDD_t31 2.68579
R296 VDD_n33 VDD_t29 2.68545
R297 VDD_n33 VDD_t15 2.68455
R298 VDD_n48 VDD_n47 1.37246
R299 VDD_n13 VDD_n8 1.37246
R300 VDD_n29 VDD_n28 1.37246
R301 VDD_n47 VDD_n46 1.3724
R302 VDD_n28 VDD_n27 1.3724
R303 VDD_n14 VDD_n13 1.37235
R304 VDD_n50 VDD_n34 1.1926
R305 VDD_n32 VDD_n15 1.1926
R306 VDD_n32 VDD_n0 1.1926
R307 VDD_n47 VDD_n35 0.709333
R308 VDD_n28 VDD_n16 0.709333
R309 VDD_n13 VDD_t15 0.708833
R310 VDD_n46 VDD_n45 0.266246
R311 VDD_n27 VDD_n26 0.266246
R312 VDD_n14 VDD_n12 0.266156
R313 VDD_n49 VDD_n48 0.243768
R314 VDD_n8 VDD_n7 0.243768
R315 VDD_n30 VDD_n29 0.243768
R316 VDD_n51 VDD_n50 0.197667
R317 VDD_n33 VDD_n32 0.197667
R318 VDD_n32 VDD_n31 0.194
R319 VDD_n48 VDD_n34 0.146019
R320 VDD_n15 VDD_n8 0.146019
R321 VDD_n29 VDD_n0 0.146019
R322 VDD_n15 VDD_n14 0.143326
R323 VDD_n46 VDD_n34 0.143246
R324 VDD_n27 VDD_n0 0.143246
R325 VDD_n52 VDD_n51 0.141833
R326 VDD_n43 VDD_n42 0.0601808
R327 VDD_n44 VDD_n43 0.0601808
R328 VDD_n45 VDD_n44 0.0601808
R329 VDD_n49 VDD_n41 0.0601808
R330 VDD_n41 VDD_n40 0.0601808
R331 VDD_n40 VDD_n39 0.0601808
R332 VDD_n39 VDD_n38 0.0601808
R333 VDD_n38 VDD_n37 0.0601808
R334 VDD_n37 VDD_n36 0.0601808
R335 VDD_n10 VDD_n9 0.0601808
R336 VDD_n11 VDD_n10 0.0601808
R337 VDD_n12 VDD_n11 0.0601808
R338 VDD_n7 VDD_n6 0.0601808
R339 VDD_n6 VDD_n5 0.0601808
R340 VDD_n5 VDD_n4 0.0601808
R341 VDD_n4 VDD_n3 0.0601808
R342 VDD_n3 VDD_n2 0.0601808
R343 VDD_n2 VDD_n1 0.0601808
R344 VDD_n24 VDD_n23 0.0601808
R345 VDD_n25 VDD_n24 0.0601808
R346 VDD_n26 VDD_n25 0.0601808
R347 VDD_n30 VDD_n22 0.0601808
R348 VDD_n22 VDD_n21 0.0601808
R349 VDD_n21 VDD_n20 0.0601808
R350 VDD_n20 VDD_n19 0.0601808
R351 VDD_n19 VDD_n18 0.0601808
R352 VDD_n18 VDD_n17 0.0601808
R353 VDD VDD_n52 0.0236667
R354 VDD_t6 VDD_n35 0.001
R355 VDD_n35 VDD_t0 0.001
R356 VDD_t31 VDD_n16 0.001
R357 VDD_n16 VDD_t29 0.001
R358 VSS_n115 VSS_t10 19172.2
R359 VSS_t1 VSS_n117 6767.57
R360 VSS_n116 VSS_n115 6074.75
R361 VSS_n122 VSS_n36 1009.1
R362 VSS_t20 VSS_t18 667.77
R363 VSS_t24 VSS_t22 667.77
R364 VSS_n114 VSS_n44 566.419
R365 VSS_t18 VSS_t1 509.517
R366 VSS_n91 VSS_t24 455.668
R367 VSS_n117 VSS_n116 437.752
R368 VSS_n117 VSS_t17 411.68
R369 VSS_n117 VSS_t38 411.68
R370 VSS_n83 VSS_t10 404.271
R371 VSS_n90 VSS_t17 404.271
R372 VSS_n87 VSS_t38 404.267
R373 VSS_n85 VSS_n84 390.752
R374 VSS_n122 VSS_t20 381.051
R375 VSS_t22 VSS_n36 381.051
R376 VSS_t2 VSS_t4 374.827
R377 VSS_t8 VSS_t6 374.827
R378 VSS_n116 VSS_t37 351.005
R379 VSS_t27 VSS_n85 326.928
R380 VSS_t11 VSS_t2 285.649
R381 VSS_n85 VSS_t8 219.462
R382 VSS_t4 VSS_n114 213.888
R383 VSS_t6 VSS_n44 213.888
R384 VSS_n115 VSS_t11 143.522
R385 VSS_n86 VSS_t27 66.1519
R386 VSS_n124 VSS_n2 17.001
R387 VSS_n98 VSS_n45 17.001
R388 VSS_n27 VSS_n16 17.001
R389 VSS_n124 VSS_t21 17.0005
R390 VSS_t21 VSS_n8 17.0005
R391 VSS_n39 VSS_n1 17.0005
R392 VSS_t21 VSS_n9 17.0005
R393 VSS_n39 VSS_n38 17.0005
R394 VSS_t21 VSS_n7 17.0005
R395 VSS_n42 VSS_n41 17.0005
R396 VSS_n42 VSS_n40 17.0005
R397 VSS_t21 VSS_n10 17.0005
R398 VSS_n120 VSS_n119 17.0005
R399 VSS_n120 VSS_n118 17.0005
R400 VSS_n22 VSS_n21 17.0005
R401 VSS_n21 VSS_n20 17.0005
R402 VSS_n102 VSS_n101 17.0005
R403 VSS_n102 VSS_n100 17.0005
R404 VSS_n103 VSS_n102 17.0005
R405 VSS_n108 VSS_n107 17.0005
R406 VSS_n107 VSS_n53 17.0005
R407 VSS_n112 VSS_n111 17.0005
R408 VSS_n112 VSS_n51 17.0005
R409 VSS_n78 VSS_n77 17.0005
R410 VSS_n77 VSS_n58 17.0005
R411 VSS_n75 VSS_n74 17.0005
R412 VSS_n67 VSS_n66 17.0005
R413 VSS_t5 VSS_n98 17.0005
R414 VSS_t5 VSS_n99 17.0005
R415 VSS_t5 VSS_n55 17.0005
R416 VSS_t5 VSS_n54 17.0005
R417 VSS_n110 VSS_t5 17.0005
R418 VSS_n82 VSS_t26 16.0906
R419 VSS_t0 VSS_n89 15.7454
R420 VSS_n87 VSS_t28 15.7228
R421 VSS_n90 VSS_t39 15.7183
R422 VSS_n83 VSS_t12 15.7183
R423 VSS_t28 VSS_n86 15.7163
R424 VSS_t12 VSS_n82 14.7113
R425 VSS_t39 VSS_n89 14.7113
R426 VSS_n91 VSS_t0 12.6779
R427 VSS_n84 VSS_t26 12.3327
R428 VSS_n64 VSS_n62 8.53073
R429 VSS_n121 VSS_n4 8.52972
R430 VSS_t5 VSS_n50 8.50222
R431 VSS_n113 VSS_n50 8.50127
R432 VSS_n122 VSS_n2 8.501
R433 VSS_n122 VSS_n43 8.501
R434 VSS_n122 VSS_n37 8.501
R435 VSS_n123 VSS_n122 8.501
R436 VSS_n36 VSS_n16 8.501
R437 VSS_n36 VSS_n15 8.501
R438 VSS_n36 VSS_n17 8.501
R439 VSS_n36 VSS_n35 8.501
R440 VSS_n36 VSS_n14 8.501
R441 VSS_n114 VSS_n45 8.501
R442 VSS_n114 VSS_n47 8.501
R443 VSS_n114 VSS_n48 8.501
R444 VSS_n114 VSS_n49 8.501
R445 VSS_n72 VSS_n44 8.501
R446 VSS_n61 VSS_n44 8.501
R447 VSS_n29 VSS_n25 8.48448
R448 VSS_t21 VSS_n6 8.48425
R449 VSS_n12 VSS_n11 8.48425
R450 VSS_n31 VSS_n24 8.48425
R451 VSS_n34 VSS_n33 8.48425
R452 VSS_n106 VSS_n105 8.48425
R453 VSS_n75 VSS_n60 8.48425
R454 VSS_n71 VSS_n70 8.48425
R455 VSS_n66 VSS_n65 8.48425
R456 VSS_n73 VSS_t7 8.48425
R457 VSS_t7 VSS_n69 8.48425
R458 VSS_t5 VSS_n52 8.48425
R459 VSS_n30 VSS_t23 8.48425
R460 VSS_n32 VSS_t23 8.48425
R461 VSS_t7 VSS_n57 8.48402
R462 VSS_t7 VSS_n63 8.48402
R463 VSS_t5 VSS_n104 8.48402
R464 VSS_n28 VSS_t23 8.48402
R465 VSS_n18 VSS_t23 8.48402
R466 VSS_n94 VSS_n93 6.29709
R467 VSS_n19 VSS_t23 5.66889
R468 VSS_n19 VSS_n13 5.66875
R469 VSS_n122 VSS_n3 5.66778
R470 VSS_n114 VSS_n46 5.66778
R471 VSS_n76 VSS_n44 5.66778
R472 VSS_n59 VSS_n44 5.66778
R473 VSS_n122 VSS_n121 5.66767
R474 VSS_n114 VSS_n113 5.66767
R475 VSS_t21 VSS_n4 5.6498
R476 VSS_t7 VSS_n62 5.64949
R477 VSS_n88 VSS_t32 4.27736
R478 VSS_n81 VSS_t16 4.27266
R479 VSS_n92 VSS_t43 4.27234
R480 VSS_n64 VSS_n44 4.25119
R481 VSS_n36 VSS_n13 4.251
R482 VSS_t5 VSS_n109 3.37438
R483 VSS_t7 VSS_n68 3.37408
R484 VSS_n23 VSS_t23 3.37408
R485 VSS_n56 VSS_t33 3.32906
R486 VSS_n80 VSS_t36 3.32872
R487 VSS_n97 VSS_t3 3.32574
R488 VSS_n26 VSS_t25 3.32539
R489 VSS_n79 VSS_t9 3.32505
R490 VSS_n125 VSS_t19 3.32498
R491 VSS_n88 VSS_t29 2.99149
R492 VSS_n92 VSS_t40 2.97718
R493 VSS_t13 VSS_n81 2.97718
R494 VSS_n84 VSS_t13 2.63329
R495 VSS_t40 VSS_n91 2.63329
R496 VSS_n88 VSS_t30 2.39843
R497 VSS_n92 VSS_t41 2.39488
R498 VSS_n81 VSS_t14 2.39343
R499 VSS_t21 VSS_n5 2.39143
R500 VSS_n80 VSS_t35 2.04274
R501 VSS_n56 VSS_t34 2.04186
R502 VSS_n114 VSS_t34 1.21479
R503 VSS_t35 VSS_n44 1.21479
R504 VSS_n125 VSS_n124 1.16557
R505 VSS_n79 VSS_n78 1.16557
R506 VSS_n98 VSS_n97 1.16557
R507 VSS_n27 VSS_n26 1.16557
R508 VSS_t13 VSS_n82 1.14157
R509 VSS_t40 VSS_n89 1.14157
R510 VSS_n126 VSS_n125 0.629108
R511 VSS_n95 VSS_n80 0.629108
R512 VSS_n95 VSS_n79 0.629108
R513 VSS_n96 VSS_n56 0.629108
R514 VSS_n97 VSS_n96 0.629108
R515 VSS_n26 VSS_n0 0.629108
R516 VSS_n94 VSS_n88 0.627093
R517 VSS_n94 VSS_n81 0.627093
R518 VSS_n93 VSS_n92 0.541221
R519 VSS_n96 VSS_n95 0.159167
R520 VSS_n126 VSS_n0 0.159167
R521 VSS_n119 VSS_n5 0.155801
R522 VSS_n11 VSS_n5 0.151644
R523 VSS_n109 VSS_n108 0.122706
R524 VSS_n68 VSS_n67 0.12261
R525 VSS_n23 VSS_n22 0.12261
R526 VSS_n93 VSS_n0 0.122503
R527 VSS_n70 VSS_n68 0.116973
R528 VSS_n33 VSS_n23 0.116973
R529 VSS_n109 VSS_n106 0.115889
R530 VSS VSS_n126 0.11375
R531 VSS_n20 VSS_n19 0.105791
R532 VSS_t29 VSS_n86 0.0945995
R533 VSS_t29 VSS_n87 0.0945203
R534 VSS_t13 VSS_n83 0.0945198
R535 VSS_t40 VSS_n90 0.0945198
R536 VSS_n65 VSS_n62 0.0911916
R537 VSS_n95 VSS_n94 0.0869167
R538 VSS_n51 VSS_n50 0.0846138
R539 VSS_n73 VSS_n60 0.0694186
R540 VSS_n31 VSS_n30 0.0694186
R541 VSS_n30 VSS_n29 0.0689543
R542 VSS_n65 VSS_n63 0.0689507
R543 VSS_n106 VSS_n104 0.0689507
R544 VSS_n40 VSS_n7 0.0685508
R545 VSS_n11 VSS_n6 0.0684864
R546 VSS_n69 VSS_n60 0.0684864
R547 VSS_n70 VSS_n69 0.0684864
R548 VSS_n32 VSS_n31 0.0684864
R549 VSS_n33 VSS_n32 0.0684864
R550 VSS_n29 VSS_n28 0.0684864
R551 VSS_n124 VSS_n1 0.0676186
R552 VSS_n118 VSS_n10 0.0676186
R553 VSS_n101 VSS_n98 0.0676186
R554 VSS_n38 VSS_n8 0.0666864
R555 VSS_n41 VSS_n9 0.0666864
R556 VSS_n74 VSS_n58 0.0666864
R557 VSS_n100 VSS_n99 0.0666864
R558 VSS_n103 VSS_n55 0.0666864
R559 VSS_n54 VSS_n53 0.0666864
R560 VSS_n111 VSS_n110 0.0666864
R561 VSS_n118 VSS_n4 0.0568878
R562 VSS_n111 VSS_n52 0.0363576
R563 VSS_n67 VSS_n63 0.0358897
R564 VSS_n104 VSS_n103 0.0358897
R565 VSS_n22 VSS_n18 0.0358897
R566 VSS_n74 VSS_n73 0.0354254
R567 VSS_n78 VSS_n57 0.0349575
R568 VSS_n58 VSS_n57 0.0349575
R569 VSS_n28 VSS_n27 0.0349575
R570 VSS_n20 VSS_n18 0.0349575
R571 VSS_n40 VSS_n6 0.0344932
R572 VSS_n52 VSS_n51 0.0344932
R573 VSS_n119 VSS_n10 0.00236441
R574 VSS_n21 VSS_n13 0.00175
R575 VSS_n120 VSS_n3 0.00166667
R576 VSS_n76 VSS_n75 0.00166667
R577 VSS_n71 VSS_n59 0.00166667
R578 VSS_n105 VSS_n46 0.00166667
R579 VSS_n8 VSS_n1 0.0014322
R580 VSS_n38 VSS_n9 0.0014322
R581 VSS_n41 VSS_n7 0.0014322
R582 VSS_n101 VSS_n99 0.0014322
R583 VSS_n100 VSS_n55 0.0014322
R584 VSS_n108 VSS_n54 0.0014322
R585 VSS_n110 VSS_n53 0.0014322
R586 VSS_n66 VSS_n64 0.00137498
R587 VSS_t21 VSS_n3 0.00133332
R588 VSS_n102 VSS_n46 0.00133332
R589 VSS_n75 VSS_n59 0.00133332
R590 VSS_n77 VSS_n76 0.00133332
R591 VSS_n43 VSS_n42 0.001
R592 VSS_n37 VSS_n12 0.001
R593 VSS_t21 VSS_n123 0.001
R594 VSS_n39 VSS_n2 0.001
R595 VSS_n43 VSS_n39 0.001
R596 VSS_n42 VSS_n37 0.001
R597 VSS_n123 VSS_n12 0.001
R598 VSS_n121 VSS_n120 0.001
R599 VSS_n25 VSS_n16 0.001
R600 VSS_n24 VSS_n15 0.001
R601 VSS_n24 VSS_n17 0.001
R602 VSS_n35 VSS_n34 0.001
R603 VSS_n21 VSS_n14 0.001
R604 VSS_n102 VSS_n45 0.001
R605 VSS_t5 VSS_n47 0.001
R606 VSS_n107 VSS_n48 0.001
R607 VSS_n112 VSS_n49 0.001
R608 VSS_n113 VSS_n112 0.001
R609 VSS_n72 VSS_n71 0.001
R610 VSS_n66 VSS_n61 0.001
R611 VSS_t7 VSS_n72 0.001
R612 VSS_t7 VSS_n61 0.001
R613 VSS_n105 VSS_n47 0.001
R614 VSS_t5 VSS_n48 0.001
R615 VSS_n107 VSS_n49 0.001
R616 VSS_n25 VSS_n15 0.001
R617 VSS_n34 VSS_n17 0.001
R618 VSS_n35 VSS_t23 0.001
R619 VSS_t23 VSS_n14 0.001
C0 pn10 pn9 0.01413f
C1 pn25 pn11 0.03044f
C2 pn27 pn18 0.02407f
C3 VINP pn5 0.07644f
C4 IBIAS VOUT 0.03536f
C5 pn10 VDD 0.51457f
C6 CM VDD 0.23911f
C7 IBIAS pn5 0.83757f
C8 IBIAS pn11 0.75259f
C9 pn14 pn1 3.43703f
C10 pn2 pn13 0.21172f
C11 pn4 pn5 0.02821f
C12 pn9 pn18 3.43703f
C13 pn27 pn9 0.03938f
C14 pn6 IBIAS 1.21326f
C15 pn15 VDD 2.39907f
C16 pn5 VOUT 0.02823f
C17 VDD pn18 0.48122f
C18 pn27 VDD 0.0251f
C19 VINN pn10 0.35076f
C20 pn7 pn15 0.04323f
C21 pn3 VDD 9.98966f
C22 pn1 pn21 0.03938f
C23 pn10 pn17 0.21172f
C24 pn20 pn5 0.03044f
C25 pn6 pn5 0.71856f
C26 pn9 VDD 0.9236f
C27 pn1 pn13 0.32339f
C28 VINN pn18 1.8247f
C29 pn15 pn16 0.23321f
C30 pn2 pn3 1.9952f
C31 pn14 VINP 1.8247f
C32 pn17 pn18 0.23321f
C33 pn26 pn9 0.0375f
C34 pn27 pn17 0.01599f
C35 pn7 VDD 6.24434f
C36 VINN pn9 0.02823f
C37 pn14 pn4 0.03272f
C38 pn23 VOUT 0.03938f
C39 pn17 pn9 0.32339f
C40 pn12 pn18 0.03272f
C41 pn2 VDD 0.47516f
C42 pn12 pn27 0.0326f
C43 VINN VDD 10.2113f
C44 pn15 pn8 0.21172f
C45 pn22 IBIAS 0.10957f
C46 pn17 VDD 2.39907f
C47 VDD pn16 0.48122f
C48 pn1 pn3 0.02733f
C49 VINP pn13 1.2457f
C50 pn12 pn9 0.93087f
C51 pn4 pn21 0.0326f
C52 pn7 pn24 0.03165f
C53 IBIAS pn13 0.29344f
C54 pn7 pn16 0.03272f
C55 pn4 pn13 0.04323f
C56 pn12 VDD 6.24434f
C57 pn22 pn5 0.12304f
C58 pn1 VDD 0.90237f
C59 IBIAS pn10 0.01701f
C60 VINN pn17 1.2457f
C61 pn22 pn6 0.02756f
C62 pn8 VDD 0.51467f
C63 IBIAS CM 0.10014f
C64 pn13 pn5 0.0161f
C65 pn19 pn3 0.03044f
C66 pn12 VINN 0.04787f
C67 pn15 IBIAS 0.31197f
C68 VINP pn3 0.54005f
C69 pn1 pn2 0.01413f
C70 pn10 pn11 1.99542f
C71 pn25 pn9 0.03044f
C72 pn12 pn17 0.04323f
C73 IBIAS pn3 0.23169f
C74 pn15 VOUT 0.32339f
C75 pn8 pn16 0.73237f
C76 IBIAS pn9 0.38963f
C77 pn15 pn5 1.27773f
C78 VINP VDD 10.1308f
C79 pn15 pn6 1.25816f
C80 IBIAS VDD 7.78662f
C81 pn3 pn5 0.43592f
C82 pn4 VDD 6.24434f
C83 pn14 pn21 0.02407f
C84 pn9 pn11 0.02733f
C85 VINP pn2 0.35076f
C86 pn14 pn13 0.23321f
C87 VDD VOUT 0.90237f
C88 pn6 pn9 6.18368f
C89 VDD pn11 10.0553f
C90 pn5 VDD 10.9058f
C91 pn7 VOUT 0.52433f
C92 VINN IBIAS 0.12595f
C93 pn6 VDD 10.081f
C94 pn15 pn23 0.01599f
C95 pn7 pn5 0.04787f
C96 IBIAS pn17 0.31071f
C97 pn13 pn21 0.01599f
C98 pn19 pn1 0.03044f
C99 pn7 pn6 0.07823f
C100 VINP pn1 0.02823f
C101 pn24 VOUT 0.04634f
C102 VINN pn11 0.53938f
C103 pn6 pn26 0.03044f
C104 pn16 VOUT 3.43703f
C105 pn22 CM 0.04533f
C106 pn17 pn11 1.25816f
C107 pn1 IBIAS 0.03536f
C108 pn5 pn16 1.8247f
C109 pn1 pn4 0.93083f
C110 pn24 pn6 0.06135f
C111 IBIAS pn8 0.06312f
C112 pn23 VDD 0.0251f
C113 pn7 pn23 0.0326f
C114 pn1 pn5 6.47428f
C115 pn8 VOUT 0.01413f
C116 pn14 VDD 0.48122f
C117 pn6 pn12 0.02817f
C118 pn20 pn1 0.03753f
C119 pn5 pn8 0.35654f
C120 pn3 pn13 1.25816f
C121 pn6 pn8 2.00138f
C122 pn10 pn18 0.73237f
C123 pn22 VDD 0.11033f
C124 VINP IBIAS 0.05023f
C125 pn23 pn16 0.02407f
C126 pn14 pn2 0.73237f
C127 VINP pn4 0.04787f
C128 pn21 VDD 0.0251f
C129 pn13 VDD 2.38664f
C130 pn20 VSS 0.28894f
C131 pn19 VSS 0.30018f
C132 pn21 VSS 0.24077f
C133 pn4 VSS 17.01215f
C134 pn14 VSS 20.84595f
C135 VINP VSS 2.44123f
C136 pn3 VSS 1.71146f
C137 pn1 VSS 25.53439f
C138 pn13 VSS 8.09045f
C139 pn7 VSS 16.71027f
C140 pn23 VSS 0.24077f
C141 pn15 VSS 1.06981f
C142 pn5 VSS 20.28459f
C143 pn22 VSS 2.39623f
C144 CM VSS 0.85508f
C145 pn24 VSS 2.46898f
C146 VOUT VSS 9.65928f
C147 pn16 VSS 13.97077f
C148 pn26 VSS 0.28359f
C149 pn25 VSS 0.30027f
C150 pn27 VSS 0.24077f
C151 pn12 VSS 17.33918f
C152 pn18 VSS 13.9708f
C153 VINN VSS 2.44263f
C154 pn11 VSS 1.71009f
C155 pn9 VSS 25.06018f
C156 pn17 VSS 1.07447f
C157 IBIAS VSS 5.96943f
C158 VDD VSS 27.61384f
C159 VSS_t23 VSS 0.8686f
C160 VSS_t33 VSS 10.72529f
C161 VSS_t7 VSS 0.87792f
C162 VSS_t36 VSS 0.89119f
C163 VSS_t13 VSS 2.81227f
C164 VSS_t29 VSS 2.81227f
C165 VSS_t41 VSS 2.81227f
C166 VSS_t5 VSS 10.74725f
C167 VSS_t19 VSS 10.7383f
C168 VDD_t15 VSS 13.8929f
C169 VDD_t29 VSS 7.83781f
C170 VDD_n0 VSS 0.18366f
C171 VDD_t28 VSS 0.01191f
C172 VDD_t27 VSS 0.01182f
C173 VDD_n1 VSS 0.02963f
C174 VDD_t26 VSS 0.01182f
C175 VDD_n2 VSS 0.01694f
C176 VDD_t25 VSS 0.01182f
C177 VDD_n3 VSS 0.01694f
C178 VDD_t24 VSS 0.01182f
C179 VDD_n4 VSS 0.01694f
C180 VDD_t23 VSS 0.01182f
C181 VDD_n5 VSS 0.01694f
C182 VDD_t22 VSS 0.01182f
C183 VDD_n6 VSS 0.01694f
C184 VDD_t21 VSS 0.01182f
C185 VDD_n7 VSS 0.04696f
C186 VDD_n8 VSS 0.04479f
C187 VDD_t16 VSS 0.01333f
C188 VDD_t17 VSS 0.01182f
C189 VDD_n9 VSS 0.09396f
C190 VDD_t18 VSS 0.01182f
C191 VDD_n10 VSS 0.01694f
C192 VDD_t19 VSS 0.24224f
C193 VDD_n11 VSS 0.01694f
C194 VDD_t20 VSS 0.01182f
C195 VDD_n12 VSS 0.04955f
C196 VDD_n13 VSS 0.12653f
C197 VDD_n14 VSS 0.04742f
C198 VDD_n15 VSS 0.18369f
C199 VDD_t38 VSS 0.01182f
C200 VDD_t39 VSS 0.01182f
C201 VDD_t41 VSS 0.01182f
C202 VDD_t43 VSS 0.01191f
C203 VDD_t42 VSS 0.01182f
C204 VDD_t40 VSS 0.24225f
C205 VDD_t32 VSS 0.01182f
C206 VDD_n17 VSS 0.02963f
C207 VDD_n18 VSS 0.01694f
C208 VDD_n19 VSS 0.01694f
C209 VDD_n20 VSS 0.01694f
C210 VDD_n21 VSS 0.01694f
C211 VDD_n22 VSS 0.01694f
C212 VDD_t30 VSS 0.01333f
C213 VDD_t33 VSS 0.01182f
C214 VDD_n23 VSS 0.09396f
C215 VDD_t34 VSS 0.01182f
C216 VDD_n24 VSS 0.01694f
C217 VDD_t35 VSS 0.01182f
C218 VDD_n25 VSS 0.01694f
C219 VDD_t36 VSS 0.01182f
C220 VDD_n26 VSS 0.04955f
C221 VDD_n27 VSS 0.04744f
C222 VDD_n28 VSS 0.12653f
C223 VDD_n29 VSS 0.04479f
C224 VDD_n30 VSS 0.04696f
C225 VDD_t37 VSS 0.01182f
C226 VDD_t31 VSS 6.055f
C227 VDD_n31 VSS 18.7449f
C228 VDD_n32 VSS 3.68543f
C229 VDD_n33 VSS 6.11891f
C230 VDD_t0 VSS 7.83768f
C231 VDD_n34 VSS 0.18366f
C232 VDD_t14 VSS 0.01191f
C233 VDD_t13 VSS 0.01182f
C234 VDD_t12 VSS 0.01182f
C235 VDD_t11 VSS 0.01182f
C236 VDD_t10 VSS 0.01182f
C237 VDD_t9 VSS 0.01182f
C238 VDD_t8 VSS 0.01182f
C239 VDD_n36 VSS 0.02963f
C240 VDD_n37 VSS 0.01694f
C241 VDD_n38 VSS 0.01694f
C242 VDD_n39 VSS 0.01694f
C243 VDD_n40 VSS 0.01694f
C244 VDD_n41 VSS 0.01694f
C245 VDD_t1 VSS 0.24375f
C246 VDD_t2 VSS 0.01182f
C247 VDD_n42 VSS 0.09396f
C248 VDD_t3 VSS 0.01182f
C249 VDD_n43 VSS 0.01694f
C250 VDD_t4 VSS 0.01182f
C251 VDD_n44 VSS 0.01694f
C252 VDD_t5 VSS 0.01182f
C253 VDD_n45 VSS 0.04955f
C254 VDD_n46 VSS 0.04744f
C255 VDD_n47 VSS 0.12653f
C256 VDD_n48 VSS 0.04479f
C257 VDD_n49 VSS 0.04696f
C258 VDD_t7 VSS 0.01182f
C259 VDD_t6 VSS 7.32922f
C260 VDD_n50 VSS 20.6187f
C261 VDD_n51 VSS 2.80523f
C262 VDD_n52 VSS 3.43958f
C263 IBIAS_t5 VSS 0.24843f
C264 IBIAS_n0 VSS 0.33872f
C265 IBIAS_t3 VSS 0.01801f
C266 IBIAS_n1 VSS 0.51039f
C267 IBIAS_t1 VSS 0.01801f
C268 IBIAS_n2 VSS 0.43501f
C269 IBIAS_n3 VSS 4.85975f
C270 IBIAS_n4 VSS 5.02902f
C271 pn17_t3 VSS 7.69298f
C272 pn17_t4 VSS 0.55057f
C273 pn17_t0 VSS 0.55056f
C274 pn17_t1 VSS 7.51619f
C275 pn17_t2 VSS 0.72199f
C276 pn17_n0 VSS 0.49239f
C277 pn17_n1 VSS 0.33004f
C278 pn17_n2 VSS 0.22403f
C279 pn17_t8 VSS 0.02619f
C280 pn17_n3 VSS 0.1663f
C281 pn17_t6 VSS 0.02619f
C282 pn17_n4 VSS 0.17543f
C283 pn17_t7 VSS 0.02619f
C284 pn17_n5 VSS 0.17543f
C285 pn17_t5 VSS 0.02619f
C286 pn17_n6 VSS 0.20121f
C287 pn17_n7 VSS 0.42124f
C288 pn9_t2 VSS 0.05315f
C289 pn9_t1 VSS 0.13485f
C290 pn9_t0 VSS 2.93175f
C291 pn9_n6 VSS 0.1545f
C292 pn9_n7 VSS 0.5736f
C293 pn9_n8 VSS 3.70412f
C294 pn9_n9 VSS 6.53754f
C295 pn10_t2 VSS 10.80173f
C296 pn10_t0 VSS 7.15655f
C297 pn10_t1 VSS 0.06007f
C298 pn10_n0 VSS 0.06199f
C299 pn10_n1 VSS 0.04413f
C300 pn10_n2 VSS 0.07246f
C301 pn10_n6 VSS 0.0143f
C302 pn18_t1 VSS 7.05987f
C303 pn18_t2 VSS 0.07274f
C304 pn18_n0 VSS 0.39161f
C305 pn18_t0 VSS 1.03659f
C306 pn18_n1 VSS 0.17581f
C307 pn18_n2 VSS 0.08642f
C308 pn6_t0 VSS 0.11161f
C309 pn6_t1 VSS 0.09653f
C310 pn6_n0 VSS 6.8326f
C311 pn8_n2 VSS 0.07356f
C312 pn8_t0 VSS 10.78058f
C313 pn8_t3 VSS 15.70315f
C314 pn8_t2 VSS 0.06098f
C315 pn8_n3 VSS 0.06294f
C316 pn8_n4 VSS 0.0448f
C317 pn8_n5 VSS 0.02281f
C318 pn16_t2 VSS 5.76731f
C319 pn16_t1 VSS 0.07274f
C320 pn16_n0 VSS 0.39161f
C321 pn16_t0 VSS 1.04987f
C322 pn16_n1 VSS 0.17581f
C323 pn16_n2 VSS 0.08645f
C324 VOUT_t9 VSS 0.0804f
C325 VOUT_t8 VSS 2.88349f
C326 VOUT_n6 VSS 0.0921f
C327 VOUT_n7 VSS 0.34195f
C328 VOUT_n8 VSS 2.22408f
C329 VOUT_t10 VSS 0.06428f
C330 VOUT_n9 VSS 2.3095f
C331 CM_t0 VSS 0.20734f
C332 pn5_t0 VSS 2.74586f
C333 pn5_n0 VSS 9.19611f
C334 pn15_t7 VSS 0.60678f
C335 pn15_t8 VSS 16.19023f
C336 pn15_t4 VSS 0.55433f
C337 pn15_t5 VSS 6.22776f
C338 pn15_t6 VSS 0.72696f
C339 pn15_n0 VSS 0.49567f
C340 pn15_n1 VSS 0.33226f
C341 pn15_n2 VSS 0.22555f
C342 pn15_t1 VSS 0.02637f
C343 pn15_n3 VSS 0.16743f
C344 pn15_t0 VSS 0.25679f
C345 pn15_n4 VSS 0.17663f
C346 pn15_t2 VSS 0.02637f
C347 pn15_n5 VSS 0.17663f
C348 pn15_t3 VSS 0.02637f
C349 pn15_n6 VSS 0.20258f
C350 pn15_n7 VSS 0.42398f
C351 pn13_t4 VSS 0.60132f
C352 pn13_t5 VSS 0.54932f
C353 pn13_t6 VSS 7.42448f
C354 pn13_t7 VSS 0.60132f
C355 pn13_t8 VSS 0.72033f
C356 pn13_n0 VSS 0.49132f
C357 pn13_n1 VSS 0.32928f
C358 pn13_n2 VSS 0.22354f
C359 pn13_t3 VSS 0.02613f
C360 pn13_n3 VSS 0.16592f
C361 pn13_t2 VSS 0.02613f
C362 pn13_n4 VSS 0.17504f
C363 pn13_t1 VSS 0.02613f
C364 pn13_n5 VSS 0.17504f
C365 pn13_t0 VSS 0.02613f
C366 pn13_n6 VSS 0.20076f
C367 pn13_n7 VSS 0.42029f
C368 pn1_t8 VSS 0.05293f
C369 pn1_t10 VSS 0.13393f
C370 pn1_t9 VSS 2.93093f
C371 pn1_t7 VSS 0.23559f
C372 pn1_n6 VSS 0.15344f
C373 pn1_n7 VSS 0.56966f
C374 pn1_n8 VSS 3.6787f
C375 pn1_n9 VSS 6.49262f
C376 pn2_t2 VSS 10.7922f
C377 pn2_t1 VSS 0.06555f
C378 pn2_t0 VSS 7.07704f
C379 pn2_n0 VSS 0.06133f
C380 pn2_n1 VSS 0.04366f
C381 pn2_n2 VSS 0.07169f
C382 pn2_n6 VSS 0.01414f
C383 pn14_t1 VSS 0.14637f
C384 pn14_t2 VSS 0.07274f
C385 pn14_n0 VSS 0.39161f
C386 pn14_t0 VSS 1.02727f
C387 pn14_n1 VSS 0.17581f
C388 pn14_n2 VSS 0.08642f
XCM_1 pn4 pn1 cap_cmomi w=15e-6 l=15e-6 mmin=1 mmax=4 feed=double subblock=0 m=1
XCM_2 pn4 pn1 cap_cmomi w=15e-6 l=15e-6 mmin=1 mmax=4 feed=double subblock=0 m=1
XCM_3 pn4 pn1 cap_cmomi w=15e-6 l=15e-6 mmin=1 mmax=4 feed=double subblock=0 m=1
XCM_4 pn4 pn1 cap_cmomi w=15e-6 l=15e-6 mmin=1 mmax=4 feed=double subblock=0 m=1
XCM_5 pn1 pn4 cap_cmomi w=15e-6 l=15e-6 mmin=1 mmax=4 feed=double subblock=0 m=1
XCM_6 pn1 pn4 cap_cmomi w=15e-6 l=15e-6 mmin=1 mmax=4 feed=double subblock=0 m=1
XCM_7 pn1 pn4 cap_cmomi w=15e-6 l=15e-6 mmin=1 mmax=4 feed=double subblock=0 m=1
XCM_8 pn1 pn4 cap_cmomi w=15e-6 l=15e-6 mmin=1 mmax=4 feed=double subblock=0 m=1
XCM_9 pn1 pn4 cap_cmomi w=15e-6 l=15e-6 mmin=1 mmax=4 feed=double subblock=0 m=1
XCM_10 pn7 VOUT cap_cmomi w=15e-6 l=15e-6 mmin=1 mmax=4 feed=double subblock=0 m=1
XCM_11 pn7 VOUT cap_cmomi w=15e-6 l=15e-6 mmin=1 mmax=4 feed=double subblock=0 m=1
XCM_12 pn7 VOUT cap_cmomi w=15e-6 l=15e-6 mmin=1 mmax=4 feed=double subblock=0 m=1
XCM_13 pn7 VOUT cap_cmomi w=15e-6 l=15e-6 mmin=1 mmax=4 feed=double subblock=0 m=1
XCM_14 pn7 VOUT cap_cmomi w=15e-6 l=15e-6 mmin=1 mmax=4 feed=double subblock=0 m=1
XCM_15 VOUT pn7 cap_cmomi w=15e-6 l=15e-6 mmin=1 mmax=4 feed=double subblock=0 m=1
XCM_16 VOUT pn7 cap_cmomi w=15e-6 l=15e-6 mmin=1 mmax=4 feed=double subblock=0 m=1
XCM_17 VOUT pn7 cap_cmomi w=15e-6 l=15e-6 mmin=1 mmax=4 feed=double subblock=0 m=1
XCM_18 VOUT pn7 cap_cmomi w=15e-6 l=15e-6 mmin=1 mmax=4 feed=double subblock=0 m=1
XCM_19 pn12 pn9 cap_cmomi w=15e-6 l=15e-6 mmin=1 mmax=4 feed=double subblock=0 m=1
XCM_20 pn12 pn9 cap_cmomi w=15e-6 l=15e-6 mmin=1 mmax=4 feed=double subblock=0 m=1
XCM_21 pn12 pn9 cap_cmomi w=15e-6 l=15e-6 mmin=1 mmax=4 feed=double subblock=0 m=1
XCM_22 pn12 pn9 cap_cmomi w=15e-6 l=15e-6 mmin=1 mmax=4 feed=double subblock=0 m=1
XCM_23 pn9 pn12 cap_cmomi w=15e-6 l=15e-6 mmin=1 mmax=4 feed=double subblock=0 m=1
XCM_24 pn9 pn12 cap_cmomi w=15e-6 l=15e-6 mmin=1 mmax=4 feed=double subblock=0 m=1
XCM_25 pn9 pn12 cap_cmomi w=15e-6 l=15e-6 mmin=1 mmax=4 feed=double subblock=0 m=1
XCM_26 pn9 pn12 cap_cmomi w=15e-6 l=15e-6 mmin=1 mmax=4 feed=double subblock=0 m=1
XCM_27 pn9 pn12 cap_cmomi w=15e-6 l=15e-6 mmin=1 mmax=4 feed=double subblock=0 m=1
.ends instramp_cmos5l
