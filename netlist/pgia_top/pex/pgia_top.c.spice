** post-layout netlist of pgia_top: kpex -> ngspice by scripts/pex_netlist.py (source: /foss/designs/sg13cmos5l_spma_ip__instramp/runs/pex/pgia_top/kpex/pgia_top__pgia_top/pgia_top_k25d_pex_netlist.spice)
.subckt pgia_top VINP VINN VCM gain_sel[0] gain_sel[1] gain_sel[2] gain_sel[3] VOUT AVDD VPWR IBIAS_IA AVSS VGND
XM_1 n110 n110 AVSS AVSS sg13_lv_nmos L=2U W=9.21U AS=3.1314P AD=3.1314P PS=19.1U PD=19.1U rfmode=0
XM_2 n111 n111 n10 AVSS sg13_lv_nmos L=2U W=1.6U AS=0.544P AD=0.544P PS=3.88U PD=3.88U rfmode=0
XM_3 n96 n98 AVSS AVSS sg13_lv_nmos L=3U W=5U AS=1.7P AD=0.95P PS=10.68U PD=5.38U rfmode=0
XM_4 AVSS n98 n96 AVSS sg13_lv_nmos L=3U W=5U AS=0.95P AD=0.95P PS=5.38U PD=5.38U rfmode=0
XM_5 n96 n98 AVSS AVSS sg13_lv_nmos L=3U W=5U AS=0.95P AD=0.95P PS=5.38U PD=5.38U rfmode=0
XM_6 AVSS n98 n96 AVSS sg13_lv_nmos L=3U W=5U AS=0.95P AD=1.8P PS=5.38U PD=10.72U rfmode=0
XM_7 n98 n97 AVSS AVSS sg13_lv_nmos L=5U W=5U AS=1.7P AD=0.95P PS=10.68U PD=5.38U rfmode=0
XM_8 AVSS n97 n98 AVSS sg13_lv_nmos L=5U W=5U AS=0.95P AD=1.8P PS=5.38U PD=10.72U rfmode=0
XM_9 n97 n97 AVSS AVSS sg13_lv_nmos L=5U W=5U AS=1.8P AD=0.95P PS=10.72U PD=5.38U rfmode=0
XM_10 AVSS n97 n97 AVSS sg13_lv_nmos L=5U W=5U AS=0.95P AD=1.7P PS=5.38U PD=10.68U rfmode=0
XM_11 n236 n111 n93 AVSS sg13_lv_nmos L=2U W=6.41U AS=2.1794P AD=2.1794P PS=13.5U PD=13.5U rfmode=0
XM_12 n132 n111 n119 AVSS sg13_lv_nmos L=2U W=6.41U AS=2.1794P AD=2.1794P PS=13.5U PD=13.5U rfmode=0
XM_13 AVSS n110 n132 AVSS sg13_lv_nmos L=2U W=9.21U AS=3.1314P AD=3.1314P PS=19.1U PD=19.1U rfmode=0
XM_14 n93 n110 AVSS AVSS sg13_lv_nmos L=2U W=9.21U AS=3.1314P AD=3.1314P PS=19.1U PD=19.1U rfmode=0
XM_15 n353 n133 AVSS AVSS sg13_lv_nmos L=2U W=3.2U AS=1.088P AD=1.088P PS=7.08U PD=7.08U rfmode=0
XM_16 n345 n133 AVSS AVSS sg13_lv_nmos L=2U W=1.74U AS=0.5916P AD=0.5916P PS=4.16U PD=4.16U rfmode=0
XM_17 n653 n133 AVSS AVSS sg13_lv_nmos L=2U W=6U AS=2.04P AD=2.04P PS=12.68U PD=12.68U rfmode=0
XM_18 n497 n133 AVSS AVSS sg13_lv_nmos L=2U W=0.87U AS=0.2958P AD=0.2958P PS=2.42U PD=2.42U rfmode=0
XM_19 AVSS n133 n133 AVSS sg13_lv_nmos L=2U W=0.87U AS=0.2958P AD=0.2958P PS=2.42U PD=2.42U rfmode=0
XM_20 n119 n344 n353 AVSS sg13_lv_nmos L=0.5U W=0.84U AS=0.2856P AD=0.2856P PS=2.36U PD=2.36U rfmode=0
XM_21 n359 n353 AVSS AVSS sg13_lv_nmos L=0.5U W=8.4U AS=2.856P AD=2.856P PS=17.48U PD=17.48U rfmode=0
XM_22 n344 n344 n238 AVSS sg13_lv_nmos L=0.5U W=0.84U AS=0.2856P AD=0.2856P PS=2.36U PD=2.36U rfmode=0
XM_23 n238 n238 AVSS AVSS sg13_lv_nmos L=0.5U W=2.1U AS=0.714P AD=0.714P PS=4.88U PD=4.88U rfmode=0
XM_24 VGND n692 n670 VGND sg13_lv_nmos L=0.15U W=0.74U AS=0.2516P AD=0.1406P PS=2.16U PD=1.12U rfmode=0
XM_25 n670 n686 VGND VGND sg13_lv_nmos L=0.15U W=0.74U AS=0.1406P AD=0.1406P PS=1.12U PD=1.12U rfmode=0
XM_26 n671 n687 n670 VGND sg13_lv_nmos L=0.15U W=0.74U AS=0.1406P AD=0.2516P PS=1.12U PD=2.16U rfmode=0
XM_27 n681 gain_sel[1] VGND VGND sg13_lv_nmos L=0.13U W=0.55U AS=0.14875P AD=0.187P PS=1.16U PD=1.78U rfmode=0
XM_28 n664 n681 VGND VGND sg13_lv_nmos L=0.13U W=0.74U AS=0.14875P AD=0.2886P PS=1.16U PD=2.26U rfmode=0
XM_29 n682 gain_sel[0] VGND VGND sg13_lv_nmos L=0.13U W=0.55U AS=0.14875P AD=0.187P PS=1.16U PD=1.78U rfmode=0
XM_30 n665 n682 VGND VGND sg13_lv_nmos L=0.13U W=0.74U AS=0.14875P AD=0.2886P PS=1.16U PD=2.26U rfmode=0
XM_31 n689 n660 VGND VGND sg13_lv_nmos L=0.13U W=0.55U AS=0.14875P AD=0.187P PS=1.16U PD=1.78U rfmode=0
XM_32 n1014 n689 VGND VGND sg13_lv_nmos L=0.13U W=0.74U AS=0.14875P AD=0.2886P PS=1.16U PD=2.26U rfmode=0
XM_33 n690 n965 VGND VGND sg13_lv_nmos L=0.13U W=0.55U AS=0.14875P AD=0.187P PS=1.16U PD=1.78U rfmode=0
XM_34 n1023 n690 VGND VGND sg13_lv_nmos L=0.13U W=0.74U AS=0.14875P AD=0.2886P PS=1.16U PD=2.26U rfmode=0
XM_35 n691 n669 VGND VGND sg13_lv_nmos L=0.13U W=0.55U AS=0.14875P AD=0.187P PS=1.16U PD=1.78U rfmode=0
XM_36 n1022 n691 VGND VGND sg13_lv_nmos L=0.13U W=0.74U AS=0.14875P AD=0.2886P PS=1.16U PD=2.26U rfmode=0
XM_37 n693 n703 VGND VGND sg13_lv_nmos L=0.13U W=0.55U AS=0.14875P AD=0.187P PS=1.16U PD=1.78U rfmode=0
XM_38 n1021 n693 VGND VGND sg13_lv_nmos L=0.13U W=0.74U AS=0.14875P AD=0.2886P PS=1.16U PD=2.26U rfmode=0
XM_39 n694 n671 VGND VGND sg13_lv_nmos L=0.13U W=0.55U AS=0.14875P AD=0.187P PS=1.16U PD=1.78U rfmode=0
XM_40 n1020 n694 VGND VGND sg13_lv_nmos L=0.13U W=0.74U AS=0.14875P AD=0.2886P PS=1.16U PD=2.26U rfmode=0
XM_41 n695 n705 VGND VGND sg13_lv_nmos L=0.13U W=0.55U AS=0.14875P AD=0.187P PS=1.16U PD=1.78U rfmode=0
XM_42 n663 n695 VGND VGND sg13_lv_nmos L=0.13U W=0.74U AS=0.14875P AD=0.2886P PS=1.16U PD=2.26U rfmode=0
XM_43 n696 n706 VGND VGND sg13_lv_nmos L=0.13U W=0.55U AS=0.14875P AD=0.187P PS=1.16U PD=1.78U rfmode=0
XM_44 n674 n696 VGND VGND sg13_lv_nmos L=0.13U W=0.74U AS=0.14875P AD=0.2886P PS=1.16U PD=2.26U rfmode=0
XM_45 n697 n707 VGND VGND sg13_lv_nmos L=0.13U W=0.55U AS=0.14875P AD=0.187P PS=1.16U PD=1.78U rfmode=0
XM_46 n675 n697 VGND VGND sg13_lv_nmos L=0.13U W=0.74U AS=0.14875P AD=0.2886P PS=1.16U PD=2.26U rfmode=0
XM_47 n698 n708 VGND VGND sg13_lv_nmos L=0.13U W=0.55U AS=0.14875P AD=0.187P PS=1.16U PD=1.78U rfmode=0
XM_48 n677 n698 VGND VGND sg13_lv_nmos L=0.13U W=0.74U AS=0.14875P AD=0.2886P PS=1.16U PD=2.26U rfmode=0
XM_49 n699 n971 VGND VGND sg13_lv_nmos L=0.13U W=0.55U AS=0.14875P AD=0.187P PS=1.16U PD=1.78U rfmode=0
XM_50 n678 n699 VGND VGND sg13_lv_nmos L=0.13U W=0.74U AS=0.14875P AD=0.2886P PS=1.16U PD=2.26U rfmode=0
XM_51 VGND VPWR VGND VGND sg13_lv_nmos L=1U W=0.42U AS=0.1428P AD=0.0798P PS=1.52U PD=0.8U rfmode=0
XM_52 VGND VPWR VGND VGND sg13_lv_nmos L=1U W=0.42U AS=0.0798P AD=0.1428P PS=0.8U PD=1.52U rfmode=0
XM_53 VGND VPWR VGND VGND sg13_lv_nmos L=1U W=0.42U AS=0.1428P AD=0.0798P PS=1.52U PD=0.8U rfmode=0
XM_54 VGND VPWR VGND VGND sg13_lv_nmos L=1U W=0.42U AS=0.0798P AD=0.1428P PS=0.8U PD=1.52U rfmode=0
XM_55 VGND VPWR VGND VGND sg13_lv_nmos L=1U W=0.42U AS=0.1428P AD=0.0798P PS=1.52U PD=0.8U rfmode=0
XM_56 VGND VPWR VGND VGND sg13_lv_nmos L=1U W=0.42U AS=0.0798P AD=0.1428P PS=0.8U PD=1.52U rfmode=0
XM_57 VGND VPWR VGND VGND sg13_lv_nmos L=1U W=0.42U AS=0.1428P AD=0.1428P PS=1.52U PD=1.52U rfmode=0
XM_58 n666 n928 VGND VGND sg13_lv_nmos L=0.13U W=0.74U AS=0.2516P AD=0.1406P PS=2.16U PD=1.12U rfmode=0
XM_59 VGND n818 n666 VGND sg13_lv_nmos L=0.13U W=0.74U AS=0.1406P AD=0.2516P PS=1.12U PD=2.16U rfmode=0
XM_60 n700 n665 VGND VGND sg13_lv_nmos L=0.13U W=0.74U AS=0.2516P AD=0.1406P PS=2.16U PD=1.12U rfmode=0
XM_61 n668 n664 n700 VGND sg13_lv_nmos L=0.13U W=0.74U AS=0.1406P AD=0.2516P PS=1.12U PD=2.16U rfmode=0
XM_62 VGND VPWR VGND VGND sg13_lv_nmos L=1U W=0.42U AS=0.1428P AD=0.0798P PS=1.52U PD=0.8U rfmode=0
XM_63 VGND VPWR VGND VGND sg13_lv_nmos L=1U W=0.42U AS=0.0798P AD=0.1428P PS=0.8U PD=1.52U rfmode=0
XM_64 VGND VPWR VGND VGND sg13_lv_nmos L=1U W=0.42U AS=0.1428P AD=0.1428P PS=1.52U PD=1.52U rfmode=0
XM_65 n669 n684 VGND VGND sg13_lv_nmos L=0.13U W=0.74U AS=0.2516P AD=0.2516P PS=2.16U PD=2.16U rfmode=0
XM_66 n701 n692 n672 VGND sg13_lv_nmos L=0.13U W=0.74U AS=0.2516P AD=0.1406P PS=2.16U PD=1.12U rfmode=0
XM_67 VGND n837 n701 VGND sg13_lv_nmos L=0.13U W=0.74U AS=0.1406P AD=0.2516P PS=1.12U PD=2.16U rfmode=0
XM_68 n702 n652 VGND VGND sg13_lv_nmos L=0.13U W=0.74U AS=0.2516P AD=0.1406P PS=2.16U PD=1.12U rfmode=0
XM_69 n676 n818 n702 VGND sg13_lv_nmos L=0.13U W=0.74U AS=0.1406P AD=0.2516P PS=1.12U PD=2.16U rfmode=0
XM_70 n815 n665 VGND VGND sg13_lv_nmos L=0.13U W=0.74U AS=0.2516P AD=0.2516P PS=2.16U PD=2.16U rfmode=0
XM_71 n652 n664 VGND VGND sg13_lv_nmos L=0.13U W=0.77U AS=0.2618P AD=0.1694P PS=2.22U PD=1.21U rfmode=0
XM_72 VGND n815 n652 VGND sg13_lv_nmos L=0.13U W=0.77U AS=0.1694P AD=0.1463P PS=1.21U PD=1.15U rfmode=0
XM_73 n652 n928 VGND VGND sg13_lv_nmos L=0.13U W=0.77U AS=0.1463P AD=0.2618P PS=1.15U PD=2.22U rfmode=0
XM_74 n950 n664 n684 VGND sg13_lv_nmos L=0.13U W=0.74U AS=0.2516P AD=0.1406P PS=2.16U PD=1.12U rfmode=0
XM_75 n949 n665 n950 VGND sg13_lv_nmos L=0.13U W=0.74U AS=0.1406P AD=0.1406P PS=1.12U PD=1.12U rfmode=0
XM_76 VGND n666 n949 VGND sg13_lv_nmos L=0.13U W=0.74U AS=0.1406P AD=0.2886P PS=1.12U PD=2.26U rfmode=0
XM_77 VGND n664 n833 VGND sg13_lv_nmos L=0.13U W=0.55U AS=0.187P AD=0.17255P PS=1.78U PD=1.25U rfmode=0
XM_78 n816 n833 VGND VGND sg13_lv_nmos L=0.13U W=0.74U AS=0.17255P AD=0.1406P PS=1.25U PD=1.12U rfmode=0
XM_79 VGND n665 n816 VGND sg13_lv_nmos L=0.13U W=0.74U AS=0.1406P AD=0.2516P PS=1.12U PD=2.16U rfmode=0
XM_80 n951 n666 VGND VGND sg13_lv_nmos L=0.13U W=0.74U AS=0.2516P AD=0.1406P PS=2.16U PD=1.12U rfmode=0
XM_81 n706 n816 n951 VGND sg13_lv_nmos L=0.13U W=0.74U AS=0.1406P AD=0.2516P PS=1.12U PD=2.16U rfmode=0
XM_82 VGND n707 n703 VGND sg13_lv_nmos L=0.13U W=0.74U AS=0.2516P AD=0.2516P PS=2.16U PD=2.16U rfmode=0
XM_83 VGND n818 n835 VGND sg13_lv_nmos L=0.13U W=0.55U AS=0.187P AD=0.14505P PS=1.78U PD=1.15U rfmode=0
XM_84 n952 n928 VGND VGND sg13_lv_nmos L=0.13U W=0.74U AS=0.14505P AD=0.1406P PS=1.15U PD=1.12U rfmode=0
XM_85 n686 n835 n952 VGND sg13_lv_nmos L=0.13U W=0.74U AS=0.1406P AD=0.333P PS=1.12U PD=2.38U rfmode=0
XM_86 VGND n818 n836 VGND sg13_lv_nmos L=0.13U W=0.55U AS=0.187P AD=0.17255P PS=1.78U PD=1.25U rfmode=0
XM_87 n837 n836 VGND VGND sg13_lv_nmos L=0.13U W=0.74U AS=0.17255P AD=0.1406P PS=1.25U PD=1.12U rfmode=0
XM_88 VGND n928 n837 VGND sg13_lv_nmos L=0.13U W=0.74U AS=0.1406P AD=0.2516P PS=1.12U PD=2.16U rfmode=0
XM_89 VGND n928 n839 VGND sg13_lv_nmos L=0.13U W=0.55U AS=0.187P AD=0.17255P PS=1.78U PD=1.25U rfmode=0
XM_90 n819 n839 VGND VGND sg13_lv_nmos L=0.13U W=0.74U AS=0.17255P AD=0.1406P PS=1.25U PD=1.12U rfmode=0
XM_91 VGND n818 n819 VGND sg13_lv_nmos L=0.13U W=0.74U AS=0.1406P AD=0.2516P PS=1.12U PD=2.16U rfmode=0
XM_92 n820 n692 VGND VGND sg13_lv_nmos L=0.13U W=0.74U AS=0.2516P AD=0.2516P PS=2.16U PD=2.16U rfmode=0
XM_93 VGND n668 n843 VGND sg13_lv_nmos L=0.13U W=0.55U AS=0.187P AD=0.14505P PS=1.78U PD=1.15U rfmode=0
XM_94 n959 n819 VGND VGND sg13_lv_nmos L=0.13U W=0.74U AS=0.14505P AD=0.1406P PS=1.15U PD=1.12U rfmode=0
XM_95 n938 n843 n959 VGND sg13_lv_nmos L=0.13U W=0.74U AS=0.1406P AD=0.333P PS=1.12U PD=2.38U rfmode=0
XM_96 n957 n837 VGND VGND sg13_lv_nmos L=0.13U W=0.74U AS=0.2516P AD=0.1406P PS=2.16U PD=1.12U rfmode=0
XM_97 n822 n816 n957 VGND sg13_lv_nmos L=0.13U W=0.74U AS=0.1406P AD=0.2516P PS=1.12U PD=2.16U rfmode=0
XM_98 n956 n819 VGND VGND sg13_lv_nmos L=0.13U W=0.74U AS=0.2516P AD=0.1406P PS=2.16U PD=1.12U rfmode=0
XM_99 n707 n692 n956 VGND sg13_lv_nmos L=0.13U W=0.74U AS=0.1406P AD=0.2516P PS=1.12U PD=2.16U rfmode=0
XM_100 n845 n652 VGND VGND sg13_lv_nmos L=0.13U W=0.55U AS=0.17255P AD=0.187P PS=1.25U PD=1.78U rfmode=0
XM_101 n660 n818 VGND VGND sg13_lv_nmos L=0.13U W=0.74U AS=0.2516P AD=0.1406P PS=2.16U PD=1.12U rfmode=0
XM_102 VGND n845 n660 VGND sg13_lv_nmos L=0.13U W=0.74U AS=0.1406P AD=0.17255P PS=1.12U PD=1.25U rfmode=0
XM_103 n942 n818 n828 VGND sg13_lv_nmos L=0.13U W=0.64U AS=0.2176P AD=0.1216P PS=1.96U PD=1.02U rfmode=0
XM_104 VGND n652 n942 VGND sg13_lv_nmos L=0.13U W=0.64U AS=0.1216P AD=0.1331P PS=1.02U PD=1.12U rfmode=0
XM_105 n708 n828 VGND VGND sg13_lv_nmos L=0.13U W=0.74U AS=0.1331P AD=0.2516P PS=1.12U PD=2.16U rfmode=0
XM_106 VGND n818 n846 VGND sg13_lv_nmos L=0.13U W=0.55U AS=0.187P AD=0.14505P PS=1.78U PD=1.15U rfmode=0
XM_107 n955 n652 VGND VGND sg13_lv_nmos L=0.13U W=0.74U AS=0.14505P AD=0.1406P PS=1.15U PD=1.12U rfmode=0
XM_108 n705 n846 n955 VGND sg13_lv_nmos L=0.13U W=0.74U AS=0.1406P AD=0.333P PS=1.12U PD=2.38U rfmode=0
XM_109 VGND VPWR VGND VGND sg13_lv_nmos L=1U W=0.42U AS=0.1428P AD=0.0798P PS=1.52U PD=0.8U rfmode=0
XM_110 VGND VPWR VGND VGND sg13_lv_nmos L=1U W=0.42U AS=0.0798P AD=0.1428P PS=0.8U PD=1.52U rfmode=0
XM_111 n961 gain_sel[3] VGND VGND sg13_lv_nmos L=0.13U W=0.55U AS=0.14875P AD=0.187P PS=1.16U PD=1.78U rfmode=0
XM_112 n818 n961 VGND VGND sg13_lv_nmos L=0.13U W=0.74U AS=0.14875P AD=0.2886P PS=1.16U PD=2.26U rfmode=0
XM_113 n963 gain_sel[2] VGND VGND sg13_lv_nmos L=0.13U W=0.55U AS=0.14875P AD=0.187P PS=1.16U PD=1.78U rfmode=0
XM_114 n928 n963 VGND VGND sg13_lv_nmos L=0.13U W=0.74U AS=0.14875P AD=0.2886P PS=1.16U PD=2.26U rfmode=0
XM_115 VGND VPWR VGND VGND sg13_lv_nmos L=1U W=0.42U AS=0.1428P AD=0.0798P PS=1.52U PD=0.8U rfmode=0
XM_116 VGND VPWR VGND VGND sg13_lv_nmos L=1U W=0.42U AS=0.0798P AD=0.1428P PS=0.8U PD=1.52U rfmode=0
XM_117 VGND VPWR VGND VGND sg13_lv_nmos L=1U W=0.42U AS=0.1428P AD=0.0798P PS=1.52U PD=0.8U rfmode=0
XM_118 VGND VPWR VGND VGND sg13_lv_nmos L=1U W=0.42U AS=0.0798P AD=0.1428P PS=0.8U PD=1.52U rfmode=0
XM_119 n692 n665 VGND VGND sg13_lv_nmos L=0.13U W=0.74U AS=0.2516P AD=0.1406P PS=2.16U PD=1.12U rfmode=0
XM_120 VGND n664 n692 VGND sg13_lv_nmos L=0.13U W=0.74U AS=0.1406P AD=0.2516P PS=1.12U PD=2.16U rfmode=0
XM_121 n965 n706 VGND VGND sg13_lv_nmos L=0.13U W=0.74U AS=0.2516P AD=0.2516P PS=2.16U PD=2.16U rfmode=0
XM_122 n989 n837 VGND VGND sg13_lv_nmos L=0.13U W=0.74U AS=0.2516P AD=0.1406P PS=2.16U PD=1.12U rfmode=0
XM_123 n687 n668 n989 VGND sg13_lv_nmos L=0.13U W=0.74U AS=0.1406P AD=0.2516P PS=1.12U PD=2.16U rfmode=0
XM_124 VGND n822 n967 VGND sg13_lv_nmos L=0.13U W=0.74U AS=0.2516P AD=0.2516P PS=2.16U PD=2.16U rfmode=0
XM_125 VGND n672 n968 VGND sg13_lv_nmos L=0.13U W=0.74U AS=0.2516P AD=0.2516P PS=2.16U PD=2.16U rfmode=0
XM_126 n958 n837 VGND VGND sg13_lv_nmos L=0.13U W=0.74U AS=0.2553P AD=0.13875P PS=2.17U PD=1.115U rfmode=0
XM_127 n840 n668 n958 VGND sg13_lv_nmos L=0.13U W=0.74U AS=0.13875P AD=0.2664P PS=1.115U PD=1.46U rfmode=0
XM_128 n960 n820 n840 VGND sg13_lv_nmos L=0.13U W=0.74U AS=0.2664P AD=0.0962P PS=1.46U PD=1U rfmode=0
XM_129 VGND n819 n960 VGND sg13_lv_nmos L=0.13U W=0.74U AS=0.0962P AD=0.2516P PS=1U PD=2.16U rfmode=0
XM_130 VGND n938 n969 VGND sg13_lv_nmos L=0.13U W=0.74U AS=0.2516P AD=0.2516P PS=2.16U PD=2.16U rfmode=0
XM_131 VGND n971 n842 VGND sg13_lv_nmos L=0.13U W=0.74U AS=0.2516P AD=0.2516P PS=2.16U PD=2.16U rfmode=0
XM_132 n992 n816 n971 VGND sg13_lv_nmos L=0.13U W=0.74U AS=0.2516P AD=0.1406P PS=2.16U PD=1.12U rfmode=0
XM_133 VGND n819 n992 VGND sg13_lv_nmos L=0.13U W=0.74U AS=0.1406P AD=0.2516P PS=1.12U PD=2.16U rfmode=0
XM_134 n973 n840 VGND VGND sg13_lv_nmos L=0.13U W=0.55U AS=0.14875P AD=0.187P PS=1.16U PD=1.78U rfmode=0
XM_135 n932 n973 VGND VGND sg13_lv_nmos L=0.13U W=0.74U AS=0.14875P AD=0.2886P PS=1.16U PD=2.26U rfmode=0
XM_136 n974 n969 VGND VGND sg13_lv_nmos L=0.13U W=0.55U AS=0.14875P AD=0.187P PS=1.16U PD=1.78U rfmode=0
XM_137 n996 n974 VGND VGND sg13_lv_nmos L=0.13U W=0.74U AS=0.14875P AD=0.2886P PS=1.16U PD=2.26U rfmode=0
XM_138 VGND n684 n824 VGND sg13_lv_nmos L=0.13U W=0.55U AS=0.187P AD=0.14875P PS=1.78U PD=1.16U rfmode=0
XM_139 n713 n824 VGND VGND sg13_lv_nmos L=0.13U W=0.74U AS=0.14875P AD=0.2886P PS=1.16U PD=2.26U rfmode=0
XM_140 n975 n968 VGND VGND sg13_lv_nmos L=0.13U W=0.55U AS=0.14875P AD=0.187P PS=1.16U PD=1.78U rfmode=0
XM_141 n976 n975 VGND VGND sg13_lv_nmos L=0.13U W=0.74U AS=0.14875P AD=0.2886P PS=1.16U PD=2.26U rfmode=0
XM_142 VGND n842 n825 VGND sg13_lv_nmos L=0.13U W=0.55U AS=0.187P AD=0.14875P PS=1.78U PD=1.16U rfmode=0
XM_143 n826 n825 VGND VGND sg13_lv_nmos L=0.13U W=0.74U AS=0.14875P AD=0.2886P PS=1.16U PD=2.26U rfmode=0
XM_144 n977 n967 VGND VGND sg13_lv_nmos L=0.13U W=0.55U AS=0.14875P AD=0.187P PS=1.16U PD=1.78U rfmode=0
XM_145 n979 n977 VGND VGND sg13_lv_nmos L=0.13U W=0.74U AS=0.14875P AD=0.2886P PS=1.16U PD=2.26U rfmode=0
XM_146 n980 n938 VGND VGND sg13_lv_nmos L=0.13U W=0.55U AS=0.14875P AD=0.187P PS=1.16U PD=1.78U rfmode=0
XM_147 n981 n980 VGND VGND sg13_lv_nmos L=0.13U W=0.74U AS=0.14875P AD=0.2886P PS=1.16U PD=2.26U rfmode=0
XM_148 n982 n822 VGND VGND sg13_lv_nmos L=0.13U W=0.55U AS=0.14875P AD=0.187P PS=1.16U PD=1.78U rfmode=0
XM_149 n983 n982 VGND VGND sg13_lv_nmos L=0.13U W=0.74U AS=0.14875P AD=0.2886P PS=1.16U PD=2.26U rfmode=0
XM_150 n984 n672 VGND VGND sg13_lv_nmos L=0.13U W=0.55U AS=0.14875P AD=0.187P PS=1.16U PD=1.78U rfmode=0
XM_151 n985 n984 VGND VGND sg13_lv_nmos L=0.13U W=0.74U AS=0.14875P AD=0.2886P PS=1.16U PD=2.26U rfmode=0
XM_152 n986 n676 VGND VGND sg13_lv_nmos L=0.13U W=0.55U AS=0.14875P AD=0.187P PS=1.16U PD=1.78U rfmode=0
XM_153 n987 n986 VGND VGND sg13_lv_nmos L=0.13U W=0.74U AS=0.14875P AD=0.2886P PS=1.16U PD=2.26U rfmode=0
XM_154 n517 n624 AVSS AVSS sg13_lv_nmos L=3U W=5U AS=1.7P AD=0.95P PS=10.68U PD=5.38U rfmode=0
XM_155 AVSS n624 n517 AVSS sg13_lv_nmos L=3U W=5U AS=0.95P AD=0.95P PS=5.38U PD=5.38U rfmode=0
XM_156 n517 n624 AVSS AVSS sg13_lv_nmos L=3U W=5U AS=0.95P AD=0.95P PS=5.38U PD=5.38U rfmode=0
XM_157 AVSS n624 n517 AVSS sg13_lv_nmos L=3U W=5U AS=0.95P AD=1.8P PS=5.38U PD=10.72U rfmode=0
XM_158 n624 n625 AVSS AVSS sg13_lv_nmos L=5U W=5U AS=1.7P AD=0.95P PS=10.68U PD=5.38U rfmode=0
XM_159 AVSS n625 n624 AVSS sg13_lv_nmos L=5U W=5U AS=0.95P AD=1.8P PS=5.38U PD=10.72U rfmode=0
XM_160 n625 n625 AVSS AVSS sg13_lv_nmos L=5U W=5U AS=1.8P AD=0.95P PS=10.72U PD=5.38U rfmode=0
XM_161 AVSS n625 n625 AVSS sg13_lv_nmos L=5U W=5U AS=0.95P AD=1.7P PS=5.38U PD=10.68U rfmode=0
XM_162 VGND VPWR VGND VGND sg13_lv_nmos L=1U W=0.42U AS=0.1428P AD=0.0798P PS=1.52U PD=0.8U rfmode=0
XM_163 VGND VPWR VGND VGND sg13_lv_nmos L=1U W=0.42U AS=0.0798P AD=0.1428P PS=0.8U PD=1.52U rfmode=0
XM_164 VGND VPWR VGND VGND sg13_lv_nmos L=1U W=0.42U AS=0.1428P AD=0.0798P PS=1.52U PD=0.8U rfmode=0
XM_165 VGND VPWR VGND VGND sg13_lv_nmos L=1U W=0.42U AS=0.0798P AD=0.1428P PS=0.8U PD=1.52U rfmode=0
XM_166 VGND VPWR VGND VGND sg13_lv_nmos L=1U W=0.42U AS=0.1428P AD=0.0798P PS=1.52U PD=0.8U rfmode=0
XM_167 VGND VPWR VGND VGND sg13_lv_nmos L=1U W=0.42U AS=0.0798P AD=0.1428P PS=0.8U PD=1.52U rfmode=0
XM_168 VGND VPWR VGND VGND sg13_lv_nmos L=1U W=0.42U AS=0.1428P AD=0.0798P PS=1.52U PD=0.8U rfmode=0
XM_169 VGND VPWR VGND VGND sg13_lv_nmos L=1U W=0.42U AS=0.0798P AD=0.1428P PS=0.8U PD=1.52U rfmode=0
XM_170 VGND VPWR VGND VGND sg13_lv_nmos L=1U W=0.42U AS=0.1428P AD=0.0798P PS=1.52U PD=0.8U rfmode=0
XM_171 VGND VPWR VGND VGND sg13_lv_nmos L=1U W=0.42U AS=0.0798P AD=0.1428P PS=0.8U PD=1.52U rfmode=0
XM_172 VGND VPWR VGND VGND sg13_lv_nmos L=1U W=0.42U AS=0.1428P AD=0.1428P PS=1.52U PD=1.52U rfmode=0
XM_173 AVSS n1020 n1009 AVSS sg13_lv_nmos L=0.13U W=0.74U AS=0.2516P AD=0.2516P PS=2.16U PD=2.16U rfmode=0
XM_174 n1043 n1020 n1026 AVSS sg13_lv_nmos L=0.13U W=0.18U AS=0.1026P AD=0.1026P PS=1.34U PD=1.34U rfmode=0
XM_175 AVSS n1021 n1010 AVSS sg13_lv_nmos L=0.13U W=0.74U AS=0.2516P AD=0.2516P PS=2.16U PD=2.16U rfmode=0
XM_176 n1044 n1021 n1026 AVSS sg13_lv_nmos L=0.13U W=0.18U AS=0.1026P AD=0.1026P PS=1.34U PD=1.34U rfmode=0
XM_177 AVSS n1022 n1011 AVSS sg13_lv_nmos L=0.13U W=0.74U AS=0.2516P AD=0.2516P PS=2.16U PD=2.16U rfmode=0
XM_178 n1045 n1022 n1026 AVSS sg13_lv_nmos L=0.13U W=0.18U AS=0.1026P AD=0.1026P PS=1.34U PD=1.34U rfmode=0
XM_179 AVSS n1023 n1012 AVSS sg13_lv_nmos L=0.13U W=0.74U AS=0.2516P AD=0.2516P PS=2.16U PD=2.16U rfmode=0
XM_180 n1046 n1023 n1026 AVSS sg13_lv_nmos L=0.13U W=0.2U AS=0.104P AD=0.104P PS=1.34U PD=1.34U rfmode=0
XM_181 AVSS n1014 n1013 AVSS sg13_lv_nmos L=0.13U W=0.74U AS=0.2516P AD=0.2516P PS=2.16U PD=2.16U rfmode=0
XM_182 n1047 n1014 n1026 AVSS sg13_lv_nmos L=0.13U W=0.3U AS=0.102P AD=0.102P PS=1.28U PD=1.28U rfmode=0
XM_183 AVSS n1024 n1015 AVSS sg13_lv_nmos L=0.13U W=0.74U AS=0.2516P AD=0.2516P PS=2.16U PD=2.16U rfmode=0
XM_184 n1048 n1024 n1026 AVSS sg13_lv_nmos L=0.13U W=0.4U AS=0.136P AD=0.136P PS=1.48U PD=1.48U rfmode=0
XM_185 n1145 n1020 AVSS AVSS sg13_lv_nmos L=0.13U W=0.74U AS=0.2516P AD=0.1406P PS=2.16U PD=1.12U rfmode=0
XM_186 AVSS n1021 n1145 AVSS sg13_lv_nmos L=0.13U W=0.74U AS=0.1406P AD=0.2516P PS=1.12U PD=2.16U rfmode=0
XM_187 AVSS n1022 n1146 AVSS sg13_lv_nmos L=0.13U W=0.77U AS=0.2618P AD=0.1463P PS=2.22U PD=1.15U rfmode=0
XM_188 n1146 n1023 AVSS AVSS sg13_lv_nmos L=0.13U W=0.77U AS=0.1463P AD=0.1694P PS=1.15U PD=1.21U rfmode=0
XM_189 AVSS n1014 n1146 AVSS sg13_lv_nmos L=0.13U W=0.77U AS=0.1694P AD=0.2618P PS=1.21U PD=2.22U rfmode=0
XM_190 AVSS n1144 n1024 AVSS sg13_lv_nmos L=0.13U W=0.74U AS=0.2516P AD=0.1331P PS=2.16U PD=1.12U rfmode=0
XM_191 n1149 n1145 AVSS AVSS sg13_lv_nmos L=0.13U W=0.64U AS=0.1331P AD=0.1216P PS=1.12U PD=1.02U rfmode=0
XM_192 n1144 n1146 n1149 AVSS sg13_lv_nmos L=0.13U W=0.64U AS=0.1216P AD=0.2176P PS=1.02U PD=1.96U rfmode=0
XM_193 n1237 n1238 AVSS AVSS sg13_lv_nmos L=3U W=5U AS=1.7P AD=0.95P PS=10.68U PD=5.38U rfmode=0
XM_194 AVSS n1238 n1237 AVSS sg13_lv_nmos L=3U W=5U AS=0.95P AD=0.95P PS=5.38U PD=5.38U rfmode=0
XM_195 n1237 n1238 AVSS AVSS sg13_lv_nmos L=3U W=5U AS=0.95P AD=0.95P PS=5.38U PD=5.38U rfmode=0
XM_196 AVSS n1238 n1237 AVSS sg13_lv_nmos L=3U W=5U AS=0.95P AD=1.8P PS=5.38U PD=10.72U rfmode=0
XM_197 n1238 n1230 AVSS AVSS sg13_lv_nmos L=5U W=5U AS=1.7P AD=0.95P PS=10.68U PD=5.38U rfmode=0
XM_198 AVSS n1230 n1238 AVSS sg13_lv_nmos L=5U W=5U AS=0.95P AD=1.8P PS=5.38U PD=10.72U rfmode=0
XM_199 n1230 n1230 AVSS AVSS sg13_lv_nmos L=5U W=5U AS=1.8P AD=0.95P PS=10.72U PD=5.38U rfmode=0
XM_200 AVSS n1230 n1230 AVSS sg13_lv_nmos L=5U W=5U AS=0.95P AD=1.7P PS=5.38U PD=10.68U rfmode=0
XM_201 n1243 IBIAS_IA AVSS AVSS sg13_lv_nmos L=2U W=1U AS=0.34P AD=0.34P PS=2.68U PD=2.68U rfmode=0
XM_202 n1243 IBIAS_IA AVSS AVSS sg13_lv_nmos L=2U W=1U AS=0.34P AD=0.34P PS=2.68U PD=2.68U rfmode=0
XM_203 n1243 IBIAS_IA AVSS AVSS sg13_lv_nmos L=2U W=1U AS=0.34P AD=0.34P PS=2.68U PD=2.68U rfmode=0
XM_204 n1243 IBIAS_IA AVSS AVSS sg13_lv_nmos L=2U W=1U AS=0.34P AD=0.34P PS=2.68U PD=2.68U rfmode=0
XM_205 n1243 IBIAS_IA AVSS AVSS sg13_lv_nmos L=2U W=1U AS=0.34P AD=0.34P PS=2.68U PD=2.68U rfmode=0
XM_206 n1243 IBIAS_IA AVSS AVSS sg13_lv_nmos L=2U W=1U AS=0.34P AD=0.34P PS=2.68U PD=2.68U rfmode=0
XM_207 n1243 IBIAS_IA AVSS AVSS sg13_lv_nmos L=2U W=1U AS=0.34P AD=0.34P PS=2.68U PD=2.68U rfmode=0
XM_208 n1243 IBIAS_IA AVSS AVSS sg13_lv_nmos L=2U W=1U AS=0.34P AD=0.34P PS=2.68U PD=2.68U rfmode=0
XM_209 n1243 IBIAS_IA AVSS AVSS sg13_lv_nmos L=2U W=1U AS=0.34P AD=0.34P PS=2.68U PD=2.68U rfmode=0
XM_210 n1245 IBIAS_IA AVSS AVSS sg13_lv_nmos L=2U W=1U AS=0.34P AD=0.34P PS=2.68U PD=2.68U rfmode=0
XM_211 n1246 IBIAS_IA AVSS AVSS sg13_lv_nmos L=2U W=1U AS=0.34P AD=0.34P PS=2.68U PD=2.68U rfmode=0
XM_212 IBIAS_IA IBIAS_IA AVSS AVSS sg13_lv_nmos L=2U W=1U AS=0.34P AD=0.34P PS=2.68U PD=2.68U rfmode=0
XM_213 n1246 IBIAS_IA AVSS AVSS sg13_lv_nmos L=2U W=1U AS=0.34P AD=0.34P PS=2.68U PD=2.68U rfmode=0
XM_214 n1245 IBIAS_IA AVSS AVSS sg13_lv_nmos L=2U W=1U AS=0.34P AD=0.34P PS=2.68U PD=2.68U rfmode=0
XM_215 IBIAS_IA IBIAS_IA AVSS AVSS sg13_lv_nmos L=2U W=1U AS=0.34P AD=0.34P PS=2.68U PD=2.68U rfmode=0
XM_216 n1243 IBIAS_IA AVSS AVSS sg13_lv_nmos L=2U W=1U AS=0.34P AD=0.34P PS=2.68U PD=2.68U rfmode=0
XM_217 n1243 IBIAS_IA AVSS AVSS sg13_lv_nmos L=2U W=1U AS=0.34P AD=0.34P PS=2.68U PD=2.68U rfmode=0
XM_218 n1243 IBIAS_IA AVSS AVSS sg13_lv_nmos L=2U W=1U AS=0.34P AD=0.34P PS=2.68U PD=2.68U rfmode=0
XM_219 n1243 IBIAS_IA AVSS AVSS sg13_lv_nmos L=2U W=1U AS=0.34P AD=0.34P PS=2.68U PD=2.68U rfmode=0
XM_220 n1243 IBIAS_IA AVSS AVSS sg13_lv_nmos L=2U W=1U AS=0.34P AD=0.34P PS=2.68U PD=2.68U rfmode=0
XM_221 n1243 IBIAS_IA AVSS AVSS sg13_lv_nmos L=2U W=1U AS=0.34P AD=0.34P PS=2.68U PD=2.68U rfmode=0
XM_222 n1243 IBIAS_IA AVSS AVSS sg13_lv_nmos L=2U W=1U AS=0.34P AD=0.34P PS=2.68U PD=2.68U rfmode=0
XM_223 n1243 IBIAS_IA AVSS AVSS sg13_lv_nmos L=2U W=1U AS=0.34P AD=0.34P PS=2.68U PD=2.68U rfmode=0
XM_224 IBIAS_IA IBIAS_IA AVSS AVSS sg13_lv_nmos L=2U W=1U AS=0.34P AD=0.34P PS=2.68U PD=2.68U rfmode=0
XM_225 n1246 IBIAS_IA AVSS AVSS sg13_lv_nmos L=2U W=1U AS=0.34P AD=0.34P PS=2.68U PD=2.68U rfmode=0
XM_226 n1245 IBIAS_IA AVSS AVSS sg13_lv_nmos L=2U W=1U AS=0.34P AD=0.34P PS=2.68U PD=2.68U rfmode=0
XM_227 IBIAS_IA IBIAS_IA AVSS AVSS sg13_lv_nmos L=2U W=1U AS=0.34P AD=0.34P PS=2.68U PD=2.68U rfmode=0
XM_228 n1246 IBIAS_IA AVSS AVSS sg13_lv_nmos L=2U W=1U AS=0.34P AD=0.34P PS=2.68U PD=2.68U rfmode=0
XM_229 n1245 IBIAS_IA AVSS AVSS sg13_lv_nmos L=2U W=1U AS=0.34P AD=0.34P PS=2.68U PD=2.68U rfmode=0
XM_230 IBIAS_IA IBIAS_IA AVSS AVSS sg13_lv_nmos L=2U W=1U AS=0.34P AD=0.34P PS=2.68U PD=2.68U rfmode=0
XM_231 n1246 IBIAS_IA AVSS AVSS sg13_lv_nmos L=2U W=1U AS=0.34P AD=0.34P PS=2.68U PD=2.68U rfmode=0
XM_232 n1246 IBIAS_IA AVSS AVSS sg13_lv_nmos L=2U W=1U AS=0.34P AD=0.34P PS=2.68U PD=2.68U rfmode=0
XM_233 IBIAS_IA IBIAS_IA AVSS AVSS sg13_lv_nmos L=2U W=1U AS=0.34P AD=0.34P PS=2.68U PD=2.68U rfmode=0
XM_234 n1245 IBIAS_IA AVSS AVSS sg13_lv_nmos L=2U W=1U AS=0.34P AD=0.34P PS=2.68U PD=2.68U rfmode=0
XM_235 n1246 IBIAS_IA AVSS AVSS sg13_lv_nmos L=2U W=1U AS=0.34P AD=0.34P PS=2.68U PD=2.68U rfmode=0
XM_236 IBIAS_IA IBIAS_IA AVSS AVSS sg13_lv_nmos L=2U W=1U AS=0.34P AD=0.34P PS=2.68U PD=2.68U rfmode=0
XM_237 n1245 IBIAS_IA AVSS AVSS sg13_lv_nmos L=2U W=1U AS=0.34P AD=0.34P PS=2.68U PD=2.68U rfmode=0
XM_238 n1579 n1579 n1540 AVSS sg13_lv_nmos L=2U W=1.6U AS=0.544P AD=0.544P PS=3.88U PD=3.88U rfmode=0
XM_239 n1246 IBIAS_IA AVSS AVSS sg13_lv_nmos L=2U W=1U AS=0.34P AD=0.34P PS=2.68U PD=2.68U rfmode=0
XM_240 n1768 n1426 AVSS AVSS sg13_lv_nmos L=2U W=6U AS=2.04P AD=2.04P PS=12.68U PD=12.68U rfmode=0
XM_241 IBIAS_IA IBIAS_IA AVSS AVSS sg13_lv_nmos L=2U W=1U AS=0.34P AD=0.34P PS=2.68U PD=2.68U rfmode=0
XM_242 n1580 n1580 AVSS AVSS sg13_lv_nmos L=2U W=9.21U AS=3.1314P AD=3.1314P PS=19.1U PD=19.1U rfmode=0
XM_243 n1243 IBIAS_IA AVSS AVSS sg13_lv_nmos L=2U W=1U AS=0.34P AD=0.34P PS=2.68U PD=2.68U rfmode=0
XM_244 n1243 IBIAS_IA AVSS AVSS sg13_lv_nmos L=2U W=1U AS=0.34P AD=0.34P PS=2.68U PD=2.68U rfmode=0
XM_245 n1623 n1426 AVSS AVSS sg13_lv_nmos L=2U W=3.2U AS=1.088P AD=1.088P PS=7.08U PD=7.08U rfmode=0
XM_246 n1243 IBIAS_IA AVSS AVSS sg13_lv_nmos L=2U W=1U AS=0.34P AD=0.34P PS=2.68U PD=2.68U rfmode=0
XM_247 n1243 IBIAS_IA AVSS AVSS sg13_lv_nmos L=2U W=1U AS=0.34P AD=0.34P PS=2.68U PD=2.68U rfmode=0
XM_248 n1243 IBIAS_IA AVSS AVSS sg13_lv_nmos L=2U W=1U AS=0.34P AD=0.34P PS=2.68U PD=2.68U rfmode=0
XM_249 AVSS n1580 n1581 AVSS sg13_lv_nmos L=2U W=9.21U AS=3.1314P AD=3.1314P PS=19.1U PD=19.1U rfmode=0
XM_250 n1243 IBIAS_IA AVSS AVSS sg13_lv_nmos L=2U W=1U AS=0.34P AD=0.34P PS=2.68U PD=2.68U rfmode=0
XM_251 n1243 IBIAS_IA AVSS AVSS sg13_lv_nmos L=2U W=1U AS=0.34P AD=0.34P PS=2.68U PD=2.68U rfmode=0
XM_252 n1588 n1580 AVSS AVSS sg13_lv_nmos L=2U W=9.21U AS=3.1314P AD=3.1314P PS=19.1U PD=19.1U rfmode=0
XM_253 n1246 IBIAS_IA AVSS AVSS sg13_lv_nmos L=2U W=1U AS=0.34P AD=0.34P PS=2.68U PD=2.68U rfmode=0
XM_254 IBIAS_IA IBIAS_IA AVSS AVSS sg13_lv_nmos L=2U W=1U AS=0.34P AD=0.34P PS=2.68U PD=2.68U rfmode=0
XM_255 n1588 n1579 n1599 AVSS sg13_lv_nmos L=2U W=6.41U AS=2.1794P AD=2.1794P PS=13.5U PD=13.5U rfmode=0
XM_256 n1245 IBIAS_IA AVSS AVSS sg13_lv_nmos L=2U W=1U AS=0.34P AD=0.34P PS=2.68U PD=2.68U rfmode=0
XM_257 n1246 IBIAS_IA AVSS AVSS sg13_lv_nmos L=2U W=1U AS=0.34P AD=0.34P PS=2.68U PD=2.68U rfmode=0
XM_258 IBIAS_IA IBIAS_IA AVSS AVSS sg13_lv_nmos L=2U W=1U AS=0.34P AD=0.34P PS=2.68U PD=2.68U rfmode=0
XM_259 n1246 IBIAS_IA AVSS AVSS sg13_lv_nmos L=2U W=1U AS=0.34P AD=0.34P PS=2.68U PD=2.68U rfmode=0
XM_260 n1245 IBIAS_IA AVSS AVSS sg13_lv_nmos L=2U W=1U AS=0.34P AD=0.34P PS=2.68U PD=2.68U rfmode=0
XM_261 n1243 IBIAS_IA AVSS AVSS sg13_lv_nmos L=2U W=1U AS=0.34P AD=0.34P PS=2.68U PD=2.68U rfmode=0
XM_262 n1243 IBIAS_IA AVSS AVSS sg13_lv_nmos L=2U W=1U AS=0.34P AD=0.34P PS=2.68U PD=2.68U rfmode=0
XM_263 n1243 IBIAS_IA AVSS AVSS sg13_lv_nmos L=2U W=1U AS=0.34P AD=0.34P PS=2.68U PD=2.68U rfmode=0
XM_264 n1243 IBIAS_IA AVSS AVSS sg13_lv_nmos L=2U W=1U AS=0.34P AD=0.34P PS=2.68U PD=2.68U rfmode=0
XM_265 n1243 IBIAS_IA AVSS AVSS sg13_lv_nmos L=2U W=1U AS=0.34P AD=0.34P PS=2.68U PD=2.68U rfmode=0
XM_266 n1243 IBIAS_IA AVSS AVSS sg13_lv_nmos L=2U W=1U AS=0.34P AD=0.34P PS=2.68U PD=2.68U rfmode=0
XM_267 n1243 IBIAS_IA AVSS AVSS sg13_lv_nmos L=2U W=1U AS=0.34P AD=0.34P PS=2.68U PD=2.68U rfmode=0
XM_268 n1243 IBIAS_IA AVSS AVSS sg13_lv_nmos L=2U W=1U AS=0.34P AD=0.34P PS=2.68U PD=2.68U rfmode=0
XM_269 n1243 IBIAS_IA AVSS AVSS sg13_lv_nmos L=2U W=1U AS=0.34P AD=0.34P PS=2.68U PD=2.68U rfmode=0
XM_270 AVSS n1426 n1426 AVSS sg13_lv_nmos L=2U W=0.87U AS=0.2958P AD=0.2958P PS=2.42U PD=2.42U rfmode=0
XM_271 n1706 n1426 AVSS AVSS sg13_lv_nmos L=2U W=0.87U AS=0.2958P AD=0.2958P PS=2.42U PD=2.42U rfmode=0
XM_272 n1654 n1426 AVSS AVSS sg13_lv_nmos L=2U W=1.74U AS=0.5916P AD=0.5916P PS=4.16U PD=4.16U rfmode=0
XM_273 n1645 n1579 n1581 AVSS sg13_lv_nmos L=2U W=6.41U AS=2.1794P AD=2.1794P PS=13.5U PD=13.5U rfmode=0
XM_274 n1648 n1648 AVSS AVSS sg13_lv_nmos L=0.5U W=2.1U AS=0.714P AD=0.714P PS=4.88U PD=4.88U rfmode=0
XM_275 n1748 n1748 n1648 AVSS sg13_lv_nmos L=0.5U W=0.84U AS=0.2856P AD=0.2856P PS=2.36U PD=2.36U rfmode=0
XM_276 n1667 n1623 AVSS AVSS sg13_lv_nmos L=0.5U W=8.4U AS=2.856P AD=2.856P PS=17.48U PD=17.48U rfmode=0
XM_277 n1599 n1748 n1623 AVSS sg13_lv_nmos L=0.5U W=0.84U AS=0.2856P AD=0.2856P PS=2.36U PD=2.36U rfmode=0
XM_278 VOUT n1843 AVSS AVSS sg13_lv_nmos L=3U W=5U AS=1.8P AD=0.95P PS=10.72U PD=5.38U rfmode=0
XM_279 AVSS n1843 VOUT AVSS sg13_lv_nmos L=3U W=5U AS=0.95P AD=0.95P PS=5.38U PD=5.38U rfmode=0
XM_280 VOUT n1843 AVSS AVSS sg13_lv_nmos L=3U W=5U AS=0.95P AD=0.95P PS=5.38U PD=5.38U rfmode=0
XM_281 AVSS n1843 VOUT AVSS sg13_lv_nmos L=3U W=5U AS=0.95P AD=1.7P PS=5.38U PD=10.68U rfmode=0
XM_282 n1842 n1842 AVSS AVSS sg13_lv_nmos L=5U W=5U AS=1.7P AD=0.95P PS=10.68U PD=5.38U rfmode=0
XM_283 AVSS n1842 n1842 AVSS sg13_lv_nmos L=5U W=5U AS=0.95P AD=1.8P PS=5.38U PD=10.72U rfmode=0
XM_284 n1843 n1842 AVSS AVSS sg13_lv_nmos L=5U W=5U AS=1.8P AD=0.95P PS=10.72U PD=5.38U rfmode=0
XM_285 AVSS n1842 n1843 AVSS sg13_lv_nmos L=5U W=5U AS=0.95P AD=1.7P PS=5.38U PD=10.68U rfmode=0
XM_286 n1851 n1859 AVSS AVSS sg13_lv_nmos L=0.13U W=0.74U AS=0.2516P AD=0.2516P PS=2.16U PD=2.16U rfmode=0
XM_287 n1852 n826 AVSS AVSS sg13_lv_nmos L=0.13U W=0.74U AS=0.2516P AD=0.2516P PS=2.16U PD=2.16U rfmode=0
XM_288 n1853 n996 AVSS AVSS sg13_lv_nmos L=0.13U W=0.74U AS=0.2516P AD=0.2516P PS=2.16U PD=2.16U rfmode=0
XM_289 n1854 n976 AVSS AVSS sg13_lv_nmos L=0.13U W=0.74U AS=0.2516P AD=0.2516P PS=2.16U PD=2.16U rfmode=0
XM_290 n1855 n677 AVSS AVSS sg13_lv_nmos L=0.13U W=0.74U AS=0.2516P AD=0.2516P PS=2.16U PD=2.16U rfmode=0
XM_291 n1856 n979 AVSS AVSS sg13_lv_nmos L=0.13U W=0.74U AS=0.2516P AD=0.2516P PS=2.16U PD=2.16U rfmode=0
XM_292 n2040 n976 n1766 AVSS sg13_lv_nmos L=0.13U W=0.18U AS=0.1026P AD=0.1026P PS=1.34U PD=1.34U rfmode=0
XM_293 n2041 n677 n1766 AVSS sg13_lv_nmos L=0.13U W=0.18U AS=0.1026P AD=0.1026P PS=1.34U PD=1.34U rfmode=0
XM_294 n2042 n979 n1766 AVSS sg13_lv_nmos L=0.13U W=0.18U AS=0.1026P AD=0.1026P PS=1.34U PD=1.34U rfmode=0
XM_295 n2038 n826 n1766 AVSS sg13_lv_nmos L=0.13U W=0.3U AS=0.102P AD=0.102P PS=1.28U PD=1.28U rfmode=0
XM_296 n2039 n996 n1766 AVSS sg13_lv_nmos L=0.13U W=0.2U AS=0.104P AD=0.104P PS=1.34U PD=1.34U rfmode=0
XM_297 n2075 n677 AVSS AVSS sg13_lv_nmos L=0.13U W=0.74U AS=0.2516P AD=0.1406P PS=2.16U PD=1.12U rfmode=0
XM_298 AVSS n979 n2075 AVSS sg13_lv_nmos L=0.13U W=0.74U AS=0.1406P AD=0.2516P PS=1.12U PD=2.16U rfmode=0
XM_299 n2037 n1859 n1766 AVSS sg13_lv_nmos L=0.13U W=0.4U AS=0.136P AD=0.136P PS=1.48U PD=1.48U rfmode=0
XM_300 n2074 n826 AVSS AVSS sg13_lv_nmos L=0.13U W=0.77U AS=0.2618P AD=0.1694P PS=2.22U PD=1.21U rfmode=0
XM_301 AVSS n996 n2074 AVSS sg13_lv_nmos L=0.13U W=0.77U AS=0.1694P AD=0.1463P PS=1.21U PD=1.15U rfmode=0
XM_302 n2074 n976 AVSS AVSS sg13_lv_nmos L=0.13U W=0.77U AS=0.1463P AD=0.2618P PS=1.15U PD=2.22U rfmode=0
XM_303 n2080 n2074 n2079 AVSS sg13_lv_nmos L=0.13U W=0.64U AS=0.2176P AD=0.1216P PS=1.96U PD=1.02U rfmode=0
XM_304 n2080 n2075 AVSS AVSS sg13_lv_nmos L=0.13U W=0.64U AS=0.1331P AD=0.1216P PS=1.12U PD=1.02U rfmode=0
XM_305 n1859 n2079 AVSS AVSS sg13_lv_nmos L=0.13U W=0.74U AS=0.1331P AD=0.2516P PS=1.12U PD=2.16U rfmode=0
XM_306 n98 VINP n360 AVDD sg13_lv_pmos L=3U W=5U AS=1.7P AD=0.95P PS=10.68U PD=5.38U rfmode=0
XM_307 n360 VINP n98 AVDD sg13_lv_pmos L=3U W=5U AS=0.95P AD=0.95P PS=5.38U PD=5.38U rfmode=0
XM_308 n98 VINP n360 AVDD sg13_lv_pmos L=3U W=5U AS=0.95P AD=0.95P PS=5.38U PD=5.38U rfmode=0
XM_309 n360 VINP n98 AVDD sg13_lv_pmos L=3U W=5U AS=0.95P AD=1.7P PS=5.38U PD=10.68U rfmode=0
XM_310 n97 n240 n360 AVDD sg13_lv_pmos L=3U W=5U AS=1.7P AD=0.95P PS=10.68U PD=5.38U rfmode=0
XM_311 n360 n240 n97 AVDD sg13_lv_pmos L=3U W=5U AS=0.95P AD=0.95P PS=5.38U PD=5.38U rfmode=0
XM_312 n97 n240 n360 AVDD sg13_lv_pmos L=3U W=5U AS=0.95P AD=0.95P PS=5.38U PD=5.38U rfmode=0
XM_313 n360 n240 n97 AVDD sg13_lv_pmos L=3U W=5U AS=0.95P AD=1.7P PS=5.38U PD=10.68U rfmode=0
XM_314 AVDD n236 n119 AVDD sg13_lv_pmos L=2U W=7.33U AS=2.4922P AD=2.4922P PS=15.34U PD=15.34U rfmode=0
XM_315 n110 n497 AVDD AVDD sg13_lv_pmos L=2U W=5.75U AS=1.955P AD=1.0925P PS=12.18U PD=6.13U rfmode=0
XM_316 AVDD n497 n110 AVDD sg13_lv_pmos L=2U W=5.75U AS=1.0925P AD=1.0925P PS=6.13U PD=6.13U rfmode=0
XM_317 n110 n497 AVDD AVDD sg13_lv_pmos L=2U W=5.75U AS=1.0925P AD=1.0925P PS=6.13U PD=6.13U rfmode=0
XM_318 AVDD n497 n110 AVDD sg13_lv_pmos L=2U W=5.75U AS=1.0925P AD=1.955P PS=6.13U PD=12.18U rfmode=0
XM_319 n390 n390 AVDD AVDD sg13_lv_pmos L=0.5U W=5.55U AS=1.887P AD=1.887P PS=11.78U PD=11.78U rfmode=0
XM_320 n390 n345 n345 AVDD sg13_lv_pmos L=0.5U W=2.2U AS=0.748P AD=0.748P PS=5.08U PD=5.08U rfmode=0
XM_321 AVDD n1243 n96 AVDD sg13_lv_pmos L=0.15U W=0.15U AS=0.1005P AD=0.1545P PS=1.34U PD=1.7U rfmode=0
XM_322 AVDD n1243 n96 AVDD sg13_lv_pmos L=0.15U W=0.15U AS=0.1005P AD=0.1545P PS=1.34U PD=1.7U rfmode=0
XM_323 AVDD n1243 n96 AVDD sg13_lv_pmos L=0.15U W=0.15U AS=0.1005P AD=0.1545P PS=1.34U PD=1.7U rfmode=0
XM_324 AVDD n1243 n96 AVDD sg13_lv_pmos L=0.15U W=0.15U AS=0.1005P AD=0.1545P PS=1.34U PD=1.7U rfmode=0
XM_325 AVDD n1243 n96 AVDD sg13_lv_pmos L=0.15U W=0.15U AS=0.1005P AD=0.1545P PS=1.34U PD=1.7U rfmode=0
XM_326 AVDD n1243 n96 AVDD sg13_lv_pmos L=0.15U W=0.15U AS=0.1005P AD=0.1545P PS=1.34U PD=1.7U rfmode=0
XM_327 AVDD n1243 n96 AVDD sg13_lv_pmos L=0.15U W=0.15U AS=0.1005P AD=0.1545P PS=1.34U PD=1.7U rfmode=0
XM_328 AVDD n1243 n96 AVDD sg13_lv_pmos L=0.15U W=0.15U AS=0.1005P AD=0.1545P PS=1.34U PD=1.7U rfmode=0
XM_329 AVDD n1243 n360 AVDD sg13_lv_pmos L=0.15U W=0.15U AS=0.1005P AD=0.1545P PS=1.34U PD=1.7U rfmode=0
XM_330 AVDD n1243 n360 AVDD sg13_lv_pmos L=0.15U W=0.15U AS=0.1005P AD=0.1545P PS=1.34U PD=1.7U rfmode=0
XM_331 AVDD n1243 n360 AVDD sg13_lv_pmos L=0.15U W=0.15U AS=0.1005P AD=0.1545P PS=1.34U PD=1.7U rfmode=0
XM_332 AVDD n1243 n360 AVDD sg13_lv_pmos L=0.15U W=0.15U AS=0.1005P AD=0.1545P PS=1.34U PD=1.7U rfmode=0
XM_333 AVDD n1243 n1243 AVDD sg13_lv_pmos L=0.15U W=0.15U AS=0.1005P AD=0.1545P PS=1.34U PD=1.7U rfmode=0
XM_334 AVDD n236 n236 AVDD sg13_lv_pmos L=2U W=7.33U AS=2.4922P AD=2.4922P PS=15.34U PD=15.34U rfmode=0
XM_335 n359 n119 AVDD AVDD sg13_lv_pmos L=0.5U W=5.55U AS=1.887P AD=1.0545P PS=11.78U PD=5.93U rfmode=0
XM_336 AVDD n119 n359 AVDD sg13_lv_pmos L=0.5U W=5.55U AS=1.0545P AD=1.0545P PS=5.93U PD=5.93U rfmode=0
XM_337 n359 n119 AVDD AVDD sg13_lv_pmos L=0.5U W=5.55U AS=1.0545P AD=1.0545P PS=5.93U PD=5.93U rfmode=0
XM_338 AVDD n119 n359 AVDD sg13_lv_pmos L=0.5U W=5.55U AS=1.0545P AD=1.887P PS=5.93U PD=11.78U rfmode=0
XM_339 n132 VCM n389 AVDD sg13_lv_pmos L=2U W=6.64U AS=2.2576P AD=1.2616P PS=13.96U PD=7.02U rfmode=0
XM_340 n389 VCM n132 AVDD sg13_lv_pmos L=2U W=6.64U AS=1.2616P AD=1.2616P PS=7.02U PD=7.02U rfmode=0
XM_341 n132 VCM n389 AVDD sg13_lv_pmos L=2U W=6.64U AS=1.2616P AD=1.2616P PS=7.02U PD=7.02U rfmode=0
XM_342 n389 VCM n132 AVDD sg13_lv_pmos L=2U W=6.64U AS=1.2616P AD=2.2576P PS=7.02U PD=13.96U rfmode=0
XM_343 AVDD n497 n119 AVDD sg13_lv_pmos L=2U W=9.21U AS=3.1314P AD=3.1314P PS=19.1U PD=19.1U rfmode=0
XM_344 n497 n497 AVDD AVDD sg13_lv_pmos L=2U W=2.3U AS=0.782P AD=0.782P PS=5.28U PD=5.28U rfmode=0
XM_345 n353 n345 n119 AVDD sg13_lv_pmos L=0.5U W=2.2U AS=0.748P AD=0.748P PS=5.08U PD=5.08U rfmode=0
XM_346 n517 n1243 AVDD AVDD sg13_lv_pmos L=0.15U W=0.15U AS=0.1545P AD=0.1005P PS=1.7U PD=1.34U rfmode=0
XM_347 n517 n1243 AVDD AVDD sg13_lv_pmos L=0.15U W=0.15U AS=0.1545P AD=0.1005P PS=1.7U PD=1.34U rfmode=0
XM_348 n517 n1243 AVDD AVDD sg13_lv_pmos L=0.15U W=0.15U AS=0.1545P AD=0.1005P PS=1.7U PD=1.34U rfmode=0
XM_349 n517 n1243 AVDD AVDD sg13_lv_pmos L=0.15U W=0.15U AS=0.1545P AD=0.1005P PS=1.7U PD=1.34U rfmode=0
XM_350 n517 n1243 AVDD AVDD sg13_lv_pmos L=0.15U W=0.15U AS=0.1545P AD=0.1005P PS=1.7U PD=1.34U rfmode=0
XM_351 n517 n1243 AVDD AVDD sg13_lv_pmos L=0.15U W=0.15U AS=0.1545P AD=0.1005P PS=1.7U PD=1.34U rfmode=0
XM_352 n517 n1243 AVDD AVDD sg13_lv_pmos L=0.15U W=0.15U AS=0.1545P AD=0.1005P PS=1.7U PD=1.34U rfmode=0
XM_353 n517 n1243 AVDD AVDD sg13_lv_pmos L=0.15U W=0.15U AS=0.1545P AD=0.1005P PS=1.7U PD=1.34U rfmode=0
XM_354 n623 n1243 AVDD AVDD sg13_lv_pmos L=0.15U W=0.15U AS=0.1545P AD=0.1005P PS=1.7U PD=1.34U rfmode=0
XM_355 n623 n1243 AVDD AVDD sg13_lv_pmos L=0.15U W=0.15U AS=0.1545P AD=0.1005P PS=1.7U PD=1.34U rfmode=0
XM_356 n623 n1243 AVDD AVDD sg13_lv_pmos L=0.15U W=0.15U AS=0.1545P AD=0.1005P PS=1.7U PD=1.34U rfmode=0
XM_357 n623 n1243 AVDD AVDD sg13_lv_pmos L=0.15U W=0.15U AS=0.1545P AD=0.1005P PS=1.7U PD=1.34U rfmode=0
XM_358 n1243 n1243 AVDD AVDD sg13_lv_pmos L=0.15U W=0.15U AS=0.1545P AD=0.1005P PS=1.7U PD=1.34U rfmode=0
XM_359 n389 n653 AVDD AVDD sg13_lv_pmos L=2U W=7.46U AS=2.5364P AD=2.5364P PS=15.6U PD=15.6U rfmode=0
XM_360 n389 n653 AVDD AVDD sg13_lv_pmos L=2U W=7.46U AS=2.5364P AD=2.5364P PS=15.6U PD=15.6U rfmode=0
XM_361 n389 n653 AVDD AVDD sg13_lv_pmos L=2U W=7.46U AS=2.5364P AD=2.5364P PS=15.6U PD=15.6U rfmode=0
XM_362 n389 n653 AVDD AVDD sg13_lv_pmos L=2U W=7.46U AS=2.5364P AD=2.5364P PS=15.6U PD=15.6U rfmode=0
XM_363 n389 n653 AVDD AVDD sg13_lv_pmos L=2U W=7.46U AS=2.5364P AD=2.5364P PS=15.6U PD=15.6U rfmode=0
XM_364 n389 n653 AVDD AVDD sg13_lv_pmos L=2U W=7.46U AS=2.5364P AD=2.5364P PS=15.6U PD=15.6U rfmode=0
XM_365 n389 n653 AVDD AVDD sg13_lv_pmos L=2U W=7.46U AS=2.5364P AD=2.5364P PS=15.6U PD=15.6U rfmode=0
XM_366 n389 n653 AVDD AVDD sg13_lv_pmos L=2U W=7.46U AS=2.5364P AD=2.5364P PS=15.6U PD=15.6U rfmode=0
XM_367 n93 n1026 n389 AVDD sg13_lv_pmos L=2U W=6.64U AS=2.2576P AD=1.2616P PS=13.96U PD=7.02U rfmode=0
XM_368 n389 n1026 n93 AVDD sg13_lv_pmos L=2U W=6.64U AS=1.2616P AD=1.2616P PS=7.02U PD=7.02U rfmode=0
XM_369 n93 n1026 n389 AVDD sg13_lv_pmos L=2U W=6.64U AS=1.2616P AD=1.2616P PS=7.02U PD=7.02U rfmode=0
XM_370 n389 n1026 n93 AVDD sg13_lv_pmos L=2U W=6.64U AS=1.2616P AD=2.2576P PS=7.02U PD=13.96U rfmode=0
XM_371 n111 n497 AVDD AVDD sg13_lv_pmos L=2U W=5.75U AS=1.955P AD=1.0925P PS=12.18U PD=6.13U rfmode=0
XM_372 AVDD n497 n111 AVDD sg13_lv_pmos L=2U W=5.75U AS=1.0925P AD=1.955P PS=6.13U PD=12.18U rfmode=0
XM_373 n653 n653 AVDD AVDD sg13_lv_pmos L=2U W=7.46U AS=2.5364P AD=2.5364P PS=15.6U PD=15.6U rfmode=0
XM_374 n653 n653 AVDD AVDD sg13_lv_pmos L=2U W=7.46U AS=2.5364P AD=2.5364P PS=15.6U PD=15.6U rfmode=0
XM_375 n653 n653 AVDD AVDD sg13_lv_pmos L=2U W=7.46U AS=2.5364P AD=2.5364P PS=15.6U PD=15.6U rfmode=0
XM_376 n653 n653 AVDD AVDD sg13_lv_pmos L=2U W=7.46U AS=2.5364P AD=2.5364P PS=15.6U PD=15.6U rfmode=0
XM_377 AVDD n497 n344 AVDD sg13_lv_pmos L=2U W=4.6U AS=1.564P AD=1.564P PS=9.88U PD=9.88U rfmode=0
XM_378 n653 n653 AVDD AVDD sg13_lv_pmos L=2U W=7.46U AS=2.5364P AD=2.5364P PS=15.6U PD=15.6U rfmode=0
XM_379 n653 n653 AVDD AVDD sg13_lv_pmos L=2U W=7.46U AS=2.5364P AD=2.5364P PS=15.6U PD=15.6U rfmode=0
XM_380 n653 n653 AVDD AVDD sg13_lv_pmos L=2U W=7.46U AS=2.5364P AD=2.5364P PS=15.6U PD=15.6U rfmode=0
XM_381 n653 n653 AVDD AVDD sg13_lv_pmos L=2U W=7.46U AS=2.5364P AD=2.5364P PS=15.6U PD=15.6U rfmode=0
XM_382 n624 n654 n623 AVDD sg13_lv_pmos L=3U W=5U AS=1.7P AD=0.95P PS=10.68U PD=5.38U rfmode=0
XM_383 n623 n654 n624 AVDD sg13_lv_pmos L=3U W=5U AS=0.95P AD=0.95P PS=5.38U PD=5.38U rfmode=0
XM_384 n624 n654 n623 AVDD sg13_lv_pmos L=3U W=5U AS=0.95P AD=0.95P PS=5.38U PD=5.38U rfmode=0
XM_385 n623 n654 n624 AVDD sg13_lv_pmos L=3U W=5U AS=0.95P AD=1.7P PS=5.38U PD=10.68U rfmode=0
XM_386 n625 n655 n623 AVDD sg13_lv_pmos L=3U W=5U AS=1.7P AD=0.95P PS=10.68U PD=5.38U rfmode=0
XM_387 n623 n655 n625 AVDD sg13_lv_pmos L=3U W=5U AS=0.95P AD=0.95P PS=5.38U PD=5.38U rfmode=0
XM_388 n625 n655 n623 AVDD sg13_lv_pmos L=3U W=5U AS=0.95P AD=0.95P PS=5.38U PD=5.38U rfmode=0
XM_389 n623 n655 n625 AVDD sg13_lv_pmos L=3U W=5U AS=0.95P AD=1.7P PS=5.38U PD=10.68U rfmode=0
XM_390 n650 n650 VINP AVDD sg13_lv_pmos L=2U W=0.2U AS=0.104P AD=0.104P PS=1.34U PD=1.34U rfmode=0
XM_391 n681 gain_sel[1] VPWR VPWR sg13_lv_pmos L=0.13U W=0.84U AS=0.2114P AD=0.2856P PS=1.54U PD=2.36U rfmode=0
XM_392 n664 n681 VPWR VPWR sg13_lv_pmos L=0.13U W=1.12U AS=0.2114P AD=0.42P PS=1.54U PD=2.99U rfmode=0
XM_393 n682 gain_sel[0] VPWR VPWR sg13_lv_pmos L=0.13U W=0.84U AS=0.2114P AD=0.2856P PS=1.54U PD=2.36U rfmode=0
XM_394 n665 n682 VPWR VPWR sg13_lv_pmos L=0.13U W=1.12U AS=0.2114P AD=0.42P PS=1.54U PD=2.99U rfmode=0
XM_395 n806 n928 n666 VPWR sg13_lv_pmos L=0.13U W=1.12U AS=0.3808P AD=0.1176P PS=2.92U PD=1.33U rfmode=0
XM_396 VPWR n818 n806 VPWR sg13_lv_pmos L=0.13U W=1.12U AS=0.1176P AD=0.4032P PS=1.33U PD=2.96U rfmode=0
XM_397 n668 n665 VPWR VPWR sg13_lv_pmos L=0.13U W=1.12U AS=0.3808P AD=0.2128P PS=2.92U PD=1.5U rfmode=0
XM_398 VPWR n664 n668 VPWR sg13_lv_pmos L=0.13U W=1.12U AS=0.2128P AD=0.3808P PS=1.5U PD=2.92U rfmode=0
XM_399 n689 n660 VPWR VPWR sg13_lv_pmos L=0.13U W=0.84U AS=0.2114P AD=0.2856P PS=1.54U PD=2.36U rfmode=0
XM_400 n1014 n689 VPWR VPWR sg13_lv_pmos L=0.13U W=1.12U AS=0.2114P AD=0.42P PS=1.54U PD=2.99U rfmode=0
XM_401 n690 n965 VPWR VPWR sg13_lv_pmos L=0.13U W=0.84U AS=0.2114P AD=0.2856P PS=1.54U PD=2.36U rfmode=0
XM_402 n1023 n690 VPWR VPWR sg13_lv_pmos L=0.13U W=1.12U AS=0.2114P AD=0.42P PS=1.54U PD=2.99U rfmode=0
XM_403 n691 n669 VPWR VPWR sg13_lv_pmos L=0.13U W=0.84U AS=0.2114P AD=0.2856P PS=1.54U PD=2.36U rfmode=0
XM_404 n1022 n691 VPWR VPWR sg13_lv_pmos L=0.13U W=1.12U AS=0.2114P AD=0.42P PS=1.54U PD=2.99U rfmode=0
XM_405 n672 n692 VPWR VPWR sg13_lv_pmos L=0.13U W=1.12U AS=0.3808P AD=0.2128P PS=2.92U PD=1.5U rfmode=0
XM_406 VPWR n837 n672 VPWR sg13_lv_pmos L=0.13U W=1.12U AS=0.2128P AD=0.3808P PS=1.5U PD=2.92U rfmode=0
XM_407 n693 n703 VPWR VPWR sg13_lv_pmos L=0.13U W=0.84U AS=0.2114P AD=0.2856P PS=1.54U PD=2.36U rfmode=0
XM_408 n1021 n693 VPWR VPWR sg13_lv_pmos L=0.13U W=1.12U AS=0.2114P AD=0.42P PS=1.54U PD=2.99U rfmode=0
XM_409 n694 n671 VPWR VPWR sg13_lv_pmos L=0.13U W=0.84U AS=0.2114P AD=0.2856P PS=1.54U PD=2.36U rfmode=0
XM_410 n1020 n694 VPWR VPWR sg13_lv_pmos L=0.13U W=1.12U AS=0.2114P AD=0.42P PS=1.54U PD=2.99U rfmode=0
XM_411 n695 n705 VPWR VPWR sg13_lv_pmos L=0.13U W=0.84U AS=0.2114P AD=0.2856P PS=1.54U PD=2.36U rfmode=0
XM_412 n663 n695 VPWR VPWR sg13_lv_pmos L=0.13U W=1.12U AS=0.2114P AD=0.42P PS=1.54U PD=2.99U rfmode=0
XM_413 n696 n706 VPWR VPWR sg13_lv_pmos L=0.13U W=0.84U AS=0.2114P AD=0.2856P PS=1.54U PD=2.36U rfmode=0
XM_414 n674 n696 VPWR VPWR sg13_lv_pmos L=0.13U W=1.12U AS=0.2114P AD=0.42P PS=1.54U PD=2.99U rfmode=0
XM_415 n697 n707 VPWR VPWR sg13_lv_pmos L=0.13U W=0.84U AS=0.2114P AD=0.2856P PS=1.54U PD=2.36U rfmode=0
XM_416 n675 n697 VPWR VPWR sg13_lv_pmos L=0.13U W=1.12U AS=0.2114P AD=0.42P PS=1.54U PD=2.99U rfmode=0
XM_417 n676 n652 VPWR VPWR sg13_lv_pmos L=0.13U W=1.12U AS=0.3808P AD=0.2128P PS=2.92U PD=1.5U rfmode=0
XM_418 VPWR n818 n676 VPWR sg13_lv_pmos L=0.13U W=1.12U AS=0.2128P AD=0.3808P PS=1.5U PD=2.92U rfmode=0
XM_419 n698 n708 VPWR VPWR sg13_lv_pmos L=0.13U W=0.84U AS=0.2114P AD=0.2856P PS=1.54U PD=2.36U rfmode=0
XM_420 n677 n698 VPWR VPWR sg13_lv_pmos L=0.13U W=1.12U AS=0.2114P AD=0.42P PS=1.54U PD=2.99U rfmode=0
XM_421 n699 n971 VPWR VPWR sg13_lv_pmos L=0.13U W=0.84U AS=0.2114P AD=0.2856P PS=1.54U PD=2.36U rfmode=0
XM_422 n678 n699 VPWR VPWR sg13_lv_pmos L=0.13U W=1.12U AS=0.2114P AD=0.42P PS=1.54U PD=2.99U rfmode=0
XM_423 VCM n650 n650 AVDD sg13_lv_pmos L=2U W=0.2U AS=0.104P AD=0.104P PS=1.34U PD=1.34U rfmode=0
XM_424 VPWR VGND VPWR VPWR sg13_lv_pmos L=1U W=1U AS=0.34P AD=0.19P PS=2.68U PD=1.38U rfmode=0
XM_425 VPWR VGND VPWR VPWR sg13_lv_pmos L=1U W=1U AS=0.19P AD=0.34P PS=1.38U PD=2.68U rfmode=0
XM_426 VPWR VGND VPWR VPWR sg13_lv_pmos L=1U W=1U AS=0.34P AD=0.19P PS=2.68U PD=1.38U rfmode=0
XM_427 VPWR VGND VPWR VPWR sg13_lv_pmos L=1U W=1U AS=0.19P AD=0.34P PS=1.38U PD=2.68U rfmode=0
XM_428 VPWR VGND VPWR VPWR sg13_lv_pmos L=1U W=1U AS=0.34P AD=0.19P PS=2.68U PD=1.38U rfmode=0
XM_429 VPWR VGND VPWR VPWR sg13_lv_pmos L=1U W=1U AS=0.19P AD=0.34P PS=1.38U PD=2.68U rfmode=0
XM_430 VPWR VGND VPWR VPWR sg13_lv_pmos L=1U W=1U AS=0.34P AD=0.19P PS=2.68U PD=1.38U rfmode=0
XM_431 VPWR VGND VPWR VPWR sg13_lv_pmos L=1U W=1U AS=0.19P AD=0.34P PS=1.38U PD=2.68U rfmode=0
XM_432 VPWR VGND VPWR VPWR sg13_lv_pmos L=1U W=1U AS=0.34P AD=0.19P PS=2.68U PD=1.38U rfmode=0
XM_433 VPWR VGND VPWR VPWR sg13_lv_pmos L=1U W=1U AS=0.19P AD=0.34P PS=1.38U PD=2.68U rfmode=0
XM_434 VPWR VGND VPWR VPWR sg13_lv_pmos L=1U W=1U AS=0.34P AD=0.19P PS=2.68U PD=1.38U rfmode=0
XM_435 VPWR VGND VPWR VPWR sg13_lv_pmos L=1U W=1U AS=0.19P AD=0.34P PS=1.38U PD=2.68U rfmode=0
XM_436 n815 n665 VPWR VPWR sg13_lv_pmos L=0.13U W=1.12U AS=0.3808P AD=0.3808P PS=2.92U PD=2.92U rfmode=0
XM_437 n849 n664 VPWR VPWR sg13_lv_pmos L=0.13U W=1.12U AS=0.3808P AD=0.2464P PS=2.92U PD=1.56U rfmode=0
XM_438 n848 n815 n849 VPWR sg13_lv_pmos L=0.13U W=1.12U AS=0.2464P AD=0.2128P PS=1.56U PD=1.5U rfmode=0
XM_439 n652 n928 n848 VPWR sg13_lv_pmos L=0.13U W=1.12U AS=0.2128P AD=0.3808P PS=1.5U PD=2.92U rfmode=0
XM_440 VPWR VGND VPWR VPWR sg13_lv_pmos L=1U W=1U AS=0.34P AD=0.34P PS=2.68U PD=2.68U rfmode=0
XM_441 VPWR n664 n684 VPWR sg13_lv_pmos L=0.13U W=1.12U AS=0.3808P AD=0.2128P PS=2.92U PD=1.5U rfmode=0
XM_442 n684 n665 VPWR VPWR sg13_lv_pmos L=0.13U W=1.12U AS=0.2128P AD=0.2128P PS=1.5U PD=1.5U rfmode=0
XM_443 VPWR n666 n684 VPWR sg13_lv_pmos L=0.13U W=1.12U AS=0.2128P AD=0.3808P PS=1.5U PD=2.92U rfmode=0
XM_444 n833 n664 VPWR VPWR sg13_lv_pmos L=0.13U W=0.84U AS=0.2618P AD=0.2856P PS=1.63U PD=2.36U rfmode=0
XM_445 n850 n833 VPWR VPWR sg13_lv_pmos L=0.13U W=1.12U AS=0.2618P AD=0.1176P PS=1.63U PD=1.33U rfmode=0
XM_446 n816 n665 n850 VPWR sg13_lv_pmos L=0.13U W=1.12U AS=0.1176P AD=0.3808P PS=1.33U PD=2.92U rfmode=0
XM_447 n706 n666 VPWR VPWR sg13_lv_pmos L=0.13U W=1.12U AS=0.3808P AD=0.2128P PS=2.92U PD=1.5U rfmode=0
XM_448 VPWR n816 n706 VPWR sg13_lv_pmos L=0.13U W=1.12U AS=0.2128P AD=0.3808P PS=1.5U PD=2.92U rfmode=0
XM_449 VPWR VGND VPWR VPWR sg13_lv_pmos L=1U W=1U AS=0.34P AD=0.19P PS=2.68U PD=1.38U rfmode=0
XM_450 VPWR VGND VPWR VPWR sg13_lv_pmos L=1U W=1U AS=0.19P AD=0.34P PS=1.38U PD=2.68U rfmode=0
XM_451 VPWR n707 n703 VPWR sg13_lv_pmos L=0.13U W=1.12U AS=0.3808P AD=0.3808P PS=2.92U PD=2.92U rfmode=0
XM_452 VPWR VGND VPWR VPWR sg13_lv_pmos L=1U W=1U AS=0.34P AD=0.34P PS=2.68U PD=2.68U rfmode=0
XM_453 n835 n818 VPWR VPWR sg13_lv_pmos L=0.13U W=0.84U AS=0.2198P AD=0.2856P PS=1.53U PD=2.36U rfmode=0
XM_454 n686 n928 VPWR VPWR sg13_lv_pmos L=0.13U W=1.12U AS=0.2198P AD=0.2128P PS=1.53U PD=1.5U rfmode=0
XM_455 VPWR n835 n686 VPWR sg13_lv_pmos L=0.13U W=1.12U AS=0.2128P AD=0.3808P PS=1.5U PD=2.92U rfmode=0
XM_456 n669 n684 VPWR VPWR sg13_lv_pmos L=0.13U W=1.12U AS=0.3808P AD=0.3808P PS=2.92U PD=2.92U rfmode=0
XM_457 n836 n818 VPWR VPWR sg13_lv_pmos L=0.13U W=0.84U AS=0.2618P AD=0.2856P PS=1.63U PD=2.36U rfmode=0
XM_458 n869 n836 VPWR VPWR sg13_lv_pmos L=0.13U W=1.12U AS=0.2618P AD=0.1176P PS=1.63U PD=1.33U rfmode=0
XM_459 n837 n928 n869 VPWR sg13_lv_pmos L=0.13U W=1.12U AS=0.1176P AD=0.3808P PS=1.33U PD=2.92U rfmode=0
XM_460 n812 n692 VPWR VPWR sg13_lv_pmos L=0.15U W=1.12U AS=0.3808P AD=0.2128P PS=2.92U PD=1.5U rfmode=0
XM_461 n671 n686 n812 VPWR sg13_lv_pmos L=0.15U W=1.12U AS=0.2128P AD=0.2128P PS=1.5U PD=1.5U rfmode=0
XM_462 VPWR n687 n671 VPWR sg13_lv_pmos L=0.15U W=1.12U AS=0.2128P AD=0.3808P PS=1.5U PD=2.92U rfmode=0
XM_463 n839 n928 VPWR VPWR sg13_lv_pmos L=0.13U W=0.84U AS=0.2618P AD=0.2856P PS=1.63U PD=2.36U rfmode=0
XM_464 n876 n839 VPWR VPWR sg13_lv_pmos L=0.13U W=1.12U AS=0.2618P AD=0.1176P PS=1.63U PD=1.33U rfmode=0
XM_465 n819 n818 n876 VPWR sg13_lv_pmos L=0.13U W=1.12U AS=0.1176P AD=0.3808P PS=1.33U PD=2.92U rfmode=0
XM_466 n820 n692 VPWR VPWR sg13_lv_pmos L=0.13U W=1.12U AS=0.3808P AD=0.3808P PS=2.92U PD=2.92U rfmode=0
XM_467 n821 n820 VPWR VPWR sg13_lv_pmos L=0.13U W=1.12U AS=0.3808P AD=0.2716P PS=2.92U PD=1.605U rfmode=0
XM_468 n840 n837 n821 VPWR sg13_lv_pmos L=0.13U W=1.12U AS=0.2716P AD=0.2128P PS=1.605U PD=1.5U rfmode=0
XM_469 n821 n668 n840 VPWR sg13_lv_pmos L=0.13U W=1.12U AS=0.2128P AD=0.2744P PS=1.5U PD=1.61U rfmode=0
XM_470 VPWR n819 n821 VPWR sg13_lv_pmos L=0.13U W=1.12U AS=0.2744P AD=0.3808P PS=1.61U PD=2.92U rfmode=0
XM_471 n843 n668 VPWR VPWR sg13_lv_pmos L=0.13U W=0.84U AS=0.2198P AD=0.2856P PS=1.53U PD=2.36U rfmode=0
XM_472 n938 n819 VPWR VPWR sg13_lv_pmos L=0.13U W=1.12U AS=0.2198P AD=0.2128P PS=1.53U PD=1.5U rfmode=0
XM_473 VPWR n843 n938 VPWR sg13_lv_pmos L=0.13U W=1.12U AS=0.2128P AD=0.3808P PS=1.5U PD=2.92U rfmode=0
XM_474 n822 n837 VPWR VPWR sg13_lv_pmos L=0.13U W=1.12U AS=0.3808P AD=0.2128P PS=2.92U PD=1.5U rfmode=0
XM_475 VPWR n816 n822 VPWR sg13_lv_pmos L=0.13U W=1.12U AS=0.2128P AD=0.3808P PS=1.5U PD=2.92U rfmode=0
XM_476 n707 n819 VPWR VPWR sg13_lv_pmos L=0.13U W=1.12U AS=0.3808P AD=0.2128P PS=2.92U PD=1.5U rfmode=0
XM_477 VPWR n692 n707 VPWR sg13_lv_pmos L=0.13U W=1.12U AS=0.2128P AD=0.3808P PS=1.5U PD=2.92U rfmode=0
XM_478 VPWR n684 n824 VPWR sg13_lv_pmos L=0.13U W=0.84U AS=0.2856P AD=0.2114P PS=2.36U PD=1.54U rfmode=0
XM_479 n713 n824 VPWR VPWR sg13_lv_pmos L=0.13U W=1.12U AS=0.2114P AD=0.42P PS=1.54U PD=2.99U rfmode=0
XM_480 VPWR n842 n825 VPWR sg13_lv_pmos L=0.13U W=0.84U AS=0.2856P AD=0.2114P PS=2.36U PD=1.54U rfmode=0
XM_481 n826 n825 VPWR VPWR sg13_lv_pmos L=0.13U W=1.12U AS=0.2114P AD=0.42P PS=1.54U PD=2.99U rfmode=0
XM_482 n925 n818 n660 VPWR sg13_lv_pmos L=0.13U W=1.12U AS=0.3808P AD=0.1176P PS=2.92U PD=1.33U rfmode=0
XM_483 VPWR n845 n925 VPWR sg13_lv_pmos L=0.13U W=1.12U AS=0.1176P AD=0.2618P PS=1.33U PD=1.63U rfmode=0
XM_484 n845 n652 VPWR VPWR sg13_lv_pmos L=0.13U W=0.84U AS=0.2618P AD=0.2856P PS=1.63U PD=2.36U rfmode=0
XM_485 n828 n818 VPWR VPWR sg13_lv_pmos L=0.13U W=0.84U AS=0.2856P AD=0.1596P PS=2.36U PD=1.22U rfmode=0
XM_486 VPWR n652 n828 VPWR sg13_lv_pmos L=0.13U W=0.84U AS=0.1596P AD=0.1918P PS=1.22U PD=1.5U rfmode=0
XM_487 n708 n828 VPWR VPWR sg13_lv_pmos L=0.13U W=1.12U AS=0.1918P AD=0.3808P PS=1.5U PD=2.92U rfmode=0
XM_488 n846 n818 VPWR VPWR sg13_lv_pmos L=0.13U W=0.84U AS=0.2198P AD=0.2856P PS=1.53U PD=2.36U rfmode=0
XM_489 n705 n652 VPWR VPWR sg13_lv_pmos L=0.13U W=1.12U AS=0.2198P AD=0.2128P PS=1.53U PD=1.5U rfmode=0
XM_490 VPWR n846 n705 VPWR sg13_lv_pmos L=0.13U W=1.12U AS=0.2128P AD=0.3808P PS=1.5U PD=2.92U rfmode=0
XM_491 n961 gain_sel[3] VPWR VPWR sg13_lv_pmos L=0.13U W=0.84U AS=0.2114P AD=0.2856P PS=1.54U PD=2.36U rfmode=0
XM_492 n818 n961 VPWR VPWR sg13_lv_pmos L=0.13U W=1.12U AS=0.2114P AD=0.42P PS=1.54U PD=2.99U rfmode=0
XM_493 n963 gain_sel[2] VPWR VPWR sg13_lv_pmos L=0.13U W=0.84U AS=0.2114P AD=0.2856P PS=1.54U PD=2.36U rfmode=0
XM_494 n928 n963 VPWR VPWR sg13_lv_pmos L=0.13U W=1.12U AS=0.2114P AD=0.42P PS=1.54U PD=2.99U rfmode=0
XM_495 VPWR VGND VPWR VPWR sg13_lv_pmos L=1U W=1U AS=0.34P AD=0.19P PS=2.68U PD=1.38U rfmode=0
XM_496 VPWR VGND VPWR VPWR sg13_lv_pmos L=1U W=1U AS=0.19P AD=0.34P PS=1.38U PD=2.68U rfmode=0
XM_497 VPWR VGND VPWR VPWR sg13_lv_pmos L=1U W=1U AS=0.34P AD=0.19P PS=2.68U PD=1.38U rfmode=0
XM_498 VPWR VGND VPWR VPWR sg13_lv_pmos L=1U W=1U AS=0.19P AD=0.34P PS=1.38U PD=2.68U rfmode=0
XM_499 VPWR VGND VPWR VPWR sg13_lv_pmos L=1U W=1U AS=0.34P AD=0.19P PS=2.68U PD=1.38U rfmode=0
XM_500 VPWR VGND VPWR VPWR sg13_lv_pmos L=1U W=1U AS=0.19P AD=0.34P PS=1.38U PD=2.68U rfmode=0
XM_501 VPWR VGND VPWR VPWR sg13_lv_pmos L=1U W=1U AS=0.34P AD=0.19P PS=2.68U PD=1.38U rfmode=0
XM_502 VPWR VGND VPWR VPWR sg13_lv_pmos L=1U W=1U AS=0.19P AD=0.34P PS=1.38U PD=2.68U rfmode=0
XM_503 n1018 n665 n692 VPWR sg13_lv_pmos L=0.13U W=1.12U AS=0.3808P AD=0.1176P PS=2.92U PD=1.33U rfmode=0
XM_504 VPWR n664 n1018 VPWR sg13_lv_pmos L=0.13U W=1.12U AS=0.1176P AD=0.4032P PS=1.33U PD=2.96U rfmode=0
XM_505 VPWR VGND VPWR VPWR sg13_lv_pmos L=1U W=1U AS=0.34P AD=0.19P PS=2.68U PD=1.38U rfmode=0
XM_506 VPWR VGND VPWR VPWR sg13_lv_pmos L=1U W=1U AS=0.19P AD=0.34P PS=1.38U PD=2.68U rfmode=0
XM_507 VPWR VGND VPWR VPWR sg13_lv_pmos L=1U W=1U AS=0.34P AD=0.34P PS=2.68U PD=2.68U rfmode=0
XM_508 n965 n706 VPWR VPWR sg13_lv_pmos L=0.13U W=1.12U AS=0.3808P AD=0.3808P PS=2.92U PD=2.92U rfmode=0
XM_509 n687 n837 VPWR VPWR sg13_lv_pmos L=0.13U W=1.12U AS=0.3808P AD=0.2128P PS=2.92U PD=1.5U rfmode=0
XM_510 VPWR n668 n687 VPWR sg13_lv_pmos L=0.13U W=1.12U AS=0.2128P AD=0.3808P PS=1.5U PD=2.92U rfmode=0
XM_511 VPWR n822 n967 VPWR sg13_lv_pmos L=0.13U W=1.12U AS=0.3808P AD=0.3808P PS=2.92U PD=2.92U rfmode=0
XM_512 VPWR n672 n968 VPWR sg13_lv_pmos L=0.13U W=1.12U AS=0.3808P AD=0.3808P PS=2.92U PD=2.92U rfmode=0
XM_513 VPWR n938 n969 VPWR sg13_lv_pmos L=0.13U W=1.12U AS=0.3808P AD=0.3808P PS=2.92U PD=2.92U rfmode=0
XM_514 VPWR n971 n842 VPWR sg13_lv_pmos L=0.13U W=1.12U AS=0.3808P AD=0.3808P PS=2.92U PD=2.92U rfmode=0
XM_515 n971 n816 VPWR VPWR sg13_lv_pmos L=0.13U W=1.12U AS=0.3808P AD=0.2128P PS=2.92U PD=1.5U rfmode=0
XM_516 VPWR n819 n971 VPWR sg13_lv_pmos L=0.13U W=1.12U AS=0.2128P AD=0.3808P PS=1.5U PD=2.92U rfmode=0
XM_517 n973 n840 VPWR VPWR sg13_lv_pmos L=0.13U W=0.84U AS=0.2114P AD=0.2856P PS=1.54U PD=2.36U rfmode=0
XM_518 n932 n973 VPWR VPWR sg13_lv_pmos L=0.13U W=1.12U AS=0.2114P AD=0.42P PS=1.54U PD=2.99U rfmode=0
XM_519 n974 n969 VPWR VPWR sg13_lv_pmos L=0.13U W=0.84U AS=0.2114P AD=0.2856P PS=1.54U PD=2.36U rfmode=0
XM_520 n996 n974 VPWR VPWR sg13_lv_pmos L=0.13U W=1.12U AS=0.2114P AD=0.42P PS=1.54U PD=2.99U rfmode=0
XM_521 n975 n968 VPWR VPWR sg13_lv_pmos L=0.13U W=0.84U AS=0.2114P AD=0.2856P PS=1.54U PD=2.36U rfmode=0
XM_522 n976 n975 VPWR VPWR sg13_lv_pmos L=0.13U W=1.12U AS=0.2114P AD=0.42P PS=1.54U PD=2.99U rfmode=0
XM_523 n977 n967 VPWR VPWR sg13_lv_pmos L=0.13U W=0.84U AS=0.2114P AD=0.2856P PS=1.54U PD=2.36U rfmode=0
XM_524 n979 n977 VPWR VPWR sg13_lv_pmos L=0.13U W=1.12U AS=0.2114P AD=0.42P PS=1.54U PD=2.99U rfmode=0
XM_525 n980 n938 VPWR VPWR sg13_lv_pmos L=0.13U W=0.84U AS=0.2114P AD=0.2856P PS=1.54U PD=2.36U rfmode=0
XM_526 n981 n980 VPWR VPWR sg13_lv_pmos L=0.13U W=1.12U AS=0.2114P AD=0.42P PS=1.54U PD=2.99U rfmode=0
XM_527 n982 n822 VPWR VPWR sg13_lv_pmos L=0.13U W=0.84U AS=0.2114P AD=0.2856P PS=1.54U PD=2.36U rfmode=0
XM_528 n983 n982 VPWR VPWR sg13_lv_pmos L=0.13U W=1.12U AS=0.2114P AD=0.42P PS=1.54U PD=2.99U rfmode=0
XM_529 n984 n672 VPWR VPWR sg13_lv_pmos L=0.13U W=0.84U AS=0.2114P AD=0.2856P PS=1.54U PD=2.36U rfmode=0
XM_530 n985 n984 VPWR VPWR sg13_lv_pmos L=0.13U W=1.12U AS=0.2114P AD=0.42P PS=1.54U PD=2.99U rfmode=0
XM_531 n986 n676 VPWR VPWR sg13_lv_pmos L=0.13U W=0.84U AS=0.2114P AD=0.2856P PS=1.54U PD=2.36U rfmode=0
XM_532 n987 n986 VPWR VPWR sg13_lv_pmos L=0.13U W=1.12U AS=0.2114P AD=0.42P PS=1.54U PD=2.99U rfmode=0
XM_533 AVDD n1020 n1009 AVDD sg13_lv_pmos L=0.13U W=1.12U AS=0.3808P AD=0.3808P PS=2.92U PD=2.92U rfmode=0
XM_534 n1043 n1009 n1026 AVDD sg13_lv_pmos L=0.13U W=0.54U AS=0.1836P AD=0.1836P PS=1.76U PD=1.76U rfmode=0
XM_535 AVDD n1021 n1010 AVDD sg13_lv_pmos L=0.13U W=1.12U AS=0.3808P AD=0.3808P PS=2.92U PD=2.92U rfmode=0
XM_536 n1044 n1010 n1026 AVDD sg13_lv_pmos L=0.13U W=0.54U AS=0.1836P AD=0.1836P PS=1.76U PD=1.76U rfmode=0
XM_537 AVDD n1022 n1011 AVDD sg13_lv_pmos L=0.13U W=1.12U AS=0.3808P AD=0.3808P PS=2.92U PD=2.92U rfmode=0
XM_538 n1045 n1011 n1026 AVDD sg13_lv_pmos L=0.13U W=0.54U AS=0.1836P AD=0.1836P PS=1.76U PD=1.76U rfmode=0
XM_539 AVDD n1023 n1012 AVDD sg13_lv_pmos L=0.13U W=1.12U AS=0.3808P AD=0.3808P PS=2.92U PD=2.92U rfmode=0
XM_540 n1046 n1012 n1026 AVDD sg13_lv_pmos L=0.13U W=0.6U AS=0.204P AD=0.204P PS=1.88U PD=1.88U rfmode=0
XM_541 AVDD n1014 n1013 AVDD sg13_lv_pmos L=0.13U W=1.12U AS=0.3808P AD=0.3808P PS=2.92U PD=2.92U rfmode=0
XM_542 n1047 n1013 n1026 AVDD sg13_lv_pmos L=0.13U W=0.9U AS=0.306P AD=0.306P PS=2.48U PD=2.48U rfmode=0
XM_543 AVDD n1024 n1015 AVDD sg13_lv_pmos L=0.13U W=1.12U AS=0.3808P AD=0.3808P PS=2.92U PD=2.92U rfmode=0
XM_544 VINN n847 n847 AVDD sg13_lv_pmos L=2U W=0.2U AS=0.104P AD=0.104P PS=1.34U PD=1.34U rfmode=0
XM_545 n847 n847 VCM AVDD sg13_lv_pmos L=2U W=0.2U AS=0.104P AD=0.104P PS=1.34U PD=1.34U rfmode=0
XM_546 n1048 n1015 n1026 AVDD sg13_lv_pmos L=0.13U W=1.2U AS=0.408P AD=0.408P PS=3.08U PD=3.08U rfmode=0
XM_547 AVDD n1144 n1024 AVDD sg13_lv_pmos L=0.13U W=1.12U AS=0.3808P AD=0.1918P PS=2.92U PD=1.5U rfmode=0
XM_548 n1144 n1145 AVDD AVDD sg13_lv_pmos L=0.13U W=0.84U AS=0.1918P AD=0.1596P PS=1.5U PD=1.22U rfmode=0
XM_549 AVDD n1146 n1144 AVDD sg13_lv_pmos L=0.13U W=0.84U AS=0.1596P AD=0.2856P PS=1.22U PD=2.36U rfmode=0
XM_550 n1220 n1020 n1145 AVDD sg13_lv_pmos L=0.13U W=1.12U AS=0.3808P AD=0.1176P PS=2.92U PD=1.33U rfmode=0
XM_551 AVDD n1021 n1220 AVDD sg13_lv_pmos L=0.13U W=1.12U AS=0.1176P AD=0.4032P PS=1.33U PD=2.96U rfmode=0
XM_552 n1219 n1022 n1146 AVDD sg13_lv_pmos L=0.13U W=1.12U AS=0.3808P AD=0.2128P PS=2.92U PD=1.5U rfmode=0
XM_553 n1218 n1023 n1219 AVDD sg13_lv_pmos L=0.13U W=1.12U AS=0.2128P AD=0.2464P PS=1.5U PD=1.56U rfmode=0
XM_554 AVDD n1014 n1218 AVDD sg13_lv_pmos L=0.13U W=1.12U AS=0.2464P AD=0.3808P PS=1.56U PD=2.92U rfmode=0
XM_555 n1238 VINN n1422 AVDD sg13_lv_pmos L=3U W=5U AS=1.7P AD=0.95P PS=10.68U PD=5.38U rfmode=0
XM_556 n1422 VINN n1238 AVDD sg13_lv_pmos L=3U W=5U AS=0.95P AD=0.95P PS=5.38U PD=5.38U rfmode=0
XM_557 n1238 VINN n1422 AVDD sg13_lv_pmos L=3U W=5U AS=0.95P AD=0.95P PS=5.38U PD=5.38U rfmode=0
XM_558 n1422 VINN n1238 AVDD sg13_lv_pmos L=3U W=5U AS=0.95P AD=1.7P PS=5.38U PD=10.68U rfmode=0
XM_559 n1230 n1231 n1422 AVDD sg13_lv_pmos L=3U W=5U AS=1.7P AD=0.95P PS=10.68U PD=5.38U rfmode=0
XM_560 n1422 n1231 n1230 AVDD sg13_lv_pmos L=3U W=5U AS=0.95P AD=0.95P PS=5.38U PD=5.38U rfmode=0
XM_561 n1230 n1231 n1422 AVDD sg13_lv_pmos L=3U W=5U AS=0.95P AD=0.95P PS=5.38U PD=5.38U rfmode=0
XM_562 n1422 n1231 n1230 AVDD sg13_lv_pmos L=3U W=5U AS=0.95P AD=1.7P PS=5.38U PD=10.68U rfmode=0
XM_563 n1245 n1245 AVDD AVDD sg13_lv_pmos L=2U W=2U AS=0.68P AD=0.68P PS=4.68U PD=4.68U rfmode=0
XM_564 n1426 n1245 AVDD AVDD sg13_lv_pmos L=2U W=2U AS=0.68P AD=0.68P PS=4.68U PD=4.68U rfmode=0
XM_565 n133 n1245 AVDD AVDD sg13_lv_pmos L=2U W=2U AS=0.68P AD=0.68P PS=4.68U PD=4.68U rfmode=0
XM_566 n1245 n1245 AVDD AVDD sg13_lv_pmos L=2U W=2U AS=0.68P AD=0.68P PS=4.68U PD=4.68U rfmode=0
XM_567 n1426 n1245 AVDD AVDD sg13_lv_pmos L=2U W=2U AS=0.68P AD=0.68P PS=4.68U PD=4.68U rfmode=0
XM_568 n133 n1245 AVDD AVDD sg13_lv_pmos L=2U W=2U AS=0.68P AD=0.68P PS=4.68U PD=4.68U rfmode=0
XM_569 n1245 n1245 AVDD AVDD sg13_lv_pmos L=2U W=2U AS=0.68P AD=0.68P PS=4.68U PD=4.68U rfmode=0
XM_570 n1426 n1245 AVDD AVDD sg13_lv_pmos L=2U W=2U AS=0.68P AD=0.68P PS=4.68U PD=4.68U rfmode=0
XM_571 n133 n1245 AVDD AVDD sg13_lv_pmos L=2U W=2U AS=0.68P AD=0.68P PS=4.68U PD=4.68U rfmode=0
XM_572 n1245 n1245 AVDD AVDD sg13_lv_pmos L=2U W=2U AS=0.68P AD=0.68P PS=4.68U PD=4.68U rfmode=0
XM_573 n1426 n1245 AVDD AVDD sg13_lv_pmos L=2U W=2U AS=0.68P AD=0.68P PS=4.68U PD=4.68U rfmode=0
XM_574 n133 n1245 AVDD AVDD sg13_lv_pmos L=2U W=2U AS=0.68P AD=0.68P PS=4.68U PD=4.68U rfmode=0
XM_575 n1245 n1245 AVDD AVDD sg13_lv_pmos L=2U W=2U AS=0.68P AD=0.68P PS=4.68U PD=4.68U rfmode=0
XM_576 n1426 n1245 AVDD AVDD sg13_lv_pmos L=2U W=2U AS=0.68P AD=0.68P PS=4.68U PD=4.68U rfmode=0
XM_577 n133 n1245 AVDD AVDD sg13_lv_pmos L=2U W=2U AS=0.68P AD=0.68P PS=4.68U PD=4.68U rfmode=0
XM_578 n1245 n1245 AVDD AVDD sg13_lv_pmos L=2U W=2U AS=0.68P AD=0.68P PS=4.68U PD=4.68U rfmode=0
XM_579 n1426 n1245 AVDD AVDD sg13_lv_pmos L=2U W=2U AS=0.68P AD=0.68P PS=4.68U PD=4.68U rfmode=0
XM_580 n133 n1245 AVDD AVDD sg13_lv_pmos L=2U W=2U AS=0.68P AD=0.68P PS=4.68U PD=4.68U rfmode=0
XM_581 n1245 n1245 AVDD AVDD sg13_lv_pmos L=2U W=2U AS=0.68P AD=0.68P PS=4.68U PD=4.68U rfmode=0
XM_582 n1426 n1245 AVDD AVDD sg13_lv_pmos L=2U W=2U AS=0.68P AD=0.68P PS=4.68U PD=4.68U rfmode=0
XM_583 n133 n1245 AVDD AVDD sg13_lv_pmos L=2U W=2U AS=0.68P AD=0.68P PS=4.68U PD=4.68U rfmode=0
XM_584 n1245 n1245 AVDD AVDD sg13_lv_pmos L=2U W=2U AS=0.68P AD=0.68P PS=4.68U PD=4.68U rfmode=0
XM_585 n1426 n1245 AVDD AVDD sg13_lv_pmos L=2U W=2U AS=0.68P AD=0.68P PS=4.68U PD=4.68U rfmode=0
XM_586 n133 n1245 AVDD AVDD sg13_lv_pmos L=2U W=2U AS=0.68P AD=0.68P PS=4.68U PD=4.68U rfmode=0
XM_587 n1245 n1245 AVDD AVDD sg13_lv_pmos L=2U W=2U AS=0.68P AD=0.68P PS=4.68U PD=4.68U rfmode=0
XM_588 n1426 n1245 AVDD AVDD sg13_lv_pmos L=2U W=2U AS=0.68P AD=0.68P PS=4.68U PD=4.68U rfmode=0
XM_589 n133 n1245 AVDD AVDD sg13_lv_pmos L=2U W=2U AS=0.68P AD=0.68P PS=4.68U PD=4.68U rfmode=0
XM_590 n1245 n1245 AVDD AVDD sg13_lv_pmos L=2U W=2U AS=0.68P AD=0.68P PS=4.68U PD=4.68U rfmode=0
XM_591 AVDD n1243 n1237 AVDD sg13_lv_pmos L=0.15U W=0.15U AS=0.1005P AD=0.1545P PS=1.34U PD=1.7U rfmode=0
XM_592 AVDD n1243 n1237 AVDD sg13_lv_pmos L=0.15U W=0.15U AS=0.1005P AD=0.1545P PS=1.34U PD=1.7U rfmode=0
XM_593 AVDD n1243 n1237 AVDD sg13_lv_pmos L=0.15U W=0.15U AS=0.1005P AD=0.1545P PS=1.34U PD=1.7U rfmode=0
XM_594 AVDD n1243 n1237 AVDD sg13_lv_pmos L=0.15U W=0.15U AS=0.1005P AD=0.1545P PS=1.34U PD=1.7U rfmode=0
XM_595 AVDD n1243 n1237 AVDD sg13_lv_pmos L=0.15U W=0.15U AS=0.1005P AD=0.1545P PS=1.34U PD=1.7U rfmode=0
XM_596 AVDD n1243 n1237 AVDD sg13_lv_pmos L=0.15U W=0.15U AS=0.1005P AD=0.1545P PS=1.34U PD=1.7U rfmode=0
XM_597 AVDD n1243 n1237 AVDD sg13_lv_pmos L=0.15U W=0.15U AS=0.1005P AD=0.1545P PS=1.34U PD=1.7U rfmode=0
XM_598 AVDD n1243 n1237 AVDD sg13_lv_pmos L=0.15U W=0.15U AS=0.1005P AD=0.1545P PS=1.34U PD=1.7U rfmode=0
XM_599 AVDD n1243 n1422 AVDD sg13_lv_pmos L=0.15U W=0.15U AS=0.1005P AD=0.1545P PS=1.34U PD=1.7U rfmode=0
XM_600 AVDD n1243 n1422 AVDD sg13_lv_pmos L=0.15U W=0.15U AS=0.1005P AD=0.1545P PS=1.34U PD=1.7U rfmode=0
XM_601 AVDD n1243 n1422 AVDD sg13_lv_pmos L=0.15U W=0.15U AS=0.1005P AD=0.1545P PS=1.34U PD=1.7U rfmode=0
XM_602 AVDD n1243 n1422 AVDD sg13_lv_pmos L=0.15U W=0.15U AS=0.1005P AD=0.1545P PS=1.34U PD=1.7U rfmode=0
XM_603 AVDD n1243 n1243 AVDD sg13_lv_pmos L=0.15U W=0.15U AS=0.1005P AD=0.1545P PS=1.34U PD=1.7U rfmode=0
XM_604 AVDD n1706 n1599 AVDD sg13_lv_pmos L=2U W=9.21U AS=3.1314P AD=3.1314P PS=19.1U PD=19.1U rfmode=0
XM_605 AVDD n1706 n1706 AVDD sg13_lv_pmos L=2U W=2.3U AS=0.782P AD=0.782P PS=5.28U PD=5.28U rfmode=0
XM_606 n1698 n1654 n1654 AVDD sg13_lv_pmos L=0.5U W=2.2U AS=0.748P AD=0.748P PS=5.08U PD=5.08U rfmode=0
XM_607 AVDD n1698 n1698 AVDD sg13_lv_pmos L=0.5U W=5.55U AS=1.887P AD=1.887P PS=11.78U PD=11.78U rfmode=0
XM_608 n1580 n1706 AVDD AVDD sg13_lv_pmos L=2U W=5.75U AS=1.955P AD=1.0925P PS=12.18U PD=6.13U rfmode=0
XM_609 AVDD n1706 n1580 AVDD sg13_lv_pmos L=2U W=5.75U AS=1.0925P AD=1.0925P PS=6.13U PD=6.13U rfmode=0
XM_610 n1580 n1706 AVDD AVDD sg13_lv_pmos L=2U W=5.75U AS=1.0925P AD=1.0925P PS=6.13U PD=6.13U rfmode=0
XM_611 AVDD n1706 n1580 AVDD sg13_lv_pmos L=2U W=5.75U AS=1.0925P AD=1.955P PS=6.13U PD=12.18U rfmode=0
XM_612 n1588 VCM n1695 AVDD sg13_lv_pmos L=2U W=6.64U AS=2.2576P AD=1.2616P PS=13.96U PD=7.02U rfmode=0
XM_613 n1695 VCM n1588 AVDD sg13_lv_pmos L=2U W=6.64U AS=1.2616P AD=1.2616P PS=7.02U PD=7.02U rfmode=0
XM_614 n1588 VCM n1695 AVDD sg13_lv_pmos L=2U W=6.64U AS=1.2616P AD=1.2616P PS=7.02U PD=7.02U rfmode=0
XM_615 n1695 VCM n1588 AVDD sg13_lv_pmos L=2U W=6.64U AS=1.2616P AD=2.2576P PS=7.02U PD=13.96U rfmode=0
XM_616 AVDD n1645 n1599 AVDD sg13_lv_pmos L=2U W=7.33U AS=2.4922P AD=2.4922P PS=15.34U PD=15.34U rfmode=0
XM_617 AVDD n1645 n1645 AVDD sg13_lv_pmos L=2U W=7.33U AS=2.4922P AD=2.4922P PS=15.34U PD=15.34U rfmode=0
XM_618 n1667 n1599 AVDD AVDD sg13_lv_pmos L=0.5U W=5.55U AS=1.887P AD=1.0545P PS=11.78U PD=5.93U rfmode=0
XM_619 AVDD n1599 n1667 AVDD sg13_lv_pmos L=0.5U W=5.55U AS=1.0545P AD=1.0545P PS=5.93U PD=5.93U rfmode=0
XM_620 n1667 n1599 AVDD AVDD sg13_lv_pmos L=0.5U W=5.55U AS=1.0545P AD=1.0545P PS=5.93U PD=5.93U rfmode=0
XM_621 AVDD n1599 n1667 AVDD sg13_lv_pmos L=0.5U W=5.55U AS=1.0545P AD=1.887P PS=5.93U PD=11.78U rfmode=0
XM_622 n1579 n1706 AVDD AVDD sg13_lv_pmos L=2U W=5.75U AS=1.955P AD=1.0925P PS=12.18U PD=6.13U rfmode=0
XM_623 AVDD n1706 n1579 AVDD sg13_lv_pmos L=2U W=5.75U AS=1.0925P AD=1.955P PS=6.13U PD=12.18U rfmode=0
XM_624 n1599 n1654 n1623 AVDD sg13_lv_pmos L=0.5U W=2.2U AS=0.748P AD=0.748P PS=5.08U PD=5.08U rfmode=0
XM_625 AVDD n1768 n1768 AVDD sg13_lv_pmos L=2U W=7.46U AS=2.5364P AD=2.5364P PS=15.6U PD=15.6U rfmode=0
XM_626 AVDD n1768 n1768 AVDD sg13_lv_pmos L=2U W=7.46U AS=2.5364P AD=2.5364P PS=15.6U PD=15.6U rfmode=0
XM_627 AVDD n1768 n1768 AVDD sg13_lv_pmos L=2U W=7.46U AS=2.5364P AD=2.5364P PS=15.6U PD=15.6U rfmode=0
XM_628 AVDD n1706 n1748 AVDD sg13_lv_pmos L=2U W=4.6U AS=1.564P AD=1.564P PS=9.88U PD=9.88U rfmode=0
XM_629 AVDD n1768 n1768 AVDD sg13_lv_pmos L=2U W=7.46U AS=2.5364P AD=2.5364P PS=15.6U PD=15.6U rfmode=0
XM_630 AVDD n1768 n1768 AVDD sg13_lv_pmos L=2U W=7.46U AS=2.5364P AD=2.5364P PS=15.6U PD=15.6U rfmode=0
XM_631 AVDD n1768 n1768 AVDD sg13_lv_pmos L=2U W=7.46U AS=2.5364P AD=2.5364P PS=15.6U PD=15.6U rfmode=0
XM_632 AVDD n1768 n1768 AVDD sg13_lv_pmos L=2U W=7.46U AS=2.5364P AD=2.5364P PS=15.6U PD=15.6U rfmode=0
XM_633 AVDD n1768 n1768 AVDD sg13_lv_pmos L=2U W=7.46U AS=2.5364P AD=2.5364P PS=15.6U PD=15.6U rfmode=0
XM_634 n1581 n1766 n1695 AVDD sg13_lv_pmos L=2U W=6.64U AS=2.2576P AD=1.2616P PS=13.96U PD=7.02U rfmode=0
XM_635 n1695 n1766 n1581 AVDD sg13_lv_pmos L=2U W=6.64U AS=1.2616P AD=1.2616P PS=7.02U PD=7.02U rfmode=0
XM_636 n1581 n1766 n1695 AVDD sg13_lv_pmos L=2U W=6.64U AS=1.2616P AD=1.2616P PS=7.02U PD=7.02U rfmode=0
XM_637 n1695 n1766 n1581 AVDD sg13_lv_pmos L=2U W=6.64U AS=1.2616P AD=2.2576P PS=7.02U PD=13.96U rfmode=0
XM_638 AVDD n1768 n1695 AVDD sg13_lv_pmos L=2U W=7.46U AS=2.5364P AD=2.5364P PS=15.6U PD=15.6U rfmode=0
XM_639 AVDD n1768 n1695 AVDD sg13_lv_pmos L=2U W=7.46U AS=2.5364P AD=2.5364P PS=15.6U PD=15.6U rfmode=0
XM_640 AVDD n1768 n1695 AVDD sg13_lv_pmos L=2U W=7.46U AS=2.5364P AD=2.5364P PS=15.6U PD=15.6U rfmode=0
XM_641 AVDD n1768 n1695 AVDD sg13_lv_pmos L=2U W=7.46U AS=2.5364P AD=2.5364P PS=15.6U PD=15.6U rfmode=0
XM_642 AVDD n1768 n1695 AVDD sg13_lv_pmos L=2U W=7.46U AS=2.5364P AD=2.5364P PS=15.6U PD=15.6U rfmode=0
XM_643 AVDD n1768 n1695 AVDD sg13_lv_pmos L=2U W=7.46U AS=2.5364P AD=2.5364P PS=15.6U PD=15.6U rfmode=0
XM_644 AVDD n1768 n1695 AVDD sg13_lv_pmos L=2U W=7.46U AS=2.5364P AD=2.5364P PS=15.6U PD=15.6U rfmode=0
XM_645 AVDD n1768 n1695 AVDD sg13_lv_pmos L=2U W=7.46U AS=2.5364P AD=2.5364P PS=15.6U PD=15.6U rfmode=0
XM_646 n2037 n1851 n1766 AVDD sg13_lv_pmos L=0.13U W=1.2U AS=0.408P AD=0.408P PS=3.08U PD=3.08U rfmode=0
XM_647 n1851 n1859 AVDD AVDD sg13_lv_pmos L=0.13U W=1.12U AS=0.3808P AD=0.3808P PS=2.92U PD=2.92U rfmode=0
XM_648 n2038 n1852 n1766 AVDD sg13_lv_pmos L=0.13U W=0.9U AS=0.306P AD=0.306P PS=2.48U PD=2.48U rfmode=0
XM_649 n1852 n826 AVDD AVDD sg13_lv_pmos L=0.13U W=1.12U AS=0.3808P AD=0.3808P PS=2.92U PD=2.92U rfmode=0
XM_650 n2039 n1853 n1766 AVDD sg13_lv_pmos L=0.13U W=0.6U AS=0.204P AD=0.204P PS=1.88U PD=1.88U rfmode=0
XM_651 n1853 n996 AVDD AVDD sg13_lv_pmos L=0.13U W=1.12U AS=0.3808P AD=0.3808P PS=2.92U PD=2.92U rfmode=0
XM_652 n2040 n1854 n1766 AVDD sg13_lv_pmos L=0.13U W=0.54U AS=0.1836P AD=0.1836P PS=1.76U PD=1.76U rfmode=0
XM_653 n1854 n976 AVDD AVDD sg13_lv_pmos L=0.13U W=1.12U AS=0.3808P AD=0.3808P PS=2.92U PD=2.92U rfmode=0
XM_654 n2041 n1855 n1766 AVDD sg13_lv_pmos L=0.13U W=0.54U AS=0.1836P AD=0.1836P PS=1.76U PD=1.76U rfmode=0
XM_655 n1855 n677 AVDD AVDD sg13_lv_pmos L=0.13U W=1.12U AS=0.3808P AD=0.3808P PS=2.92U PD=2.92U rfmode=0
XM_656 n2042 n1856 n1766 AVDD sg13_lv_pmos L=0.13U W=0.54U AS=0.1836P AD=0.1836P PS=1.76U PD=1.76U rfmode=0
XM_657 n1856 n979 AVDD AVDD sg13_lv_pmos L=0.13U W=1.12U AS=0.3808P AD=0.3808P PS=2.92U PD=2.92U rfmode=0
XM_658 n1842 VOUT n2057 AVDD sg13_lv_pmos L=3U W=5U AS=1.7P AD=0.95P PS=10.68U PD=5.38U rfmode=0
XM_659 n2057 VOUT n1842 AVDD sg13_lv_pmos L=3U W=5U AS=0.95P AD=0.95P PS=5.38U PD=5.38U rfmode=0
XM_660 n1842 VOUT n2057 AVDD sg13_lv_pmos L=3U W=5U AS=0.95P AD=0.95P PS=5.38U PD=5.38U rfmode=0
XM_661 n2057 VOUT n1842 AVDD sg13_lv_pmos L=3U W=5U AS=0.95P AD=1.7P PS=5.38U PD=10.68U rfmode=0
XM_662 n1843 n1667 n2057 AVDD sg13_lv_pmos L=3U W=5U AS=1.7P AD=0.95P PS=10.68U PD=5.38U rfmode=0
XM_663 n2057 n1667 n1843 AVDD sg13_lv_pmos L=3U W=5U AS=0.95P AD=0.95P PS=5.38U PD=5.38U rfmode=0
XM_664 n1843 n1667 n2057 AVDD sg13_lv_pmos L=3U W=5U AS=0.95P AD=0.95P PS=5.38U PD=5.38U rfmode=0
XM_665 n2057 n1667 n1843 AVDD sg13_lv_pmos L=3U W=5U AS=0.95P AD=1.7P PS=5.38U PD=10.68U rfmode=0
XM_666 AVDD n1246 n1246 AVDD sg13_lv_pmos L=0.15U W=0.15U AS=0.1005P AD=0.1545P PS=1.34U PD=1.7U rfmode=0
XM_667 AVDD n1246 n2057 AVDD sg13_lv_pmos L=0.15U W=0.15U AS=0.1005P AD=0.1545P PS=1.34U PD=1.7U rfmode=0
XM_668 AVDD n1246 n2057 AVDD sg13_lv_pmos L=0.15U W=0.15U AS=0.1005P AD=0.1545P PS=1.34U PD=1.7U rfmode=0
XM_669 AVDD n1246 n2057 AVDD sg13_lv_pmos L=0.15U W=0.15U AS=0.1005P AD=0.1545P PS=1.34U PD=1.7U rfmode=0
XM_670 AVDD n1246 n2057 AVDD sg13_lv_pmos L=0.15U W=0.15U AS=0.1005P AD=0.1545P PS=1.34U PD=1.7U rfmode=0
XM_671 AVDD n1246 VOUT AVDD sg13_lv_pmos L=0.15U W=0.15U AS=0.1005P AD=0.1545P PS=1.34U PD=1.7U rfmode=0
XM_672 AVDD n1246 VOUT AVDD sg13_lv_pmos L=0.15U W=0.15U AS=0.1005P AD=0.1545P PS=1.34U PD=1.7U rfmode=0
XM_673 AVDD n1246 VOUT AVDD sg13_lv_pmos L=0.15U W=0.15U AS=0.1005P AD=0.1545P PS=1.34U PD=1.7U rfmode=0
XM_674 AVDD n1246 VOUT AVDD sg13_lv_pmos L=0.15U W=0.15U AS=0.1005P AD=0.1545P PS=1.34U PD=1.7U rfmode=0
XM_675 AVDD n1246 VOUT AVDD sg13_lv_pmos L=0.15U W=0.15U AS=0.1005P AD=0.1545P PS=1.34U PD=1.7U rfmode=0
XM_676 AVDD n1246 VOUT AVDD sg13_lv_pmos L=0.15U W=0.15U AS=0.1005P AD=0.1545P PS=1.34U PD=1.7U rfmode=0
XM_677 AVDD n1246 VOUT AVDD sg13_lv_pmos L=0.15U W=0.15U AS=0.1005P AD=0.1545P PS=1.34U PD=1.7U rfmode=0
XM_678 AVDD n1246 VOUT AVDD sg13_lv_pmos L=0.15U W=0.15U AS=0.1005P AD=0.1545P PS=1.34U PD=1.7U rfmode=0
XM_679 n2086 n826 AVDD AVDD sg13_lv_pmos L=0.13U W=1.12U AS=0.3808P AD=0.2464P PS=2.92U PD=1.56U rfmode=0
XM_680 n2085 n996 n2086 AVDD sg13_lv_pmos L=0.13U W=1.12U AS=0.2464P AD=0.2128P PS=1.56U PD=1.5U rfmode=0
XM_681 n2074 n976 n2085 AVDD sg13_lv_pmos L=0.13U W=1.12U AS=0.2128P AD=0.3808P PS=1.5U PD=2.92U rfmode=0
XM_682 n2087 n677 AVDD AVDD sg13_lv_pmos L=0.13U W=1.12U AS=0.4032P AD=0.1176P PS=2.96U PD=1.33U rfmode=0
XM_683 n2075 n979 n2087 AVDD sg13_lv_pmos L=0.13U W=1.12U AS=0.1176P AD=0.3808P PS=1.33U PD=2.92U rfmode=0
XM_684 n2079 n2074 AVDD AVDD sg13_lv_pmos L=0.13U W=0.84U AS=0.2856P AD=0.1596P PS=2.36U PD=1.22U rfmode=0
XM_685 n2079 n2075 AVDD AVDD sg13_lv_pmos L=0.13U W=0.84U AS=0.1918P AD=0.1596P PS=1.5U PD=1.22U rfmode=0
XM_686 n1859 n2079 AVDD AVDD sg13_lv_pmos L=0.13U W=1.12U AS=0.1918P AD=0.3808P PS=1.5U PD=2.92U rfmode=0
XD_687 AVSS n979 dantenna w=0.78u l=0.78u
XD_688 AVSS n1020 dantenna w=0.78u l=0.78u
XR_689 n96 n240 AVSS rhigh w=0.5u l=2.0u ps=0 b=0 m=1
XR_690 n10 AVSS AVSS rhigh w=0.5u l=15.0u ps=0 b=0 m=1
XR_691 n654 n96 AVSS rhigh w=0.5u l=2.0u ps=0 b=0 m=1
XR_692 n8 n119 AVSS rhigh w=0.5u l=4.0u ps=0 b=0 m=1
XR_693 n98 n6 AVSS rhigh w=0.5u l=1.95u ps=0 b=0 m=1
XR_694 n654 VCM AVSS rhigh w=0.5u l=17.84u ps=0 b=0 m=1
XR_695 n517 n1026 AVSS rhigh w=0.5u l=6.66u ps=0 b=0 m=1
XR_696 n512 n624 AVSS rhigh w=0.5u l=1.95u ps=0 b=0 m=1
XR_697 n359 n1048 AVSS rhigh w=0.5u l=3.2u ps=0 b=0 m=1
XR_698 n517 n655 AVSS rhigh w=0.5u l=17.84u ps=0 b=0 m=1
XR_699 n1045 n1046 AVSS rhigh w=0.5u l=26.95u ps=0 b=0 m=1
XR_700 n1046 n1047 AVSS rhigh w=0.5u l=13.42u ps=0 b=0 m=1
XR_701 n1047 n1048 AVSS rhigh w=0.5u l=6.66u ps=0 b=0 m=1
XR_702 n1043 n1139 AVSS rhigh w=0.5u l=54.0u ps=0 b=0 m=1
XR_703 n1044 n1139 AVSS rhigh w=0.5u l=54.0u ps=0 b=0 m=1
XR_704 n1044 n1045 AVSS rhigh w=0.5u l=54.0u ps=0 b=0 m=1
XR_705 n1237 n1231 AVSS rhigh w=0.5u l=2.0u ps=0 b=0 m=1
XR_706 n655 n1237 AVSS rhigh w=0.5u l=2.0u ps=0 b=0 m=1
XR_707 n1238 n1151 AVSS rhigh w=0.5u l=1.95u ps=0 b=0 m=1
XR_708 n1540 AVSS AVSS rhigh w=0.5u l=15.0u ps=0 b=0 m=1
XR_709 n1542 n1599 AVSS rhigh w=0.5u l=4.0u ps=0 b=0 m=1
XR_710 n359 n1766 AVSS rhigh w=0.5u l=6.66u ps=0 b=0 m=1
XR_711 n1667 n2037 AVSS rhigh w=0.5u l=3.2u ps=0 b=0 m=1
XR_712 n2037 n2038 AVSS rhigh w=0.5u l=6.66u ps=0 b=0 m=1
XR_713 n2038 n2039 AVSS rhigh w=0.5u l=13.42u ps=0 b=0 m=1
XR_714 n2039 n2040 AVSS rhigh w=0.5u l=26.95u ps=0 b=0 m=1
XR_715 n2040 n2041 AVSS rhigh w=0.5u l=54.0u ps=0 b=0 m=1
XR_716 n2068 n2041 AVSS rhigh w=0.5u l=54.0u ps=0 b=0 m=1
XR_717 n1843 n1770 AVSS rhigh w=0.5u l=1.95u ps=0 b=0 m=1
XR_718 n2068 n2042 AVSS rhigh w=0.5u l=54.0u ps=0 b=0 m=1
XC_719 n6 n96 cap_cmomi w=15e-6 l=15e-6 mmin=1 mmax=4 feed=double subblock=0 m=1
XC_720 n6 n96 cap_cmomi w=15e-6 l=15e-6 mmin=1 mmax=4 feed=double subblock=0 m=1
XC_721 n6 n96 cap_cmomi w=15e-6 l=15e-6 mmin=1 mmax=4 feed=double subblock=0 m=1
XC_722 n6 n96 cap_cmomi w=15e-6 l=15e-6 mmin=1 mmax=4 feed=double subblock=0 m=1
XC_723 n359 n8 cap_cmomi w=15e-6 l=15e-6 mmin=1 mmax=4 feed=double subblock=0 m=1
XC_724 n359 n8 cap_cmomi w=15e-6 l=15e-6 mmin=1 mmax=4 feed=double subblock=0 m=1
XC_725 n359 n8 cap_cmomi w=15e-6 l=15e-6 mmin=1 mmax=4 feed=double subblock=0 m=1
XC_726 n359 n8 cap_cmomi w=15e-6 l=15e-6 mmin=1 mmax=4 feed=double subblock=0 m=1
XC_727 n96 n6 cap_cmomi w=15e-6 l=15e-6 mmin=1 mmax=4 feed=double subblock=0 m=1
XC_728 n96 n6 cap_cmomi w=15e-6 l=15e-6 mmin=1 mmax=4 feed=double subblock=0 m=1
XC_729 n96 n6 cap_cmomi w=15e-6 l=15e-6 mmin=1 mmax=4 feed=double subblock=0 m=1
XC_730 n96 n6 cap_cmomi w=15e-6 l=15e-6 mmin=1 mmax=4 feed=double subblock=0 m=1
XC_731 n96 n6 cap_cmomi w=15e-6 l=15e-6 mmin=1 mmax=4 feed=double subblock=0 m=1
XC_732 n359 n132 cap_cmomi w=15e-6 l=15e-6 mmin=1 mmax=4 feed=double subblock=0 m=1
XC_733 n512 n517 cap_cmomi w=15e-6 l=15e-6 mmin=1 mmax=4 feed=double subblock=0 m=1
XC_734 n512 n517 cap_cmomi w=15e-6 l=15e-6 mmin=1 mmax=4 feed=double subblock=0 m=1
XC_735 n512 n517 cap_cmomi w=15e-6 l=15e-6 mmin=1 mmax=4 feed=double subblock=0 m=1
XC_736 n512 n517 cap_cmomi w=15e-6 l=15e-6 mmin=1 mmax=4 feed=double subblock=0 m=1
XC_737 n512 n517 cap_cmomi w=15e-6 l=15e-6 mmin=1 mmax=4 feed=double subblock=0 m=1
XC_738 n517 n512 cap_cmomi w=15e-6 l=15e-6 mmin=1 mmax=4 feed=double subblock=0 m=1
XC_739 n517 n512 cap_cmomi w=15e-6 l=15e-6 mmin=1 mmax=4 feed=double subblock=0 m=1
XC_740 n517 n512 cap_cmomi w=15e-6 l=15e-6 mmin=1 mmax=4 feed=double subblock=0 m=1
XC_741 n517 n512 cap_cmomi w=15e-6 l=15e-6 mmin=1 mmax=4 feed=double subblock=0 m=1
XC_742 n1151 n1237 cap_cmomi w=15e-6 l=15e-6 mmin=1 mmax=4 feed=double subblock=0 m=1
XC_743 n1151 n1237 cap_cmomi w=15e-6 l=15e-6 mmin=1 mmax=4 feed=double subblock=0 m=1
XC_744 n1151 n1237 cap_cmomi w=15e-6 l=15e-6 mmin=1 mmax=4 feed=double subblock=0 m=1
XC_745 n1151 n1237 cap_cmomi w=15e-6 l=15e-6 mmin=1 mmax=4 feed=double subblock=0 m=1
XC_746 n1237 n1151 cap_cmomi w=15e-6 l=15e-6 mmin=1 mmax=4 feed=double subblock=0 m=1
XC_747 n1237 n1151 cap_cmomi w=15e-6 l=15e-6 mmin=1 mmax=4 feed=double subblock=0 m=1
XC_748 n1237 n1151 cap_cmomi w=15e-6 l=15e-6 mmin=1 mmax=4 feed=double subblock=0 m=1
XC_749 n1237 n1151 cap_cmomi w=15e-6 l=15e-6 mmin=1 mmax=4 feed=double subblock=0 m=1
XC_750 n1237 n1151 cap_cmomi w=15e-6 l=15e-6 mmin=1 mmax=4 feed=double subblock=0 m=1
XC_751 n1542 n1667 cap_cmomi w=15e-6 l=15e-6 mmin=1 mmax=4 feed=double subblock=0 m=1
XC_752 n1542 n1667 cap_cmomi w=15e-6 l=15e-6 mmin=1 mmax=4 feed=double subblock=0 m=1
XC_753 n1542 n1667 cap_cmomi w=15e-6 l=15e-6 mmin=1 mmax=4 feed=double subblock=0 m=1
XC_754 n1542 n1667 cap_cmomi w=15e-6 l=15e-6 mmin=1 mmax=4 feed=double subblock=0 m=1
XC_755 n1588 n1667 cap_cmomi w=15e-6 l=15e-6 mmin=1 mmax=4 feed=double subblock=0 m=1
XC_756 n1770 VOUT cap_cmomi w=15e-6 l=15e-6 mmin=1 mmax=4 feed=double subblock=0 m=1
XC_757 n1770 VOUT cap_cmomi w=15e-6 l=15e-6 mmin=1 mmax=4 feed=double subblock=0 m=1
XC_758 n1770 VOUT cap_cmomi w=15e-6 l=15e-6 mmin=1 mmax=4 feed=double subblock=0 m=1
XC_759 n1770 VOUT cap_cmomi w=15e-6 l=15e-6 mmin=1 mmax=4 feed=double subblock=0 m=1
XC_760 VOUT n1770 cap_cmomi w=15e-6 l=15e-6 mmin=1 mmax=4 feed=double subblock=0 m=1
XC_761 VOUT n1770 cap_cmomi w=15e-6 l=15e-6 mmin=1 mmax=4 feed=double subblock=0 m=1
XC_762 VOUT n1770 cap_cmomi w=15e-6 l=15e-6 mmin=1 mmax=4 feed=double subblock=0 m=1
XC_763 VOUT n1770 cap_cmomi w=15e-6 l=15e-6 mmin=1 mmax=4 feed=double subblock=0 m=1
XC_764 VOUT n1770 cap_cmomi w=15e-6 l=15e-6 mmin=1 mmax=4 feed=double subblock=0 m=1
Cext_1 n10 n110 31.7384a
Cext_2 n10 n111 716.628a
Cext_3 n10 n133 0.100778a
Cext_4 n10 n93 3.38527a
Cext_5 n10 AVSS 961.281a
Cext_6 n10 AVSS 1.8725f
Cext_7 n1001 n664 2.08773a
Cext_8 n1001 n665 15.5012a
Cext_9 n1001 n692 23.0386a
Cext_10 n1001 n706 0.561186a
Cext_11 n1001 n715 0.0584444a
Cext_12 n1001 n816 0.182808a
Cext_13 n1001 n818 6.37138a
Cext_14 n1001 AVSS 6.61145a
Cext_15 n1001 VGND 25.8485a
Cext_16 n1001 VPWR 22.0055a
Cext_17 n1001 AVSS 206.497a
Cext_18 n1002 n668 0.993418a
Cext_19 n1002 n686 0.147473a
Cext_20 n1002 n706 17.8286a
Cext_21 n1002 n816 1.17892a
Cext_22 n1002 n818 0.109062a
Cext_23 n1002 n928 0.294494a
Cext_24 n1002 n965 1.20043a
Cext_25 n1002 AVSS 1.52775a
Cext_26 n1002 VGND 10.4265a
Cext_27 n1002 VPWR 20.6753a
Cext_28 n1002 AVSS 114.961a
Cext_29 n1004 n668 16.4824a
Cext_30 n1004 n687 0.844917a
Cext_31 n1004 n706 0.130708a
Cext_32 n1004 n816 1.75322a
Cext_33 n1004 n822 11.1778a
Cext_34 n1004 n839 0.450035a
Cext_35 n1004 n965 1.82039a
Cext_36 n1004 n967 11.0817a
Cext_37 n1004 n968 0.639482a
Cext_38 n1004 AVSS 1.77005a
Cext_39 n1004 VGND 1.79683a
Cext_40 n1004 VPWR 7.85598a
Cext_41 n1004 AVSS 119.033a
Cext_42 n1005 n672 3.36859a
Cext_43 n1005 n816 0.632046a
Cext_44 n1005 n819 15.2528a
Cext_45 n1005 n840 17.0781a
Cext_46 n1005 n967 1.05685a
Cext_47 n1005 n968 0.905787a
Cext_48 n1005 n969 1.05334a
Cext_49 n1005 n971 1.08988a
Cext_50 n1005 n973 5.64742a
Cext_51 n1005 AVSS 0.784525a
Cext_52 n1005 VGND 2.21484a
Cext_53 n1005 VPWR 7.62393a
Cext_54 n1005 AVSS 114.977a
Cext_55 n1009 n1020 81.6791a
Cext_56 n1009 n1026 16.0868a
Cext_57 n1009 n1043 18.7116a
Cext_58 n1009 n1044 8.57318a
Cext_59 n1009 n1048 1.97994a
Cext_60 n1009 AVDD 238.397a
Cext_61 n1009 AVSS 88.8779a
Cext_62 n1009 AVSS 887.611a
Cext_63 n1010 n1020 44.6356a
Cext_64 n1010 n1021 81.5561a
Cext_65 n1010 n1026 77.1806a
Cext_66 n1010 n1044 30.0348a
Cext_67 n1010 n1048 1.66542a
Cext_68 n1010 n653 0.614975a
Cext_69 n1010 AVDD 239.075a
Cext_70 n1010 AVSS 92.4463a
Cext_71 n1010 AVSS 823.906a
Cext_72 n1011 n1020 3.1237a
Cext_73 n1011 n1021 129.752a
Cext_74 n1011 n1022 86.9843a
Cext_75 n1011 n1026 70.9045a
Cext_76 n1011 n1045 11.1041a
Cext_77 n1011 n1048 1.97994a
Cext_78 n1011 n653 0.675214a
Cext_79 n1011 AVDD 234.188a
Cext_80 n1011 AVSS 88.8779a
Cext_81 n1011 AVSS 844.91a
Cext_82 n1012 n1020 0.909123a
Cext_83 n1012 n1021 18.2676a
Cext_84 n1012 n1022 52.8109a
Cext_85 n1012 n1023 90.778a
Cext_86 n1012 n1026 47.0633a
Cext_87 n1012 n1046 10.9248a
Cext_88 n1012 n1048 2.03175a
Cext_89 n1012 n653 0.878709a
Cext_90 n1012 AVDD 203.483a
Cext_91 n1012 AVSS 86.5386a
Cext_92 n1012 AVSS 922.032a
Cext_93 n1013 n1014 82.9931a
Cext_94 n1013 n1020 0.86383a
Cext_95 n1013 n1021 1.07025a
Cext_96 n1013 n1022 1.46697a
Cext_97 n1013 n1023 13.2536a
Cext_98 n1013 n1026 52.6685a
Cext_99 n1013 n1047 12.5716a
Cext_100 n1013 n1048 1.97174a
Cext_101 n1013 n653 1.55087a
Cext_102 n1013 AVDD 286.385a
Cext_103 n1013 AVSS 87.4602a
Cext_104 n1013 AVSS 879.633a
Cext_105 n1014 n1015 88.9916a
Cext_106 n1014 n1020 539.447a
Cext_107 n1014 n1021 209.941a
Cext_108 n1014 n1022 210.93a
Cext_109 n1014 n1023 3.35864f
Cext_110 n1014 n1024 616.968a
Cext_111 n1014 n1026 275.418a
Cext_112 n1014 n1043 10.0183a
Cext_113 n1014 n1044 25.2195a
Cext_114 n1014 n1045 18.7711a
Cext_115 n1014 n1047 17.8768a
Cext_116 n1014 n1048 20.1655a
Cext_117 n1014 n1139 5.2175a
Cext_118 n1014 n1144 14.0641a
Cext_119 n1014 n1145 27.6842a
Cext_120 n1014 n1146 174.471a
Cext_121 n1014 n359 86.9856a
Cext_122 n1014 n652 35.2057a
Cext_123 n1014 n653 53.1992a
Cext_124 n1014 n660 78.2716a
Cext_125 n1014 n669 4.29377a
Cext_126 n1014 n671 9.97514a
Cext_127 n1014 n684 2.34855a
Cext_128 n1014 n689 144.824a
Cext_129 n1014 n690 43.6168a
Cext_130 n1014 n692 0.557994a
Cext_131 n1014 n703 1.52162a
Cext_132 n1014 n965 52.2634a
Cext_133 n1014 AVDD 868.809a
Cext_134 n1014 AVSS 1.19124f
Cext_135 n1014 VGND 171.781a
Cext_136 n1014 VPWR 88.1647a
Cext_137 n1014 AVSS 19.7592f
Cext_138 n1015 n1020 0.881791a
Cext_139 n1015 n1021 1.09981a
Cext_140 n1015 n1022 1.51556a
Cext_141 n1015 n1023 6.31963a
Cext_142 n1015 n1024 86.8078a
Cext_143 n1015 n1026 86.3181a
Cext_144 n1015 n1047 2.59005a
Cext_145 n1015 n1048 23.2372a
Cext_146 n1015 n653 1.93763a
Cext_147 n1015 AVDD 216.479a
Cext_148 n1015 AVSS 85.3167a
Cext_149 n1015 AVSS 871.924a
Cext_150 n1020 n1021 9.3735f
Cext_151 n1020 n1022 222.481a
Cext_152 n1020 n1023 226.395a
Cext_153 n1020 n1024 939.513a
Cext_154 n1020 n1026 448.387a
Cext_155 n1020 n1043 104.485a
Cext_156 n1020 n1044 134.188a
Cext_157 n1020 n1045 267.521a
Cext_158 n1020 n1046 2.07367a
Cext_159 n1020 n1047 2.42328a
Cext_160 n1020 n1048 1.65916f
Cext_161 n1020 n1139 38.009a
Cext_162 n1020 n1144 0.708298a
Cext_163 n1020 n1145 186.969a
Cext_164 n1020 n1146 47.7026a
Cext_165 n1020 n1243 34.689a
Cext_166 n1020 n1245 5.94175a
Cext_167 n1020 n1246 74.6893a
Cext_168 n1020 n133 0.2267a
Cext_169 n1020 n359 81.16a
Cext_170 n1020 n652 159.087a
Cext_171 n1020 n660 28.9795a
Cext_172 n1020 n663 172.189a
Cext_173 n1020 n671 6.63486a
Cext_174 n1020 n672 0.356456a
Cext_175 n1020 n674 0.120569a
Cext_176 n1020 n684 11.1586a
Cext_177 n1020 n692 12.283a
Cext_178 n1020 n694 145.679a
Cext_179 n1020 n695 43.4773a
Cext_180 n1020 n703 0.271063a
Cext_181 n1020 n705 17.3901a
Cext_182 n1020 AVDD 469.799a
Cext_183 n1020 AVSS 1.56863f
Cext_184 n1020 IBIAS_IA 744.593a
Cext_185 n1020 VCM 63.7403a
Cext_186 n1020 VGND 173.735a
Cext_187 n1020 VPWR 88.1647a
Cext_188 n1020 AVSS 18.4164f
Cext_189 n1021 n1022 10.0073f
Cext_190 n1021 n1023 183.187a
Cext_191 n1021 n1024 181.908a
Cext_192 n1021 n1026 240.278a
Cext_193 n1021 n1044 8.02116a
Cext_194 n1021 n1045 14.2961a
Cext_195 n1021 n1046 3.48637a
Cext_196 n1021 n1047 3.22422a
Cext_197 n1021 n1048 105.63a
Cext_198 n1021 n1145 76.2579a
Cext_199 n1021 n1146 28.2293a
Cext_200 n1021 n1246 0.108771a
Cext_201 n1021 n359 74.8307a
Cext_202 n1021 n389 3.4374a
Cext_203 n1021 n652 42.3842a
Cext_204 n1021 n653 164.016a
Cext_205 n1021 n660 26.9176a
Cext_206 n1021 n671 34.5177a
Cext_207 n1021 n672 8.37578a
Cext_208 n1021 n684 7.07345a
Cext_209 n1021 n692 0.580911a
Cext_210 n1021 n693 146.024a
Cext_211 n1021 n694 43.6342a
Cext_212 n1021 n703 5.18169a
Cext_213 n1021 n705 0.242677a
Cext_214 n1021 n816 1.86468a
Cext_215 n1021 AVDD 716.759a
Cext_216 n1021 AVSS 1.85202f
Cext_217 n1021 IBIAS_IA 29.2146a
Cext_218 n1021 VCM 3.21611a
Cext_219 n1021 VGND 159.132a
Cext_220 n1021 VPWR 72.2109a
Cext_221 n1021 AVSS 11.3366f
Cext_222 n1022 n1023 8.92162f
Cext_223 n1022 n1024 127.927a
Cext_224 n1022 n1026 836.248a
Cext_225 n1022 n1043 0.140713a
Cext_226 n1022 n1045 34.7718a
Cext_227 n1022 n1046 19.6221a
Cext_228 n1022 n1047 4.42405a
Cext_229 n1022 n1048 220.163a
Cext_230 n1022 n1145 1.85914a
Cext_231 n1022 n1146 122.611a
Cext_232 n1022 n359 74.8307a
Cext_233 n1022 n652 48.2243a
Cext_234 n1022 n653 3.33186a
Cext_235 n1022 n660 26.9843a
Cext_236 n1022 n669 4.72463a
Cext_237 n1022 n671 11.3528a
Cext_238 n1022 n672 28.0793a
Cext_239 n1022 n684 5.46134a
Cext_240 n1022 n691 145.519a
Cext_241 n1022 n692 23.1411a
Cext_242 n1022 n703 6.42611a
Cext_243 n1022 n819 2.88744a
Cext_244 n1022 n837 0.293351a
Cext_245 n1022 AVDD 212.822a
Cext_246 n1022 AVSS 743.669a
Cext_247 n1022 IBIAS_IA 18.4461a
Cext_248 n1022 VCM 2.65986a
Cext_249 n1022 VGND 148.527a
Cext_250 n1022 VPWR 98.8423a
Cext_251 n1022 AVSS 10.7414f
Cext_252 n1023 n1024 128.227a
Cext_253 n1023 n1026 452.777a
Cext_254 n1023 n1043 0.210588a
Cext_255 n1023 n1046 32.6275a
Cext_256 n1023 n1047 19.8978a
Cext_257 n1023 n1048 769.463a
Cext_258 n1023 n1139 0.142805a
Cext_259 n1023 n1145 0.974491a
Cext_260 n1023 n1146 164.621a
Cext_261 n1023 n359 79.4776a
Cext_262 n1023 n652 34.7534a
Cext_263 n1023 n653 16.5748a
Cext_264 n1023 n660 26.0132a
Cext_265 n1023 n669 23.9799a
Cext_266 n1023 n671 9.82251a
Cext_267 n1023 n684 5.04057a
Cext_268 n1023 n690 145.052a
Cext_269 n1023 n691 43.6168a
Cext_270 n1023 n692 1.16696a
Cext_271 n1023 n703 5.25114a
Cext_272 n1023 n820 3.07574a
Cext_273 n1023 n965 4.83039a
Cext_274 n1023 AVDD 297.206a
Cext_275 n1023 AVSS 974.476a
Cext_276 n1023 IBIAS_IA 8.70912a
Cext_277 n1023 VGND 151.272a
Cext_278 n1023 VPWR 71.5712a
Cext_279 n1023 AVSS 12.445f
Cext_280 n1024 n1026 384.598a
Cext_281 n1024 n1048 54.0794a
Cext_282 n1024 n1144 87.3158a
Cext_283 n1024 n1145 25.6704a
Cext_284 n1024 n1146 19.9739a
Cext_285 n1024 AVDD 199.643a
Cext_286 n1024 AVSS 688.219a
Cext_287 n1024 AVSS 2.14183f
Cext_288 n1026 n1043 148.274a
Cext_289 n1026 n1044 255.194a
Cext_290 n1026 n1045 293.599a
Cext_291 n1026 n1046 290.662a
Cext_292 n1026 n1047 311.514a
Cext_293 n1026 n1048 901.315a
Cext_294 n1026 n111 20.7164a
Cext_295 n1026 n119 70.7607a
Cext_296 n1026 n344 325.257a
Cext_297 n1026 n345 3.26468a
Cext_298 n1026 n359 17.2982a
Cext_299 n1026 n389 2.01927f
Cext_300 n1026 n497 228.061a
Cext_301 n1026 n517 16.6244a
Cext_302 n1026 n653 548.194a
Cext_303 n1026 n93 2.41397f
Cext_304 n1026 AVDD 1.85078f
Cext_305 n1026 AVSS 951.734a
Cext_306 n1026 VCM 8.99176a
Cext_307 n1026 AVSS 17.4f
Cext_308 n1043 n1044 410.321a
Cext_309 n1043 n1048 2.15095f
Cext_310 n1043 n359 17.4428a
Cext_311 n1043 AVDD 7.40299a
Cext_312 n1043 AVSS 2.00532f
Cext_313 n1044 n1045 0.333949a
Cext_314 n1044 n1048 798.12a
Cext_315 n1044 n359 6.40233a
Cext_316 n1044 AVDD 4.99803a
Cext_317 n1044 AVSS 3.45672f
Cext_318 n1045 n1048 495.371a
Cext_319 n1045 n1139 14.5472a
Cext_320 n1045 AVDD 1.28109a
Cext_321 n1045 AVSS 0.837701a
Cext_322 n1045 AVSS 2.86459f
Cext_323 n1046 n1048 34.1024a
Cext_324 n1046 AVDD 2.02226a
Cext_325 n1046 AVSS 2.31301a
Cext_326 n1046 AVSS 717.103a
Cext_327 n1047 n1048 44.0818a
Cext_328 n1047 AVDD 8.61895a
Cext_329 n1047 AVSS 6.58361a
Cext_330 n1047 AVSS 750.764a
Cext_331 n1048 n1139 1.75293a
Cext_332 n1048 n1144 0.404319a
Cext_333 n1048 n1145 8.50653a
Cext_334 n1048 n1146 1.33751a
Cext_335 n1048 n359 25.7777a
Cext_336 n1048 AVDD 114.184a
Cext_337 n1048 AVSS 89.0363a
Cext_338 n1048 AVSS 6.70301f
Cext_339 n110 n111 206.568a
Cext_340 n110 n119 4.15771a
Cext_341 n110 n132 1.11539f
Cext_342 n110 n133 374.902a
Cext_343 n110 n236 1.35607a
Cext_344 n110 n238 15.7279a
Cext_345 n110 n344 36.1299a
Cext_346 n110 n345 188.755a
Cext_347 n110 n353 116.618a
Cext_348 n110 n359 20.7743a
Cext_349 n110 n390 5.39096a
Cext_350 n110 n497 1.90445f
Cext_351 n110 n653 24.2479a
Cext_352 n110 n93 1.12174f
Cext_353 n110 AVDD 385.934a
Cext_354 n110 AVSS 3.14794f
Cext_355 n110 VCM 51.9279a
Cext_356 n110 AVSS 11.1144f
Cext_357 n111 n119 842.841a
Cext_358 n111 n132 412.218a
Cext_359 n111 n133 188.635a
Cext_360 n111 n236 487.033a
Cext_361 n111 n344 66.3079a
Cext_362 n111 n345 18.9182a
Cext_363 n111 n353 4.36491a
Cext_364 n111 n359 33.4006a
Cext_365 n111 n390 13.4889a
Cext_366 n111 n497 1.45187f
Cext_367 n111 n653 331.072a
Cext_368 n111 n8 90.9399a
Cext_369 n111 n93 613.552a
Cext_370 n111 AVDD 988.314a
Cext_371 n111 AVSS 1.74012f
Cext_372 n111 VCM 143.779a
Cext_373 n111 AVSS 11.1789f
Cext_374 n1139 AVSS 386.985a
Cext_375 n1144 n1145 211.095a
Cext_376 n1144 n1146 102.011a
Cext_377 n1144 AVDD 151.399a
Cext_378 n1144 AVSS 22.4779a
Cext_379 n1144 AVSS 328.686a
Cext_380 n1145 n1146 309.834a
Cext_381 n1145 AVDD 94.0834a
Cext_382 n1145 AVSS 151.735a
Cext_383 n1145 AVSS 450.284a
Cext_384 n1146 AVDD 199.526a
Cext_385 n1146 AVSS 363.255a
Cext_386 n1146 AVSS 837.965a
Cext_387 n1151 n1237 962.576a
Cext_388 n1151 n1238 28.0876a
Cext_389 n1151 n1422 34.1439a
Cext_390 n1151 n655 30.8091a
Cext_391 n1151 AVDD 5.67793f
Cext_392 n1151 AVSS 2.02722f
Cext_393 n1151 VINN 73.5058a
Cext_394 n1151 AVSS 7.82928f
Cext_395 n119 n132 457.03a
Cext_396 n119 n236 795.339a
Cext_397 n119 n344 180.048a
Cext_398 n119 n345 570.314a
Cext_399 n119 n353 1.14014f
Cext_400 n119 n359 1.52886f
Cext_401 n119 n389 121.569a
Cext_402 n119 n390 7.15795a
Cext_403 n119 n497 647.093a
Cext_404 n119 n653 45.2346a
Cext_405 n119 n8 161.589a
Cext_406 n119 n93 205.061a
Cext_407 n119 AVDD 2.59647f
Cext_408 n119 AVSS 681.318a
Cext_409 n119 VCM 309.991a
Cext_410 n119 AVSS 8.9021f
Cext_411 n1230 n1231 2.1545f
Cext_412 n1230 n1237 15.0233a
Cext_413 n1230 n1238 821.414a
Cext_414 n1230 n1243 16.7433a
Cext_415 n1230 n1422 131.46a
Cext_416 n1230 AVDD 68.5362a
Cext_417 n1230 AVSS 4.03283f
Cext_418 n1230 VINN 356.728a
Cext_419 n1230 AVSS 18.0703f
Cext_420 n1231 n1237 20.4067a
Cext_421 n1231 n1238 0.178189a
Cext_422 n1231 n1243 655.306a
Cext_423 n1231 n1422 1.39193f
Cext_424 n1231 AVDD 301.649a
Cext_425 n1231 AVSS 35.79a
Cext_426 n1231 VINN 454.184a
Cext_427 n1231 AVSS 11.9176f
Cext_428 n1237 n1238 3.90042f
Cext_429 n1237 n1243 291.441a
Cext_430 n1237 n1422 223.132a
Cext_431 n1237 n655 4.41489f
Cext_432 n1237 AVDD 352.625a
Cext_433 n1237 AVSS 10.0149f
Cext_434 n1237 VINN 33.3628a
Cext_435 n1237 AVSS 15.2309f
Cext_436 n1238 n1243 0.597256a
Cext_437 n1238 n1422 147.701a
Cext_438 n1238 AVDD 7.75179a
Cext_439 n1238 AVSS 2.4148f
Cext_440 n1238 VINN 2.01243f
Cext_441 n1238 AVSS 13.0574f
Cext_442 n1243 n1245 688.486a
Cext_443 n1243 n1246 10.4031f
Cext_444 n1243 n133 179.538a
Cext_445 n1243 n1422 280.431a
Cext_446 n1243 n240 235.595a
Cext_447 n1243 n359 0.504551a
Cext_448 n1243 n360 263.943a
Cext_449 n1243 n517 41.3938a
Cext_450 n1243 n623 278.094a
Cext_451 n1243 n624 0.597256a
Cext_452 n1243 n625 61.2214a
Cext_453 n1243 n654 843.041a
Cext_454 n1243 n655 1.02876f
Cext_455 n1243 n96 41.3938a
Cext_456 n1243 n97 5.34089a
Cext_457 n1243 n98 0.597256a
Cext_458 n1243 AVDD 5.15353f
Cext_459 n1243 AVSS 4.34057f
Cext_460 n1243 IBIAS_IA 9.87844f
Cext_461 n1243 VCM 2.10367f
Cext_462 n1243 VINN 102.207a
Cext_463 n1243 VINP 17.0577a
Cext_464 n1243 AVSS 29.8042f
Cext_465 n1245 n1246 7.56939f
Cext_466 n1245 n133 4.68335f
Cext_467 n1245 n1426 3.40004f
Cext_468 n1245 n359 50.8241a
Cext_469 n1245 AVDD 6.77278f
Cext_470 n1245 AVSS 1.27575f
Cext_471 n1245 IBIAS_IA 2.18414f
Cext_472 n1245 VCM 315.888a
Cext_473 n1245 AVSS 37.4192f
Cext_474 n1246 n133 65.8129a
Cext_475 n1246 n1667 129.024a
Cext_476 n1246 n1842 29.2661a
Cext_477 n1246 n1843 0.597256a
Cext_478 n1246 n2057 266.256a
Cext_479 n1246 n359 0.274031a
Cext_480 n1246 AVDD 2.30171f
Cext_481 n1246 AVSS 1.59202f
Cext_482 n1246 IBIAS_IA 1.10592f
Cext_483 n1246 VCM 326.734a
Cext_484 n1246 VOUT 323.464a
Cext_485 n1246 AVSS 15.8457f
Cext_486 n132 n236 257.825a
Cext_487 n132 n344 929.372a
Cext_488 n132 n345 20.8982a
Cext_489 n132 n353 394.564a
Cext_490 n132 n359 1.39271f
Cext_491 n132 n389 389.607a
Cext_492 n132 n653 5.7459a
Cext_493 n132 n8 2.11721a
Cext_494 n132 n93 279.997a
Cext_495 n132 AVDD 259.835a
Cext_496 n132 AVSS 1.304f
Cext_497 n132 VCM 2.07166f
Cext_498 n132 AVSS 3.59417f
Cext_499 n133 n1426 3.48989f
Cext_500 n133 n238 15.8842a
Cext_501 n133 n345 120.683a
Cext_502 n133 n353 177.671a
Cext_503 n133 n390 0.232728a
Cext_504 n133 n497 388.584a
Cext_505 n133 n517 205.365a
Cext_506 n133 n653 702.849a
Cext_507 n133 n93 0.249088a
Cext_508 n133 AVDD 997.059a
Cext_509 n133 AVSS 2.81407f
Cext_510 n133 VCM 1.15786f
Cext_511 n133 AVSS 17.347f
Cext_512 n1422 AVDD 260.491a
Cext_513 n1422 VINN 1.37763f
Cext_514 n1422 AVSS 2.33263f
Cext_515 n1426 n1540 0.100778a
Cext_516 n1426 n1579 188.635a
Cext_517 n1426 n1580 374.902a
Cext_518 n1426 n1581 0.249088a
Cext_519 n1426 n1623 177.671a
Cext_520 n1426 n1648 15.8842a
Cext_521 n1426 n1654 120.683a
Cext_522 n1426 n1698 0.232728a
Cext_523 n1426 n1706 388.584a
Cext_524 n1426 n1768 702.849a
Cext_525 n1426 n359 259.155a
Cext_526 n1426 AVDD 1.6584f
Cext_527 n1426 AVSS 3.61135f
Cext_528 n1426 IBIAS_IA 32.0596a
Cext_529 n1426 VCM 567.052a
Cext_530 n1426 AVSS 16.9087f
Cext_531 n1540 n1579 716.628a
Cext_532 n1540 n1580 31.7384a
Cext_533 n1540 n1581 3.38527a
Cext_534 n1540 AVSS 1.02119f
Cext_535 n1540 AVSS 1.86507f
Cext_536 n1542 n1579 90.9399a
Cext_537 n1542 n1581 3.22092a
Cext_538 n1542 n1588 2.11721a
Cext_539 n1542 n1599 161.589a
Cext_540 n1542 n1645 1.50158a
Cext_541 n1542 n1667 805.36a
Cext_542 n1542 AVSS 1.06122f
Cext_543 n1542 AVSS 3.0166f
Cext_544 n1579 n1580 206.568a
Cext_545 n1579 n1581 613.552a
Cext_546 n1579 n1588 412.218a
Cext_547 n1579 n1599 842.841a
Cext_548 n1579 n1623 4.36491a
Cext_549 n1579 n1645 487.033a
Cext_550 n1579 n1654 18.9182a
Cext_551 n1579 n1667 33.4006a
Cext_552 n1579 n1698 13.4889a
Cext_553 n1579 n1706 1.45187f
Cext_554 n1579 n1748 66.3079a
Cext_555 n1579 n1766 20.7164a
Cext_556 n1579 n1768 331.072a
Cext_557 n1579 AVDD 988.314a
Cext_558 n1579 AVSS 1.86934f
Cext_559 n1579 VCM 143.779a
Cext_560 n1579 AVSS 11.1108f
Cext_561 n1580 n1581 1.12174f
Cext_562 n1580 n1588 1.11539f
Cext_563 n1580 n1599 4.15771a
Cext_564 n1580 n1623 116.618a
Cext_565 n1580 n1645 1.35607a
Cext_566 n1580 n1648 15.7279a
Cext_567 n1580 n1654 188.755a
Cext_568 n1580 n1667 20.7743a
Cext_569 n1580 n1698 5.39096a
Cext_570 n1580 n1706 1.90445f
Cext_571 n1580 n1748 36.1299a
Cext_572 n1580 n1768 24.2479a
Cext_573 n1580 AVDD 385.934a
Cext_574 n1580 AVSS 3.14794f
Cext_575 n1580 VCM 51.9279a
Cext_576 n1580 AVSS 11.1144f
Cext_577 n1581 n1588 279.997a
Cext_578 n1581 n1599 205.061a
Cext_579 n1581 n1623 181.04a
Cext_580 n1581 n1645 76.1316a
Cext_581 n1581 n1648 0.531942a
Cext_582 n1581 n1654 223.85a
Cext_583 n1581 n1667 4.38815a
Cext_584 n1581 n1695 652.757a
Cext_585 n1581 n1706 6.12484a
Cext_586 n1581 n1748 871.945a
Cext_587 n1581 n1766 2.41397f
Cext_588 n1581 n1768 3.11757a
Cext_589 n1581 AVDD 276.26a
Cext_590 n1581 AVSS 1.63266f
Cext_591 n1581 VCM 481.14a
Cext_592 n1581 AVSS 3.5021f
Cext_593 n1588 n1599 457.03a
Cext_594 n1588 n1623 394.564a
Cext_595 n1588 n1645 257.825a
Cext_596 n1588 n1654 20.8982a
Cext_597 n1588 n1667 1.39271f
Cext_598 n1588 n1695 389.607a
Cext_599 n1588 n1748 929.372a
Cext_600 n1588 n1768 5.7459a
Cext_601 n1588 AVDD 259.835a
Cext_602 n1588 AVSS 1.304f
Cext_603 n1588 VCM 2.07166f
Cext_604 n1588 AVSS 3.59417f
Cext_605 n1599 n1623 1.14014f
Cext_606 n1599 n1645 795.339a
Cext_607 n1599 n1654 570.314a
Cext_608 n1599 n1667 1.52886f
Cext_609 n1599 n1695 121.569a
Cext_610 n1599 n1698 7.15795a
Cext_611 n1599 n1706 647.093a
Cext_612 n1599 n1748 180.048a
Cext_613 n1599 n1766 70.7607a
Cext_614 n1599 n1768 45.2346a
Cext_615 n1599 AVDD 2.59647f
Cext_616 n1599 AVSS 681.318a
Cext_617 n1599 VCM 309.991a
Cext_618 n1599 AVSS 8.9021f
Cext_619 n1623 n1645 396.181a
Cext_620 n1623 n1648 78.379a
Cext_621 n1623 n1654 287.041a
Cext_622 n1623 n1667 937.516a
Cext_623 n1623 n1695 3.29571a
Cext_624 n1623 n1748 522.541a
Cext_625 n1623 n1768 0.375416a
Cext_626 n1623 AVDD 491.762a
Cext_627 n1623 AVSS 1.22414f
Cext_628 n1623 VCM 36.3815a
Cext_629 n1623 AVSS 3.6815f
Cext_630 n1645 n1654 20.1552a
Cext_631 n1645 n1667 226.71a
Cext_632 n1645 n1695 26.2082a
Cext_633 n1645 n1748 86.661a
Cext_634 n1645 AVDD 1.86545f
Cext_635 n1645 AVSS 370.674a
Cext_636 n1645 VCM 11.1852a
Cext_637 n1645 AVSS 6.63988f
Cext_638 n1648 n1654 7.01634a
Cext_639 n1648 n1748 105.49a
Cext_640 n1648 AVSS 486.445a
Cext_641 n1648 AVSS 666.921a
Cext_642 n1654 n1667 139.68a
Cext_643 n1654 n1695 127.263a
Cext_644 n1654 n1698 156.124a
Cext_645 n1654 n1706 291.801a
Cext_646 n1654 n1748 432.592a
Cext_647 n1654 n1766 3.26468a
Cext_648 n1654 n1768 28.239a
Cext_649 n1654 AVDD 2.35207f
Cext_650 n1654 AVSS 273.99a
Cext_651 n1654 VCM 164.463a
Cext_652 n1654 AVSS 5.02711f
Cext_653 n1667 n1695 291.004a
Cext_654 n1667 n1748 75.4863a
Cext_655 n1667 n1766 17.2982a
Cext_656 n1667 n1768 2.90086a
Cext_657 n1667 n1770 73.5058a
Cext_658 n1667 n1842 356.466a
Cext_659 n1667 n1843 2.01243f
Cext_660 n1667 n2037 3.45582a
Cext_661 n1667 n2057 1.37763f
Cext_662 n1667 AVDD 1.50878f
Cext_663 n1667 AVSS 1.02745f
Cext_664 n1667 VCM 164.907a
Cext_665 n1667 VOUT 573.625a
Cext_666 n1667 AVSS 34.4239f
Cext_667 n1695 n1706 0.246446a
Cext_668 n1695 n1748 171.558a
Cext_669 n1695 n1766 2.01927f
Cext_670 n1695 n1768 3.39654f
Cext_671 n1695 n677 3.4374a
Cext_672 n1695 AVDD 5.68631f
Cext_673 n1695 VCM 1.60328f
Cext_674 n1695 AVSS 4.00742f
Cext_675 n1698 n1706 34.6845a
Cext_676 n1698 n1768 16.0229a
Cext_677 n1698 AVDD 860.018a
Cext_678 n1698 VCM 18.5073a
Cext_679 n1698 AVSS 1.59798f
Cext_680 n1706 n1748 599.226a
Cext_681 n1706 n1766 228.061a
Cext_682 n1706 n1768 1.99351f
Cext_683 n1706 n359 2.24668a
Cext_684 n1706 AVDD 5.05127f
Cext_685 n1706 AVSS 347.422a
Cext_686 n1706 VCM 644.509a
Cext_687 n1706 AVSS 19.5457f
Cext_688 n1748 n1766 325.257a
Cext_689 n1748 n1768 30.7402a
Cext_690 n1748 AVDD 3.24579f
Cext_691 n1748 AVSS 910.079a
Cext_692 n1748 VCM 412.088a
Cext_693 n1748 AVSS 3.19723f
Cext_694 n1766 n1768 548.194a
Cext_695 n1766 n1851 86.3181a
Cext_696 n1766 n1852 52.6685a
Cext_697 n1766 n1853 47.0633a
Cext_698 n1766 n1854 70.9045a
Cext_699 n1766 n1855 77.1806a
Cext_700 n1766 n1856 16.0868a
Cext_701 n1766 n1859 384.05a
Cext_702 n1766 n2037 901.315a
Cext_703 n1766 n2038 311.514a
Cext_704 n1766 n2039 290.662a
Cext_705 n1766 n2040 293.599a
Cext_706 n1766 n2041 255.194a
Cext_707 n1766 n2042 148.274a
Cext_708 n1766 n359 16.6244a
Cext_709 n1766 n677 240.036a
Cext_710 n1766 n826 275.312a
Cext_711 n1766 n976 836.013a
Cext_712 n1766 n979 448.282a
Cext_713 n1766 n996 452.589a
Cext_714 n1766 AVDD 2.07038f
Cext_715 n1766 AVSS 951.734a
Cext_716 n1766 VCM 8.99176a
Cext_717 n1766 AVSS 17.3996f
Cext_718 n1768 n1851 1.93763a
Cext_719 n1768 n1852 1.55087a
Cext_720 n1768 n1853 0.878709a
Cext_721 n1768 n1854 0.675214a
Cext_722 n1768 n1855 0.614975a
Cext_723 n1768 n359 0.292923a
Cext_724 n1768 n677 164.016a
Cext_725 n1768 n826 53.1992a
Cext_726 n1768 n976 3.33186a
Cext_727 n1768 n996 16.5748a
Cext_728 n1768 AVDD 16.4451f
Cext_729 n1768 AVSS 990.186a
Cext_730 n1768 VCM 111.984a
Cext_731 n1768 AVSS 42.2543f
Cext_732 n1770 n1843 28.0876a
Cext_733 n1770 n2057 34.1439a
Cext_734 n1770 AVDD 5.81208f
Cext_735 n1770 AVSS 2.68733f
Cext_736 n1770 VOUT 775.023a
Cext_737 n1770 AVSS 7.87513f
Cext_738 n1842 n1843 821.414a
Cext_739 n1842 n2057 131.46a
Cext_740 n1842 AVDD 5.27408a
Cext_741 n1842 AVSS 4.03288f
Cext_742 n1842 VOUT 2.16558f
Cext_743 n1842 AVSS 18.0756f
Cext_744 n1843 n2057 147.701a
Cext_745 n1843 AVDD 7.75179a
Cext_746 n1843 AVSS 2.4148f
Cext_747 n1843 VOUT 3.9006f
Cext_748 n1843 AVSS 13.0574f
Cext_749 n1851 n1859 86.8078a
Cext_750 n1851 n2037 23.2372a
Cext_751 n1851 n2038 2.59005a
Cext_752 n1851 n677 1.09981a
Cext_753 n1851 n826 88.9916a
Cext_754 n1851 n976 1.51556a
Cext_755 n1851 n979 0.881791a
Cext_756 n1851 n996 6.31963a
Cext_757 n1851 AVDD 230.278a
Cext_758 n1851 AVSS 85.3167a
Cext_759 n1851 AVSS 871.924a
Cext_760 n1852 n2037 1.97174a
Cext_761 n1852 n2038 12.5716a
Cext_762 n1852 n677 1.07025a
Cext_763 n1852 n826 82.9931a
Cext_764 n1852 n976 1.46697a
Cext_765 n1852 n979 0.86383a
Cext_766 n1852 n996 13.2536a
Cext_767 n1852 AVDD 286.385a
Cext_768 n1852 AVSS 87.4602a
Cext_769 n1852 AVSS 879.633a
Cext_770 n1853 n2037 2.03175a
Cext_771 n1853 n2039 10.9248a
Cext_772 n1853 n677 18.2676a
Cext_773 n1853 n976 52.8109a
Cext_774 n1853 n979 0.909123a
Cext_775 n1853 n996 90.778a
Cext_776 n1853 AVDD 203.483a
Cext_777 n1853 AVSS 86.5386a
Cext_778 n1853 AVSS 922.032a
Cext_779 n1854 n2037 1.97994a
Cext_780 n1854 n2040 11.1041a
Cext_781 n1854 n677 129.752a
Cext_782 n1854 n976 86.9843a
Cext_783 n1854 n979 3.1237a
Cext_784 n1854 AVDD 234.188a
Cext_785 n1854 AVSS 88.8779a
Cext_786 n1854 AVSS 844.91a
Cext_787 n1855 n2037 1.66542a
Cext_788 n1855 n2041 30.0348a
Cext_789 n1855 n677 81.5561a
Cext_790 n1855 n979 44.6356a
Cext_791 n1855 AVDD 239.075a
Cext_792 n1855 AVSS 92.4463a
Cext_793 n1855 AVSS 823.906a
Cext_794 n1856 n2037 1.97994a
Cext_795 n1856 n2041 8.57318a
Cext_796 n1856 n2042 18.7116a
Cext_797 n1856 n979 81.6791a
Cext_798 n1856 AVDD 238.397a
Cext_799 n1856 AVSS 88.8779a
Cext_800 n1856 AVSS 887.611a
Cext_801 n1859 n2037 53.9848a
Cext_802 n1859 n2074 20.0532a
Cext_803 n1859 n2075 25.7732a
Cext_804 n1859 n2079 87.5604a
Cext_805 n1859 n677 182.092a
Cext_806 n1859 n826 552.905a
Cext_807 n1859 n976 127.927a
Cext_808 n1859 n979 939.67a
Cext_809 n1859 n996 127.973a
Cext_810 n1859 AVDD 1.23685f
Cext_811 n1859 AVSS 688.219a
Cext_812 n1859 AVSS 2.21386f
Cext_813 n2037 n2038 44.0818a
Cext_814 n2037 n2039 34.1024a
Cext_815 n2037 n2040 495.371a
Cext_816 n2037 n2041 798.12a
Cext_817 n2037 n2042 2.15095f
Cext_818 n2037 n2068 1.75293a
Cext_819 n2037 n2074 1.33751a
Cext_820 n2037 n2075 8.50653a
Cext_821 n2037 n2079 0.404319a
Cext_822 n2037 n677 105.455a
Cext_823 n2037 n826 8.80394a
Cext_824 n2037 n976 220.138a
Cext_825 n2037 n979 1.65906f
Cext_826 n2037 n996 769.33a
Cext_827 n2037 AVDD 183.104a
Cext_828 n2037 AVSS 88.9179a
Cext_829 n2037 AVSS 6.70282f
Cext_830 n2038 n677 3.22422a
Cext_831 n2038 n826 17.8768a
Cext_832 n2038 n976 4.42405a
Cext_833 n2038 n979 2.42328a
Cext_834 n2038 n996 19.8978a
Cext_835 n2038 AVDD 10.373a
Cext_836 n2038 AVSS 6.58361a
Cext_837 n2038 AVSS 750.764a
Cext_838 n2039 n677 3.48637a
Cext_839 n2039 n976 19.6221a
Cext_840 n2039 n979 2.07367a
Cext_841 n2039 n996 32.6275a
Cext_842 n2039 AVDD 2.02226a
Cext_843 n2039 AVSS 2.31301a
Cext_844 n2039 AVSS 717.103a
Cext_845 n2040 n2041 0.333949a
Cext_846 n2040 n2068 14.5472a
Cext_847 n2040 n677 14.2961a
Cext_848 n2040 n976 34.7718a
Cext_849 n2040 n979 267.521a
Cext_850 n2040 AVDD 1.28109a
Cext_851 n2040 AVSS 0.837701a
Cext_852 n2040 AVSS 2.86459f
Cext_853 n2041 n2042 410.321a
Cext_854 n2041 n677 8.02116a
Cext_855 n2041 n979 134.188a
Cext_856 n2041 AVDD 4.99803a
Cext_857 n2041 AVSS 3.45672f
Cext_858 n2042 n979 104.485a
Cext_859 n2042 AVDD 7.40299a
Cext_860 n2042 AVSS 2.00532f
Cext_861 n2057 AVDD 248.144a
Cext_862 n2057 VOUT 1.61758f
Cext_863 n2057 AVSS 2.33263f
Cext_864 n2068 n979 38.009a
Cext_865 n2068 AVSS 386.985a
Cext_866 n2074 n2075 309.834a
Cext_867 n2074 n2079 102.011a
Cext_868 n2074 n677 27.6106a
Cext_869 n2074 n826 45.1152a
Cext_870 n2074 n976 121.904a
Cext_871 n2074 n979 47.1227a
Cext_872 n2074 n996 162.598a
Cext_873 n2074 AVDD 300.263a
Cext_874 n2074 AVSS 363.194a
Cext_875 n2074 AVSS 838.068a
Cext_876 n2075 n2079 211.095a
Cext_877 n2075 n677 76.2579a
Cext_878 n2075 n976 1.74208a
Cext_879 n2075 n979 186.969a
Cext_880 n2075 n996 0.768506a
Cext_881 n2075 AVDD 117.931a
Cext_882 n2075 AVSS 151.735a
Cext_883 n2075 AVSS 450.595a
Cext_884 n2079 n979 0.708298a
Cext_885 n2079 AVDD 157.023a
Cext_886 n2079 AVSS 22.4779a
Cext_887 n2079 AVSS 329.017a
Cext_888 n236 n344 86.661a
Cext_889 n236 n345 20.1552a
Cext_890 n236 n353 396.181a
Cext_891 n236 n359 226.71a
Cext_892 n236 n389 26.2082a
Cext_893 n236 n8 1.50158a
Cext_894 n236 n93 76.1316a
Cext_895 n236 AVDD 1.86545f
Cext_896 n236 AVSS 370.674a
Cext_897 n236 VCM 11.1852a
Cext_898 n236 AVSS 6.63988f
Cext_899 n238 n344 105.49a
Cext_900 n238 n345 7.01634a
Cext_901 n238 n353 78.379a
Cext_902 n238 n93 0.531942a
Cext_903 n238 AVSS 486.445a
Cext_904 n238 AVSS 666.921a
Cext_905 n240 n360 1.39193f
Cext_906 n240 n654 350.778a
Cext_907 n240 n96 20.4067a
Cext_908 n240 n97 2.1542f
Cext_909 n240 n98 0.178189a
Cext_910 n240 AVDD 206.39a
Cext_911 n240 AVSS 35.6699a
Cext_912 n240 VINP 454.895a
Cext_913 n240 AVSS 11.9294f
Cext_914 n344 n345 432.592a
Cext_915 n344 n353 522.541a
Cext_916 n344 n359 75.4863a
Cext_917 n344 n389 171.558a
Cext_918 n344 n497 599.226a
Cext_919 n344 n653 30.7402a
Cext_920 n344 n93 871.945a
Cext_921 n344 AVDD 3.24579f
Cext_922 n344 AVSS 910.079a
Cext_923 n344 VCM 412.088a
Cext_924 n344 AVSS 3.19723f
Cext_925 n345 n353 287.041a
Cext_926 n345 n359 139.68a
Cext_927 n345 n389 127.263a
Cext_928 n345 n390 156.124a
Cext_929 n345 n497 291.801a
Cext_930 n345 n653 28.239a
Cext_931 n345 n93 223.85a
Cext_932 n345 AVDD 2.35207f
Cext_933 n345 AVSS 273.99a
Cext_934 n345 VCM 164.463a
Cext_935 n345 AVSS 5.02711f
Cext_936 n353 n359 937.516a
Cext_937 n353 n389 3.29571a
Cext_938 n353 n653 0.375416a
Cext_939 n353 n93 181.04a
Cext_940 n353 AVDD 491.762a
Cext_941 n353 AVSS 1.22414f
Cext_942 n353 VCM 36.3815a
Cext_943 n353 AVSS 3.6815f
Cext_944 n359 n389 291.004a
Cext_945 n359 n653 2.90086a
Cext_946 n359 n8 805.36a
Cext_947 n359 n93 4.38815a
Cext_948 n359 AVDD 2.02849f
Cext_949 n359 AVSS 1.96719f
Cext_950 n359 IBIAS_IA 130.201a
Cext_951 n359 VCM 1.01123f
Cext_952 n359 AVSS 24.4955f
Cext_953 n360 n6 34.1439a
Cext_954 n360 n654 15.2762a
Cext_955 n360 n96 223.132a
Cext_956 n360 n97 131.46a
Cext_957 n360 n98 147.701a
Cext_958 n360 AVDD 246.295a
Cext_959 n360 VINP 1.37763f
Cext_960 n360 AVSS 2.33263f
Cext_961 n389 n497 0.246446a
Cext_962 n389 n653 3.39654f
Cext_963 n389 n93 652.757a
Cext_964 n389 AVDD 5.68631f
Cext_965 n389 VCM 1.60328f
Cext_966 n389 AVSS 4.00742f
Cext_967 n390 n497 34.6845a
Cext_968 n390 n653 16.0229a
Cext_969 n390 AVDD 860.018a
Cext_970 n390 VCM 18.5073a
Cext_971 n390 AVSS 1.59798f
Cext_972 n497 n517 2.24668a
Cext_973 n497 n653 1.99351f
Cext_974 n497 n93 6.12484a
Cext_975 n497 AVDD 5.05127f
Cext_976 n497 AVSS 347.422a
Cext_977 n497 VCM 644.509a
Cext_978 n497 AVSS 19.5457f
Cext_979 n512 n517 528.057a
Cext_980 n512 n623 34.1439a
Cext_981 n512 n624 28.0876a
Cext_982 n512 n654 73.5058a
Cext_983 n512 n655 83.1417a
Cext_984 n512 AVDD 5.67793f
Cext_985 n512 AVSS 2.13836f
Cext_986 n512 AVSS 7.55217f
Cext_987 n517 n623 223.132a
Cext_988 n517 n624 3.90042f
Cext_989 n517 n625 15.0233a
Cext_990 n517 n653 0.292923a
Cext_991 n517 n654 33.3628a
Cext_992 n517 AVDD 328.698a
Cext_993 n517 AVSS 826.811a
Cext_994 n517 VCM 220.85a
Cext_995 n517 AVSS 13.9728f
Cext_996 n6 n654 30.8462a
Cext_997 n6 n96 962.45a
Cext_998 n6 n98 28.0876a
Cext_999 n6 AVDD 5.67793f
Cext_1000 n6 AVSS 2.15054f
Cext_1001 n6 VINP 73.5058a
Cext_1002 n6 AVSS 7.47724f
Cext_1003 n623 n624 147.701a
Cext_1004 n623 n625 131.46a
Cext_1005 n623 n654 1.40898f
Cext_1006 n623 n655 1.39193f
Cext_1007 n623 AVDD 261.54a
Cext_1008 n623 AVSS 2.33263f
Cext_1009 n624 n625 821.414a
Cext_1010 n624 n654 2.01243f
Cext_1011 n624 n655 0.178189a
Cext_1012 n624 AVDD 7.75179a
Cext_1013 n624 AVSS 2.4148f
Cext_1014 n624 AVSS 13.0574f
Cext_1015 n625 n654 360.757a
Cext_1016 n625 n655 2.15584f
Cext_1017 n625 AVDD 71.1091a
Cext_1018 n625 AVSS 4.03288f
Cext_1019 n625 AVSS 18.06f
Cext_1020 n650 n847 5.28342a
Cext_1021 n650 AVDD 504.969a
Cext_1022 n650 VCM 71.9278a
Cext_1023 n650 VINP 47.605a
Cext_1024 n650 AVSS 1.21917f
Cext_1025 n652 n660 558.451a
Cext_1026 n652 n663 578.982a
Cext_1027 n652 n664 70.1334a
Cext_1028 n652 n665 3.18892a
Cext_1029 n652 n666 1.6454a
Cext_1030 n652 n668 0.219623a
Cext_1031 n652 n669 0.67374a
Cext_1032 n652 n670 0.424504a
Cext_1033 n652 n671 2.30607a
Cext_1034 n652 n672 1.92918a
Cext_1035 n652 n674 40.2665a
Cext_1036 n652 n675 217.529a
Cext_1037 n652 n676 379.96a
Cext_1038 n652 n677 70.184a
Cext_1039 n652 n678 0.177115a
Cext_1040 n652 n684 192.166a
Cext_1041 n652 n686 0.628338a
Cext_1042 n652 n687 0.200495a
Cext_1043 n652 n692 152.225a
Cext_1044 n652 n697 17.8136a
Cext_1045 n652 n698 0.887221a
Cext_1046 n652 n699 0.103399a
Cext_1047 n652 n705 167.352a
Cext_1048 n652 n706 0.135894a
Cext_1049 n652 n707 0.135894a
Cext_1050 n652 n708 15.6628a
Cext_1051 n652 n713 23.9419a
Cext_1052 n652 n716 0.132922a
Cext_1053 n652 n815 242.518a
Cext_1054 n652 n818 416.445a
Cext_1055 n652 n819 0.548857a
Cext_1056 n652 n824 0.137229a
Cext_1057 n652 n825 0.300421a
Cext_1058 n652 n826 0.633355a
Cext_1059 n652 n828 216.519a
Cext_1060 n652 n842 0.102662a
Cext_1061 n652 n845 205.718a
Cext_1062 n652 n846 183.608a
Cext_1063 n652 n928 106.951a
Cext_1064 n652 n932 452.334a
Cext_1065 n652 n938 0.475826a
Cext_1066 n652 n941 0.727392a
Cext_1067 n652 n965 0.230805a
Cext_1068 n652 n971 0.568808a
Cext_1069 n652 n981 2.48262a
Cext_1070 n652 n982 1.27723a
Cext_1071 n652 n985 2.76067a
Cext_1072 n652 AVSS 5.96544a
Cext_1073 n652 VGND 651.622a
Cext_1074 n652 VPWR 375.88a
Cext_1075 n652 AVSS 2.24526f
Cext_1076 n653 n93 3.11757a
Cext_1077 n653 AVDD 16.4423f
Cext_1078 n653 AVSS 990.186a
Cext_1079 n653 VCM 111.984a
Cext_1080 n653 AVSS 42.2543f
Cext_1081 n654 n655 678.58a
Cext_1082 n654 n96 4.61531f
Cext_1083 n654 n97 10.3212a
Cext_1084 n654 AVDD 966.385a
Cext_1085 n654 AVSS 10.8807f
Cext_1086 n654 VCM 1.23796a
Cext_1087 n654 VINP 86.2982a
Cext_1088 n654 AVSS 21.3822f
Cext_1089 n655 AVDD 339.781a
Cext_1090 n655 AVSS 9.93788f
Cext_1091 n655 VCM 4.62607a
Cext_1092 n655 AVSS 18.1167f
Cext_1093 n660 n663 424.012a
Cext_1094 n660 n669 19.4174a
Cext_1095 n660 n670 0.194024a
Cext_1096 n660 n671 230.781a
Cext_1097 n660 n672 17.788a
Cext_1098 n660 n674 83.2505a
Cext_1099 n660 n675 189.07a
Cext_1100 n660 n676 0.599392a
Cext_1101 n660 n684 15.1596a
Cext_1102 n660 n686 0.121943a
Cext_1103 n660 n687 13.4725a
Cext_1104 n660 n689 202.823a
Cext_1105 n660 n690 2.58787a
Cext_1106 n660 n691 0.811975a
Cext_1107 n660 n692 136.167a
Cext_1108 n660 n693 1.02123a
Cext_1109 n660 n694 4.15003a
Cext_1110 n660 n695 5.54524a
Cext_1111 n660 n696 8.03932a
Cext_1112 n660 n697 47.0748a
Cext_1113 n660 n703 14.8195a
Cext_1114 n660 n705 24.2654a
Cext_1115 n660 n706 2.85548a
Cext_1116 n660 n707 85.1672a
Cext_1117 n660 n713 35.72a
Cext_1118 n660 n818 277.808a
Cext_1119 n660 n819 1.70602a
Cext_1120 n660 n825 1.03384a
Cext_1121 n660 n826 30.3282a
Cext_1122 n660 n837 0.268112a
Cext_1123 n660 n839 0.0451541a
Cext_1124 n660 n845 153.645a
Cext_1125 n660 n932 5.89418a
Cext_1126 n660 n938 19.0438a
Cext_1127 n660 n965 10.5846a
Cext_1128 n660 AVSS 1.19881a
Cext_1129 n660 VGND 346.922a
Cext_1130 n660 VPWR 98.6758a
Cext_1131 n660 AVSS 534.063a
Cext_1132 n663 n671 0.167021a
Cext_1133 n663 n674 182.128a
Cext_1134 n663 n675 1.66449a
Cext_1135 n663 n676 1.40622a
Cext_1136 n663 n677 1.58836a
Cext_1137 n663 n678 1.89417a
Cext_1138 n663 n695 145.586a
Cext_1139 n663 n696 43.4773a
Cext_1140 n663 n697 0.662719a
Cext_1141 n663 n698 0.929231a
Cext_1142 n663 n699 0.918973a
Cext_1143 n663 n703 0.125165a
Cext_1144 n663 n705 12.0359a
Cext_1145 n663 n706 30.1226a
Cext_1146 n663 n707 0.182792a
Cext_1147 n663 n708 0.738208a
Cext_1148 n663 n713 25.2457a
Cext_1149 n663 n818 0.586708a
Cext_1150 n663 n971 0.363157a
Cext_1151 n663 AVSS 0.157461a
Cext_1152 n663 VGND 171.162a
Cext_1153 n663 VPWR 34.3952a
Cext_1154 n663 AVSS 383.479a
Cext_1155 n664 n665 2.34118f
Cext_1156 n664 n666 394.185a
Cext_1157 n664 n668 231.211a
Cext_1158 n664 n681 148.098a
Cext_1159 n664 n682 49.6856a
Cext_1160 n664 n684 183.864a
Cext_1161 n664 n692 154.087a
Cext_1162 n664 n703 4.33057a
Cext_1163 n664 n706 95.0917a
Cext_1164 n664 n715 0.206011a
Cext_1165 n664 n815 135.354a
Cext_1166 n664 n816 170.942a
Cext_1167 n664 n818 127.675a
Cext_1168 n664 n833 191.811a
Cext_1169 n664 n837 0.548857a
Cext_1170 n664 n928 165.758a
Cext_1171 n664 n939 5.32923a
Cext_1172 n664 n963 0.239276a
Cext_1173 n664 AVSS 14.9389a
Cext_1174 n664 gain_sel[0] 28.9481a
Cext_1175 n664 gain_sel[1] 7.43686a
Cext_1176 n664 VGND 820.938a
Cext_1177 n664 VPWR 802.854a
Cext_1178 n664 AVSS 1.64622f
Cext_1179 n665 n666 221.418a
Cext_1180 n665 n668 158.401a
Cext_1181 n665 n682 148.607a
Cext_1182 n665 n684 111.361a
Cext_1183 n665 n692 794.863a
Cext_1184 n665 n703 0.203793a
Cext_1185 n665 n706 1.12416a
Cext_1186 n665 n707 0.125973a
Cext_1187 n665 n715 14.975a
Cext_1188 n665 n815 82.8427a
Cext_1189 n665 n816 218.083a
Cext_1190 n665 n818 52.8594a
Cext_1191 n665 n833 87.4535a
Cext_1192 n665 n928 1.81233f
Cext_1193 n665 n939 25.0103a
Cext_1194 n665 AVSS 14.0686a
Cext_1195 n665 gain_sel[0] 10.1084a
Cext_1196 n665 gain_sel[1] 0.130712a
Cext_1197 n665 VGND 645.034a
Cext_1198 n665 VPWR 548.025a
Cext_1199 n665 AVSS 1.41152f
Cext_1200 n666 n668 86.2003a
Cext_1201 n666 n684 106.708a
Cext_1202 n666 n686 1.01726a
Cext_1203 n666 n692 26.6532a
Cext_1204 n666 n703 29.49a
Cext_1205 n666 n706 82.8026a
Cext_1206 n666 n707 0.0158206a
Cext_1207 n666 n715 2.80585a
Cext_1208 n666 n816 104.147a
Cext_1209 n666 n818 436.446a
Cext_1210 n666 n833 5.4677a
Cext_1211 n666 n928 227.337a
Cext_1212 n666 AVSS 7.55832a
Cext_1213 n666 VGND 248.859a
Cext_1214 n666 VPWR 380.777a
Cext_1215 n666 AVSS 638.504a
Cext_1216 n668 n669 1.5412a
Cext_1217 n668 n672 1.39415a
Cext_1218 n668 n684 39.5005a
Cext_1219 n668 n686 47.3389a
Cext_1220 n668 n687 185.29a
Cext_1221 n668 n691 1.09339a
Cext_1222 n668 n692 55.0342a
Cext_1223 n668 n703 50.1548a
Cext_1224 n668 n706 62.8975a
Cext_1225 n668 n707 1.47956f
Cext_1226 n668 n715 0.457738a
Cext_1227 n668 n816 277.684a
Cext_1228 n668 n818 1.23912f
Cext_1229 n668 n819 202.728a
Cext_1230 n668 n820 83.9588a
Cext_1231 n668 n821 56.548a
Cext_1232 n668 n822 6.03836a
Cext_1233 n668 n833 0.168063a
Cext_1234 n668 n835 2.64867a
Cext_1235 n668 n836 42.5204a
Cext_1236 n668 n837 505.917a
Cext_1237 n668 n839 1.68788a
Cext_1238 n668 n840 185.83a
Cext_1239 n668 n842 86.9421a
Cext_1240 n668 n843 128.946a
Cext_1241 n668 n928 88.3317a
Cext_1242 n668 n938 10.0484a
Cext_1243 n668 n940 0.692439a
Cext_1244 n668 n965 125.872a
Cext_1245 n668 n967 14.2202a
Cext_1246 n668 n968 7.0578a
Cext_1247 n668 n969 0.54548a
Cext_1248 n668 n971 2.15692a
Cext_1249 n668 AVSS 41.2957a
Cext_1250 n668 VGND 220.115a
Cext_1251 n668 VPWR 507.108a
Cext_1252 n668 AVSS 1.00836f
Cext_1253 n669 n670 26.528a
Cext_1254 n669 n671 513.84a
Cext_1255 n669 n672 0.229374a
Cext_1256 n669 n684 129.243a
Cext_1257 n669 n686 42.865a
Cext_1258 n669 n687 14.7664a
Cext_1259 n669 n689 5.24501a
Cext_1260 n669 n690 23.3604a
Cext_1261 n669 n691 194.094a
Cext_1262 n669 n692 166.821a
Cext_1263 n669 n693 0.108554a
Cext_1264 n669 n703 788.075a
Cext_1265 n669 n818 0.248245a
Cext_1266 n669 n821 0.278323a
Cext_1267 n669 n836 0.309793a
Cext_1268 n669 n837 1.93589a
Cext_1269 n669 n840 1.91797a
Cext_1270 n669 n938 0.112584a
Cext_1271 n669 n965 12.0711a
Cext_1272 n669 VGND 75.6535a
Cext_1273 n669 VPWR 139.809a
Cext_1274 n669 AVSS 358.497a
Cext_1275 n670 n671 55.465a
Cext_1276 n670 n684 1.6878a
Cext_1277 n670 n686 54.6239a
Cext_1278 n670 n687 26.0799a
Cext_1279 n670 n692 88.6781a
Cext_1280 n670 n703 0.116772a
Cext_1281 n670 VGND 95.8442a
Cext_1282 n670 VPWR 3.52499a
Cext_1283 n670 AVSS 48.4088a
Cext_1284 n671 n672 69.7784a
Cext_1285 n671 n674 0.944137a
Cext_1286 n671 n684 36.6941a
Cext_1287 n671 n686 21.2559a
Cext_1288 n671 n687 137.146a
Cext_1289 n671 n689 30.0924a
Cext_1290 n671 n690 6.33667a
Cext_1291 n671 n691 7.97683a
Cext_1292 n671 n692 212.484a
Cext_1293 n671 n693 27.5009a
Cext_1294 n671 n694 201.224a
Cext_1295 n671 n695 2.11501a
Cext_1296 n671 n696 0.309501a
Cext_1297 n671 n703 173.318a
Cext_1298 n671 n705 4.26987a
Cext_1299 n671 n717 1.14709a
Cext_1300 n671 n818 0.424455a
Cext_1301 n671 n819 2.32419a
Cext_1302 n671 n837 6.55467a
Cext_1303 n671 n928 1.43893a
Cext_1304 n671 n940 0.201801a
Cext_1305 n671 n965 4.69651a
Cext_1306 n671 VGND 65.5261a
Cext_1307 n671 VPWR 127.445a
Cext_1308 n671 AVSS 426.328a
Cext_1309 n672 n676 0.23337a
Cext_1310 n672 n677 16.5105a
Cext_1311 n672 n684 26.1938a
Cext_1312 n672 n687 0.173847a
Cext_1313 n672 n690 0.179019a
Cext_1314 n672 n691 1.09854a
Cext_1315 n672 n692 171.146a
Cext_1316 n672 n693 30.3286a
Cext_1317 n672 n694 1.40611a
Cext_1318 n672 n695 0.147478a
Cext_1319 n672 n703 92.7375a
Cext_1320 n672 n705 2.46765a
Cext_1321 n672 n706 15.3563a
Cext_1322 n672 n707 25.2851a
Cext_1323 n672 n708 0.868167a
Cext_1324 n672 n717 6.94118a
Cext_1325 n672 n816 851.043a
Cext_1326 n672 n818 22.8804a
Cext_1327 n672 n819 167.475a
Cext_1328 n672 n820 2.85027a
Cext_1329 n672 n822 98.6815a
Cext_1330 n672 n826 0.759743a
Cext_1331 n672 n837 301.769a
Cext_1332 n672 n840 60.273a
Cext_1333 n672 n842 16.2914a
Cext_1334 n672 n843 3.685a
Cext_1335 n672 n932 3.67231a
Cext_1336 n672 n938 120.361a
Cext_1337 n672 n965 0.208999a
Cext_1338 n672 n967 36.08a
Cext_1339 n672 n968 1.28204f
Cext_1340 n672 n969 57.3321a
Cext_1341 n672 n971 27.236a
Cext_1342 n672 n973 15.2631a
Cext_1343 n672 n974 5.01919a
Cext_1344 n672 n975 6.35801a
Cext_1345 n672 n976 248.598a
Cext_1346 n672 n977 7.3972a
Cext_1347 n672 n979 24.2736a
Cext_1348 n672 n980 7.23434a
Cext_1349 n672 n981 24.5469a
Cext_1350 n672 n982 23.5397a
Cext_1351 n672 n983 51.1007a
Cext_1352 n672 n984 199.488a
Cext_1353 n672 n985 16.016a
Cext_1354 n672 n986 0.549098a
Cext_1355 n672 n996 273.374a
Cext_1356 n672 AVSS 254.708a
Cext_1357 n672 VGND 217.168a
Cext_1358 n672 VPWR 424.337a
Cext_1359 n672 AVSS 1.02684f
Cext_1360 n674 n675 9.45687a
Cext_1361 n674 n676 11.4927a
Cext_1362 n674 n677 9.08536a
Cext_1363 n674 n678 12.0287a
Cext_1364 n674 n695 0.477369a
Cext_1365 n674 n696 147.591a
Cext_1366 n674 n697 51.6281a
Cext_1367 n674 n698 12.2392a
Cext_1368 n674 n699 11.1095a
Cext_1369 n674 n705 0.134951a
Cext_1370 n674 n706 6.39476a
Cext_1371 n674 n707 43.0498a
Cext_1372 n674 n708 9.03563a
Cext_1373 n674 n713 201.096a
Cext_1374 n674 n716 2.05729a
Cext_1375 n674 n818 10.4239a
Cext_1376 n674 n826 2.4172a
Cext_1377 n674 n971 8.53689a
Cext_1378 n674 AVSS 0.167254a
Cext_1379 n674 VGND 113.452a
Cext_1380 n674 VPWR 38.0105a
Cext_1381 n674 AVSS 342.431a
Cext_1382 n675 n676 14.9799a
Cext_1383 n675 n677 20.141a
Cext_1384 n675 n678 29.2433a
Cext_1385 n675 n697 145.84a
Cext_1386 n675 n698 0.264591a
Cext_1387 n675 n699 0.569287a
Cext_1388 n675 n705 606.695a
Cext_1389 n675 n707 4.91329a
Cext_1390 n675 n708 18.5909a
Cext_1391 n675 n713 134.362a
Cext_1392 n675 n818 491.133a
Cext_1393 n675 n828 3.34498a
Cext_1394 n675 n845 5.31614a
Cext_1395 n675 n846 2.51052a
Cext_1396 n675 n932 96.2198a
Cext_1397 n675 n941 6.00457a
Cext_1398 n675 n971 25.663a
Cext_1399 n675 n980 0.138836a
Cext_1400 n675 AVSS 4.05264a
Cext_1401 n675 VGND 70.7572a
Cext_1402 n675 VPWR 125.044a
Cext_1403 n675 AVSS 250.852a
Cext_1404 n676 n677 228.47a
Cext_1405 n676 n678 15.7301a
Cext_1406 n676 n698 6.06109a
Cext_1407 n676 n705 24.3276a
Cext_1408 n676 n708 4.69375a
Cext_1409 n676 n713 25.6802a
Cext_1410 n676 n716 0.490434a
Cext_1411 n676 n818 466.211a
Cext_1412 n676 n822 2.55724a
Cext_1413 n676 n826 515.59a
Cext_1414 n676 n828 12.5217a
Cext_1415 n676 n845 17.9096a
Cext_1416 n676 n846 1.45828a
Cext_1417 n676 n932 104.767a
Cext_1418 n676 n938 20.0763a
Cext_1419 n676 n971 149.406a
Cext_1420 n676 n976 0.900232a
Cext_1421 n676 n984 13.9992a
Cext_1422 n676 n985 17.0449a
Cext_1423 n676 n986 202.213a
Cext_1424 n676 n987 5.5521a
Cext_1425 n676 n996 19.4575a
Cext_1426 n676 AVSS 12.6515a
Cext_1427 n676 VGND 169.129a
Cext_1428 n676 VPWR 249.994a
Cext_1429 n676 AVSS 381.505a
Cext_1430 n677 n678 33.3637a
Cext_1431 n677 n698 147.725a
Cext_1432 n677 n699 49.6198a
Cext_1433 n677 n705 203.226a
Cext_1434 n677 n708 23.9471a
Cext_1435 n677 n713 32.4193a
Cext_1436 n677 n818 42.7623a
Cext_1437 n677 n822 8.25953a
Cext_1438 n677 n826 179.664a
Cext_1439 n677 n828 0.114062a
Cext_1440 n677 n846 38.3165a
Cext_1441 n677 n932 24.0324a
Cext_1442 n677 n938 2.23297a
Cext_1443 n677 n971 113.977a
Cext_1444 n677 n976 11.9855f
Cext_1445 n677 n979 11.2371f
Cext_1446 n677 n982 0.489947a
Cext_1447 n677 n983 1.02006a
Cext_1448 n677 n984 12.8751a
Cext_1449 n677 n985 269.821a
Cext_1450 n677 n986 23.182a
Cext_1451 n677 n987 73.9368a
Cext_1452 n677 n996 165.816a
Cext_1453 n677 AVDD 814.639a
Cext_1454 n677 AVSS 2.17619f
Cext_1455 n677 IBIAS_IA 52.7428a
Cext_1456 n677 VCM 53.4518a
Cext_1457 n677 VGND 149.437a
Cext_1458 n677 VPWR 188.181a
Cext_1459 n677 AVSS 10.123f
Cext_1460 n678 n699 146.657a
Cext_1461 n678 n705 3.73784a
Cext_1462 n678 n713 35.2724a
Cext_1463 n678 n826 29.03a
Cext_1464 n678 n846 0.275934a
Cext_1465 n678 n932 28.4949a
Cext_1466 n678 n941 16.3461a
Cext_1467 n678 n971 203.803a
Cext_1468 n678 n976 26.6833a
Cext_1469 n678 n979 107.684a
Cext_1470 n678 n981 81.2691a
Cext_1471 n678 n985 0.177115a
Cext_1472 n678 n986 11.7611a
Cext_1473 n678 n987 549.648a
Cext_1474 n678 n996 30.0315a
Cext_1475 n678 AVSS 113.24a
Cext_1476 n678 VGND 81.9065a
Cext_1477 n678 VPWR 78.3325a
Cext_1478 n678 AVSS 892.156a
Cext_1479 n681 n682 2.65089a
Cext_1480 n681 gain_sel[0] 18.5467a
Cext_1481 n681 gain_sel[1] 204.713a
Cext_1482 n681 VGND 63.6253a
Cext_1483 n681 VPWR 72.2115a
Cext_1484 n681 AVSS 353.253a
Cext_1485 n682 n963 0.268488a
Cext_1486 n682 gain_sel[0] 204.359a
Cext_1487 n682 gain_sel[1] 0.470867a
Cext_1488 n682 VGND 72.4791a
Cext_1489 n682 VPWR 82.1325a
Cext_1490 n682 AVSS 308.333a
Cext_1491 n684 n686 138.489a
Cext_1492 n684 n687 25.9217a
Cext_1493 n684 n689 6.87229a
Cext_1494 n684 n690 7.15078a
Cext_1495 n684 n691 6.98737a
Cext_1496 n684 n692 2.1089f
Cext_1497 n684 n693 9.7309a
Cext_1498 n684 n694 11.2742a
Cext_1499 n684 n695 14.8285a
Cext_1500 n684 n703 611.411a
Cext_1501 n684 n705 217.232a
Cext_1502 n684 n706 7.93309a
Cext_1503 n684 n707 19.906a
Cext_1504 n684 n713 9.15711a
Cext_1505 n684 n715 1.83979a
Cext_1506 n684 n717 0.719712a
Cext_1507 n684 n815 0.722967a
Cext_1508 n684 n816 0.419726a
Cext_1509 n684 n818 146.496a
Cext_1510 n684 n819 0.143265a
Cext_1511 n684 n822 0.114825a
Cext_1512 n684 n824 194.695a
Cext_1513 n684 n833 5.06054a
Cext_1514 n684 n835 0.915267a
Cext_1515 n684 n837 19.0202a
Cext_1516 n684 n840 0.110572a
Cext_1517 n684 n842 20.8927a
Cext_1518 n684 n928 334.43a
Cext_1519 n684 n932 1.66661a
Cext_1520 n684 n938 1.04859a
Cext_1521 n684 n965 29.918a
Cext_1522 n684 n996 1.21882a
Cext_1523 n684 AVSS 3.87039a
Cext_1524 n684 VGND 230.644a
Cext_1525 n684 VPWR 635.681a
Cext_1526 n684 AVSS 873.211a
Cext_1527 n686 n687 203.562a
Cext_1528 n686 n692 165.518a
Cext_1529 n686 n703 68.378a
Cext_1530 n686 n706 0.739279a
Cext_1531 n686 n707 30.1953a
Cext_1532 n686 n818 116.049a
Cext_1533 n686 n835 187.729a
Cext_1534 n686 n836 44.5542a
Cext_1535 n686 n837 7.61393a
Cext_1536 n686 n928 57.1493a
Cext_1537 n686 n940 0.0441673a
Cext_1538 n686 AVSS 3.54128a
Cext_1539 n686 VGND 56.8673a
Cext_1540 n686 VPWR 316.78a
Cext_1541 n686 AVSS 454.94a
Cext_1542 n687 n689 2.35842a
Cext_1543 n687 n692 126.373a
Cext_1544 n687 n703 16.0405a
Cext_1545 n687 n706 20.6621a
Cext_1546 n687 n707 15.5673a
Cext_1547 n687 n816 5.39606a
Cext_1548 n687 n818 25.7999a
Cext_1549 n687 n819 1.2358a
Cext_1550 n687 n822 1.65385a
Cext_1551 n687 n836 0.283168a
Cext_1552 n687 n837 404.902a
Cext_1553 n687 n839 18.6234a
Cext_1554 n687 n928 88.593a
Cext_1555 n687 n940 2.37727a
Cext_1556 n687 n965 50.3797a
Cext_1557 n687 n967 16.8822a
Cext_1558 n687 AVSS 7.46752a
Cext_1559 n687 VGND 105.18a
Cext_1560 n687 VPWR 253.452a
Cext_1561 n687 AVSS 397.055a
Cext_1562 n689 n690 2.49364a
Cext_1563 n689 n692 22.6216a
Cext_1564 n689 n703 5.24616a
Cext_1565 n689 n818 1.89802a
Cext_1566 n689 n819 0.303722a
Cext_1567 n689 n822 0.102219a
Cext_1568 n689 n839 0.278952a
Cext_1569 n689 n965 24.267a
Cext_1570 n689 AVSS 0.229175a
Cext_1571 n689 VGND 53.9388a
Cext_1572 n689 VPWR 80.9599a
Cext_1573 n689 AVSS 305.741a
Cext_1574 n690 n691 2.31821a
Cext_1575 n690 n692 1.93331a
Cext_1576 n690 n703 5.65884a
Cext_1577 n690 n820 1.66423a
Cext_1578 n690 n965 191.281a
Cext_1579 n690 AVSS 0.396334a
Cext_1580 n690 VGND 54.1062a
Cext_1581 n690 VPWR 69.2175a
Cext_1582 n690 AVSS 304.316a
Cext_1583 n691 n692 19.7266a
Cext_1584 n691 n693 0.0281305a
Cext_1585 n691 n703 7.79123a
Cext_1586 n691 n837 0.171828a
Cext_1587 n691 n840 0.50124a
Cext_1588 n691 n965 0.758095a
Cext_1589 n691 AVSS 0.15425a
Cext_1590 n691 VGND 53.8755a
Cext_1591 n691 VPWR 70.1467a
Cext_1592 n691 AVSS 306.292a
Cext_1593 n692 n693 1.18314a
Cext_1594 n692 n694 1.65898a
Cext_1595 n692 n703 46.5964a
Cext_1596 n692 n705 0.851994a
Cext_1597 n692 n706 30.1922a
Cext_1598 n692 n707 242.456a
Cext_1599 n692 n713 0.46623a
Cext_1600 n692 n715 3.41145a
Cext_1601 n692 n816 11.6494a
Cext_1602 n692 n818 646.331a
Cext_1603 n692 n819 351.328a
Cext_1604 n692 n820 108.891a
Cext_1605 n692 n821 1.45335a
Cext_1606 n692 n822 12.3975a
Cext_1607 n692 n824 10.7944a
Cext_1608 n692 n833 44.6584a
Cext_1609 n692 n837 190.964a
Cext_1610 n692 n839 40.9474a
Cext_1611 n692 n840 5.82758a
Cext_1612 n692 n842 21.5388a
Cext_1613 n692 n928 107.209a
Cext_1614 n692 n932 6.11143a
Cext_1615 n692 n938 1.5016a
Cext_1616 n692 n965 341.731a
Cext_1617 n692 n974 0.57556a
Cext_1618 n692 AVSS 35.3733a
Cext_1619 n692 VGND 451.159a
Cext_1620 n692 VPWR 693.872a
Cext_1621 n692 AVSS 1.5328f
Cext_1622 n693 n694 2.35455a
Cext_1623 n693 n703 190.943a
Cext_1624 n693 n705 0.222352a
Cext_1625 n693 n717 5.91686a
Cext_1626 n693 n816 0.502166a
Cext_1627 n693 n822 0.302476a
Cext_1628 n693 n837 4.80779a
Cext_1629 n693 n840 0.215926a
Cext_1630 n693 AVSS 0.393626a
Cext_1631 n693 VGND 58.4225a
Cext_1632 n693 VPWR 80.9969a
Cext_1633 n693 AVSS 315.251a
Cext_1634 n694 n695 2.46099a
Cext_1635 n694 n703 0.316934a
Cext_1636 n694 n705 15.7758a
Cext_1637 n694 n707 0.866394a
Cext_1638 n694 n819 0.461964a
Cext_1639 n694 n969 0.215926a
Cext_1640 n694 AVSS 0.393626a
Cext_1641 n694 VGND 54.2168a
Cext_1642 n694 VPWR 68.5353a
Cext_1643 n694 AVSS 304.921a
Cext_1644 n695 n696 2.35404a
Cext_1645 n695 n705 205.163a
Cext_1646 n695 n706 15.4295a
Cext_1647 n695 n713 0.913109a
Cext_1648 n695 n818 3.16004a
Cext_1649 n695 n824 1.18959a
Cext_1650 n695 AVSS 0.501642a
Cext_1651 n695 VGND 54.2168a
Cext_1652 n695 VPWR 68.6109a
Cext_1653 n695 AVSS 303.877a
Cext_1654 n696 n697 2.35404a
Cext_1655 n696 n706 200.835a
Cext_1656 n696 n707 20.828a
Cext_1657 n696 n713 11.5219a
Cext_1658 n696 n818 0.640165a
Cext_1659 n696 n825 1.18959a
Cext_1660 n696 n842 0.647104a
Cext_1661 n696 AVSS 0.365366a
Cext_1662 n696 VGND 54.2921a
Cext_1663 n696 VPWR 68.6109a
Cext_1664 n696 AVSS 303.774a
Cext_1665 n697 n698 0.0281305a
Cext_1666 n697 n707 196.465a
Cext_1667 n697 n713 6.51918a
Cext_1668 n697 n818 1.89696a
Cext_1669 n697 n845 0.865652a
Cext_1670 n697 n938 0.114034a
Cext_1671 n697 AVSS 0.109203a
Cext_1672 n697 VGND 55.4083a
Cext_1673 n697 VPWR 70.232a
Cext_1674 n697 AVSS 305.732a
Cext_1675 n698 n699 2.62352a
Cext_1676 n698 n708 201.491a
Cext_1677 n698 n713 10.0804a
Cext_1678 n698 n716 5.91686a
Cext_1679 n698 n818 7.00005a
Cext_1680 n698 n971 15.7758a
Cext_1681 n698 n984 0.1709a
Cext_1682 n698 AVSS 0.270248a
Cext_1683 n698 VGND 54.3948a
Cext_1684 n698 VPWR 81.5844a
Cext_1685 n698 AVSS 315.772a
Cext_1686 n699 n705 0.50124a
Cext_1687 n699 n708 0.677119a
Cext_1688 n699 n713 8.65114a
Cext_1689 n699 n818 0.116557a
Cext_1690 n699 n941 0.246433a
Cext_1691 n699 n971 211.235a
Cext_1692 n699 n986 0.228084a
Cext_1693 n699 AVSS 0.363965a
Cext_1694 n699 VGND 54.055a
Cext_1695 n699 VPWR 68.6901a
Cext_1696 n699 AVSS 337.811a
Cext_1697 n703 n705 0.191562a
Cext_1698 n703 n706 20.6941a
Cext_1699 n703 n707 67.0182a
Cext_1700 n703 n717 17.9966a
Cext_1701 n703 n816 21.475a
Cext_1702 n703 n818 5.69534a
Cext_1703 n703 n835 6.71514a
Cext_1704 n703 n837 29.2669a
Cext_1705 n703 n928 7.98389a
Cext_1706 n703 n965 33.4821a
Cext_1707 n703 AVSS 2.98494a
Cext_1708 n703 VGND 114.646a
Cext_1709 n703 VPWR 310.238a
Cext_1710 n703 AVSS 396.181a
Cext_1711 n705 n706 47.824a
Cext_1712 n705 n707 355.134a
Cext_1713 n705 n708 8.85535a
Cext_1714 n705 n713 176.214a
Cext_1715 n705 n818 115.853a
Cext_1716 n705 n824 17.3187a
Cext_1717 n705 n825 7.46194a
Cext_1718 n705 n826 21.4771a
Cext_1719 n705 n828 7.10787a
Cext_1720 n705 n842 198.583a
Cext_1721 n705 n845 8.28803a
Cext_1722 n705 n846 182.383a
Cext_1723 n705 n932 99.4056a
Cext_1724 n705 n941 23.8137a
Cext_1725 n705 n968 1.1129a
Cext_1726 n705 n971 191.439a
Cext_1727 n705 AVSS 3.01732a
Cext_1728 n705 VGND 39.6989a
Cext_1729 n705 VPWR 173.225a
Cext_1730 n705 AVSS 429.706a
Cext_1731 n706 n707 52.3427a
Cext_1732 n706 n713 224.369a
Cext_1733 n706 n816 548.813a
Cext_1734 n706 n818 133.554a
Cext_1735 n706 n819 27.5742a
Cext_1736 n706 n820 0.603259a
Cext_1737 n706 n822 1.3732f
Cext_1738 n706 n824 8.24485a
Cext_1739 n706 n825 25.3482a
Cext_1740 n706 n826 44.3268a
Cext_1741 n706 n835 0.599471a
Cext_1742 n706 n836 1.70339a
Cext_1743 n706 n837 33.686a
Cext_1744 n706 n839 1.12576a
Cext_1745 n706 n840 563.924a
Cext_1746 n706 n842 101.707a
Cext_1747 n706 n928 81.8554a
Cext_1748 n706 n932 50.6822a
Cext_1749 n706 n938 35.4672a
Cext_1750 n706 n965 600.393a
Cext_1751 n706 n967 50.5719a
Cext_1752 n706 n968 3.49939a
Cext_1753 n706 n969 3.90436a
Cext_1754 n706 n971 155.46a
Cext_1755 n706 n973 1.30917a
Cext_1756 n706 n974 1.8742a
Cext_1757 n706 n975 1.9204a
Cext_1758 n706 n976 13.8707a
Cext_1759 n706 n996 3.16863a
Cext_1760 n706 AVSS 77.1668a
Cext_1761 n706 VGND 418.681a
Cext_1762 n706 VPWR 355.485a
Cext_1763 n706 AVSS 867.559a
Cext_1764 n707 n713 40.6427a
Cext_1765 n707 n816 41.1878a
Cext_1766 n707 n818 961.506a
Cext_1767 n707 n819 87.1023a
Cext_1768 n707 n820 7.14519a
Cext_1769 n707 n821 0.78461a
Cext_1770 n707 n822 8.96284a
Cext_1771 n707 n824 15.1647a
Cext_1772 n707 n825 5.86432a
Cext_1773 n707 n826 9.84239a
Cext_1774 n707 n835 14.1896a
Cext_1775 n707 n836 5.18192a
Cext_1776 n707 n837 807.354a
Cext_1777 n707 n839 4.44459a
Cext_1778 n707 n840 14.7662a
Cext_1779 n707 n842 661.571a
Cext_1780 n707 n843 4.82988a
Cext_1781 n707 n845 0.139167a
Cext_1782 n707 n928 46.1604a
Cext_1783 n707 n932 10.9756a
Cext_1784 n707 n938 9.53971a
Cext_1785 n707 n940 0.710654a
Cext_1786 n707 n965 10.1404a
Cext_1787 n707 n969 1.56539a
Cext_1788 n707 n974 0.111497a
Cext_1789 n707 n979 1.11445a
Cext_1790 n707 AVSS 5.31895a
Cext_1791 n707 VGND 107.016a
Cext_1792 n707 VPWR 350.357a
Cext_1793 n707 AVSS 715.166a
Cext_1794 n708 n713 29.5853a
Cext_1795 n708 n716 17.9012a
Cext_1796 n708 n818 166.842a
Cext_1797 n708 n828 77.7048a
Cext_1798 n708 n846 79.0324a
Cext_1799 n708 n932 7.23451a
Cext_1800 n708 n938 0.254178a
Cext_1801 n708 n971 8.85621a
Cext_1802 n708 AVSS 3.27555a
Cext_1803 n708 VGND 64.7799a
Cext_1804 n708 VPWR 146.965a
Cext_1805 n708 AVSS 365.541a
Cext_1806 n713 n716 1.73105a
Cext_1807 n713 n818 188.034a
Cext_1808 n713 n819 0.16275a
Cext_1809 n713 n822 0.596351a
Cext_1810 n713 n824 143.672a
Cext_1811 n713 n825 43.082a
Cext_1812 n713 n826 0.110572a
Cext_1813 n713 n842 17.6594a
Cext_1814 n713 n846 0.253087a
Cext_1815 n713 n932 4.0567a
Cext_1816 n713 n938 3.63465a
Cext_1817 n713 n971 26.9964a
Cext_1818 n713 n975 0.655175a
Cext_1819 n713 AVSS 3.04377a
Cext_1820 n713 VGND 60.219a
Cext_1821 n713 VPWR 118.661a
Cext_1822 n713 AVSS 306.989a
Cext_1823 n715 n818 15.58a
Cext_1824 n715 VGND 2.15951a
Cext_1825 n715 VPWR 11.1828a
Cext_1826 n715 AVSS 118.069a
Cext_1827 n716 n818 17.4928a
Cext_1828 n716 n828 0.563214a
Cext_1829 n716 AVSS 0.220928a
Cext_1830 n716 VGND 2.04196a
Cext_1831 n716 VPWR 7.60863a
Cext_1832 n716 AVSS 114.038a
Cext_1833 n717 n837 17.543a
Cext_1834 n717 n938 0.177439a
Cext_1835 n717 AVSS 0.234054a
Cext_1836 n717 VGND 2.35369a
Cext_1837 n717 VPWR 7.74525a
Cext_1838 n717 AVSS 114.977a
Cext_1839 n8 n93 3.22092a
Cext_1840 n8 AVSS 1.04249f
Cext_1841 n8 AVSS 3.0166f
Cext_1842 n815 n818 1.5715a
Cext_1843 n815 n928 126.055a
Cext_1844 n815 n939 4.64786a
Cext_1845 n815 AVSS 2.86603a
Cext_1846 n815 VGND 217.322a
Cext_1847 n815 VPWR 233.283a
Cext_1848 n815 AVSS 357.817a
Cext_1849 n816 n818 56.0414a
Cext_1850 n816 n819 118.403a
Cext_1851 n816 n822 286.271a
Cext_1852 n816 n824 0.117845a
Cext_1853 n816 n833 141.376a
Cext_1854 n816 n837 62.2618a
Cext_1855 n816 n840 136.487a
Cext_1856 n816 n842 7.75172a
Cext_1857 n816 n928 54.7154a
Cext_1858 n816 n932 222.925a
Cext_1859 n816 n938 20.0214a
Cext_1860 n816 n965 33.2614a
Cext_1861 n816 n967 50.8647a
Cext_1862 n816 n968 55.0198a
Cext_1863 n816 n969 50.4486a
Cext_1864 n816 n971 221.966a
Cext_1865 n816 n973 42.8588a
Cext_1866 n816 n974 6.5232a
Cext_1867 n816 n975 0.308401a
Cext_1868 n816 n976 3.56142a
Cext_1869 n816 n996 4.7764a
Cext_1870 n816 AVSS 531.459a
Cext_1871 n816 VGND 281.822a
Cext_1872 n816 VPWR 635.092a
Cext_1873 n816 AVSS 1.56963f
Cext_1874 n818 n819 197.997a
Cext_1875 n818 n820 3.08894a
Cext_1876 n818 n821 3.12018a
Cext_1877 n818 n822 6.81283a
Cext_1878 n818 n824 0.408184a
Cext_1879 n818 n825 14.848a
Cext_1880 n818 n826 49.1747a
Cext_1881 n818 n828 136.978a
Cext_1882 n818 n833 19.2265a
Cext_1883 n818 n835 146.687a
Cext_1884 n818 n836 196.489a
Cext_1885 n818 n837 40.6291a
Cext_1886 n818 n839 78.4201a
Cext_1887 n818 n840 0.611041a
Cext_1888 n818 n842 1.43811a
Cext_1889 n818 n843 0.975416a
Cext_1890 n818 n845 85.6269a
Cext_1891 n818 n846 124.178a
Cext_1892 n818 n928 797.935a
Cext_1893 n818 n932 30.6284a
Cext_1894 n818 n938 4.62458a
Cext_1895 n818 n940 0.117389a
Cext_1896 n818 n961 147.005a
Cext_1897 n818 n963 52.5164a
Cext_1898 n818 n965 177.02a
Cext_1899 n818 n967 2.82791a
Cext_1900 n818 n971 0.373313a
Cext_1901 n818 n982 0.316214a
Cext_1902 n818 n984 0.596798a
Cext_1903 n818 AVSS 263.618a
Cext_1904 n818 gain_sel[2] 38.8021a
Cext_1905 n818 gain_sel[3] 9.30361a
Cext_1906 n818 VGND 1.10682f
Cext_1907 n818 VPWR 948.206a
Cext_1908 n818 AVSS 2.76855f
Cext_1909 n819 n820 114.645a
Cext_1910 n819 n821 6.57509a
Cext_1911 n819 n822 84.1487a
Cext_1912 n819 n824 0.661307a
Cext_1913 n819 n825 0.151742a
Cext_1914 n819 n837 1.00947f
Cext_1915 n819 n839 150.817a
Cext_1916 n819 n840 75.0047a
Cext_1917 n819 n842 361.389a
Cext_1918 n819 n843 210.84a
Cext_1919 n819 n928 8.46729a
Cext_1920 n819 n932 93.9548a
Cext_1921 n819 n938 590.814a
Cext_1922 n819 n965 22.383a
Cext_1923 n819 n967 14.0735a
Cext_1924 n819 n968 1.55621a
Cext_1925 n819 n969 2.66697a
Cext_1926 n819 n971 162.721a
Cext_1927 n819 n973 4.58687a
Cext_1928 n819 AVSS 12.7397a
Cext_1929 n819 VGND 343.182a
Cext_1930 n819 VPWR 251.679a
Cext_1931 n819 AVSS 1.09542f
Cext_1932 n820 n821 7.11821a
Cext_1933 n820 n822 5.04893a
Cext_1934 n820 n837 123.683a
Cext_1935 n820 n840 178.803a
Cext_1936 n820 n842 1.05323a
Cext_1937 n820 n843 3.72131a
Cext_1938 n820 n938 19.4199a
Cext_1939 n820 n965 6.4886a
Cext_1940 n820 n968 2.35708a
Cext_1941 n820 AVSS 4.05882a
Cext_1942 n820 VGND 313.352a
Cext_1943 n820 VPWR 159.266a
Cext_1944 n820 AVSS 415.677a
Cext_1945 n821 n837 36.8249a
Cext_1946 n821 n840 71.4513a
Cext_1947 n821 VPWR 146.443a
Cext_1948 n821 AVSS 35.3152a
Cext_1949 n822 n824 0.369934a
Cext_1950 n822 n825 0.328105a
Cext_1951 n822 n826 424.863a
Cext_1952 n822 n837 75.4739a
Cext_1953 n822 n840 39.5094a
Cext_1954 n822 n842 22.7826a
Cext_1955 n822 n843 0.268112a
Cext_1956 n822 n932 22.9132a
Cext_1957 n822 n938 412.044a
Cext_1958 n822 n965 110.444a
Cext_1959 n822 n967 125.675a
Cext_1960 n822 n968 27.1548a
Cext_1961 n822 n969 0.795022a
Cext_1962 n822 n971 476.304a
Cext_1963 n822 n974 0.118196a
Cext_1964 n822 n975 0.19333a
Cext_1965 n822 n976 2.20688a
Cext_1966 n822 n977 2.29048a
Cext_1967 n822 n979 4.58095a
Cext_1968 n822 n980 18.9116a
Cext_1969 n822 n981 28.775a
Cext_1970 n822 n982 202.583a
Cext_1971 n822 n983 9.78484a
Cext_1972 n822 n984 2.00453a
Cext_1973 n822 n985 0.757847a
Cext_1974 n822 n987 0.134194a
Cext_1975 n822 n996 24.2716a
Cext_1976 n822 AVSS 30.5198a
Cext_1977 n822 VGND 326.923a
Cext_1978 n822 VPWR 235.05a
Cext_1979 n822 AVSS 727.273a
Cext_1980 n824 n825 2.05145a
Cext_1981 n824 n842 18.6136a
Cext_1982 n824 n932 7.68416a
Cext_1983 n824 n938 1.68072a
Cext_1984 n824 n968 0.882311a
Cext_1985 n824 n996 0.14133a
Cext_1986 n824 AVSS 0.423662a
Cext_1987 n824 VGND 53.5387a
Cext_1988 n824 VPWR 92.274a
Cext_1989 n824 AVSS 300.589a
Cext_1990 n825 n826 162.294a
Cext_1991 n825 n842 189.041a
Cext_1992 n825 n932 8.30537a
Cext_1993 n825 n938 2.00536a
Cext_1994 n825 n967 0.944707a
Cext_1995 n825 AVSS 0.944222a
Cext_1996 n825 VGND 54.7935a
Cext_1997 n825 VPWR 68.6305a
Cext_1998 n825 AVSS 302.166a
Cext_1999 n826 n842 23.6383a
Cext_2000 n826 n845 2.19625a
Cext_2001 n826 n932 137.016a
Cext_2002 n826 n938 105.724a
Cext_2003 n826 n971 158.046a
Cext_2004 n826 n976 161.48a
Cext_2005 n826 n977 4.14513a
Cext_2006 n826 n979 192.476a
Cext_2007 n826 n980 1.02794a
Cext_2008 n826 n981 0.972032a
Cext_2009 n826 n982 1.70331a
Cext_2010 n826 n983 2.52804a
Cext_2011 n826 n984 1.93813a
Cext_2012 n826 n985 2.418a
Cext_2013 n826 n986 2.83426a
Cext_2014 n826 n987 4.412a
Cext_2015 n826 n996 1.94594f
Cext_2016 n826 AVDD 679.738a
Cext_2017 n826 AVSS 949.461a
Cext_2018 n826 IBIAS_IA 59.095a
Cext_2019 n826 VCM 59.9908a
Cext_2020 n826 VGND 272.571a
Cext_2021 n826 VPWR 205.541a
Cext_2022 n826 AVSS 20.0948f
Cext_2023 n828 n845 21.5849a
Cext_2024 n828 n846 1.42596a
Cext_2025 n828 n932 3.73024a
Cext_2026 n828 n983 0.280775a
Cext_2027 n828 AVSS 1.11852a
Cext_2028 n828 VGND 22.1408a
Cext_2029 n828 VPWR 152.782a
Cext_2030 n828 AVSS 286.791a
Cext_2031 n833 n928 5.94311a
Cext_2032 n833 AVSS 1.65048a
Cext_2033 n833 VGND 64.7131a
Cext_2034 n833 VPWR 76.77a
Cext_2035 n833 AVSS 265.039a
Cext_2036 n835 n836 2.35944a
Cext_2037 n835 n837 0.154169a
Cext_2038 n835 n928 199.481a
Cext_2039 n835 AVSS 1.48291a
Cext_2040 n835 VGND 63.5787a
Cext_2041 n835 VPWR 99.6136a
Cext_2042 n835 AVSS 328.964a
Cext_2043 n836 n837 150.263a
Cext_2044 n836 n928 85.0991a
Cext_2045 n836 AVSS 0.887162a
Cext_2046 n836 VGND 57.4623a
Cext_2047 n836 VPWR 58.1676a
Cext_2048 n836 AVSS 257.97a
Cext_2049 n837 n839 19.7045a
Cext_2050 n837 n840 147.882a
Cext_2051 n837 n842 381.447a
Cext_2052 n837 n843 42.1718a
Cext_2053 n837 n928 304.286a
Cext_2054 n837 n938 44.3789a
Cext_2055 n837 n940 8.03538a
Cext_2056 n837 n965 41.1019a
Cext_2057 n837 n967 1.54366a
Cext_2058 n837 n969 2.0654a
Cext_2059 n837 AVSS 12.0772a
Cext_2060 n837 VGND 301.088a
Cext_2061 n837 VPWR 317.1a
Cext_2062 n837 AVSS 1.16874f
Cext_2063 n839 n928 187.717a
Cext_2064 n839 n940 6.3532a
Cext_2065 n839 n965 1.54568a
Cext_2066 n839 AVSS 0.815486a
Cext_2067 n839 VGND 61.2212a
Cext_2068 n839 VPWR 58.1796a
Cext_2069 n839 AVSS 267.73a
Cext_2070 n840 n842 27.7501a
Cext_2071 n840 n932 2.21369a
Cext_2072 n840 n938 190.691a
Cext_2073 n840 n965 8.98931a
Cext_2074 n840 n967 73.6778a
Cext_2075 n840 n968 2.51011a
Cext_2076 n840 n969 18.531a
Cext_2077 n840 n971 369.283a
Cext_2078 n840 n973 193.245a
Cext_2079 n840 n974 0.141228a
Cext_2080 n840 n976 0.134194a
Cext_2081 n840 n996 0.290471a
Cext_2082 n840 AVSS 10.5592a
Cext_2083 n840 VGND 76.6782a
Cext_2084 n840 VPWR 25.7929a
Cext_2085 n840 AVSS 318.872a
Cext_2086 n842 n843 14.2517a
Cext_2087 n842 n845 0.165648a
Cext_2088 n842 n932 124.3a
Cext_2089 n842 n938 117.146a
Cext_2090 n842 n967 5.38179a
Cext_2091 n842 n968 3.75784a
Cext_2092 n842 n969 15.1306a
Cext_2093 n842 n971 98.3031a
Cext_2094 n842 AVSS 8.10137a
Cext_2095 n842 VGND 151.151a
Cext_2096 n842 VPWR 123.992a
Cext_2097 n842 AVSS 366.254a
Cext_2098 n843 n938 170.753a
Cext_2099 n843 n971 0.342958a
Cext_2100 n843 AVSS 0.120627a
Cext_2101 n843 VGND 62.2517a
Cext_2102 n843 VPWR 107.653a
Cext_2103 n843 AVSS 329.749a
Cext_2104 n845 n932 9.71115a
Cext_2105 n845 n938 1.65665a
Cext_2106 n845 n980 0.237849a
Cext_2107 n845 AVSS 1.63714a
Cext_2108 n845 VGND 58.1287a
Cext_2109 n845 VPWR 68.7431a
Cext_2110 n845 AVSS 258.097a
Cext_2111 n846 n932 9.21782a
Cext_2112 n846 n941 10.5218a
Cext_2113 n846 n971 2.40151a
Cext_2114 n846 AVSS 1.15238a
Cext_2115 n846 VGND 51.593a
Cext_2116 n846 VPWR 75.8431a
Cext_2117 n846 AVSS 334.974a
Cext_2118 n847 AVDD 499.805a
Cext_2119 n847 VCM 80.5638a
Cext_2120 n847 VINN 47.6051a
Cext_2121 n847 AVSS 1.21904f
Cext_2122 n928 n939 2.50875a
Cext_2123 n928 n940 30.7164a
Cext_2124 n928 n963 146.978a
Cext_2125 n928 n965 0.424555a
Cext_2126 n928 AVSS 23.7777a
Cext_2127 n928 gain_sel[2] 9.06283a
Cext_2128 n928 VGND 860.643a
Cext_2129 n928 VPWR 380.334a
Cext_2130 n928 AVSS 1.47599f
Cext_2131 n93 AVDD 276.26a
Cext_2132 n93 AVSS 1.63266f
Cext_2133 n93 VCM 481.14a
Cext_2134 n93 AVSS 3.5021f
Cext_2135 n932 n938 775.217a
Cext_2136 n932 n941 8.02584a
Cext_2137 n932 n967 4.13932a
Cext_2138 n932 n968 4.1643a
Cext_2139 n932 n969 22.1692a
Cext_2140 n932 n971 31.0839a
Cext_2141 n932 n973 145.414a
Cext_2142 n932 n974 43.6517a
Cext_2143 n932 n996 1.29474a
Cext_2144 n932 AVSS 13.7462a
Cext_2145 n932 VGND 143.23a
Cext_2146 n932 VPWR 35.4171a
Cext_2147 n932 AVSS 326.709a
Cext_2148 n938 n965 0.139248a
Cext_2149 n938 n967 34.9559a
Cext_2150 n938 n968 3.50997a
Cext_2151 n938 n969 90.0446a
Cext_2152 n938 n971 58.7607a
Cext_2153 n938 n975 0.391835a
Cext_2154 n938 n976 0.676677a
Cext_2155 n938 n977 18.7235a
Cext_2156 n938 n979 25.4155a
Cext_2157 n938 n980 204.068a
Cext_2158 n938 n981 9.78143a
Cext_2159 n938 n982 0.165589a
Cext_2160 n938 n996 23.6091a
Cext_2161 n938 AVSS 18.5202a
Cext_2162 n938 VGND 261.224a
Cext_2163 n938 VPWR 189.243a
Cext_2164 n938 AVSS 761.558a
Cext_2165 n939 AVSS 0.346812a
Cext_2166 n939 VGND 24.8165a
Cext_2167 n939 VPWR 38.2576a
Cext_2168 n939 AVSS 207.382a
Cext_2169 n940 AVSS 0.336888a
Cext_2170 n940 VGND 2.65341a
Cext_2171 n940 VPWR 2.56925a
Cext_2172 n940 AVSS 114.831a
Cext_2173 n941 n971 11.8425a
Cext_2174 n941 n986 0.2202a
Cext_2175 n941 n987 1.4613a
Cext_2176 n941 AVSS 3.15763a
Cext_2177 n941 VGND 7.13979a
Cext_2178 n941 VPWR 8.89597a
Cext_2179 n941 AVSS 235.802a
Cext_2180 n96 n97 15.0233a
Cext_2181 n96 n98 3.90042f
Cext_2182 n96 AVDD 328.698a
Cext_2183 n96 AVSS 10.5289f
Cext_2184 n96 VINP 33.3628a
Cext_2185 n96 AVSS 15.2394f
Cext_2186 n961 n963 2.61323a
Cext_2187 n961 AVSS 14.6112a
Cext_2188 n961 gain_sel[2] 21.616a
Cext_2189 n961 gain_sel[3] 200.283a
Cext_2190 n961 VGND 60.4825a
Cext_2191 n961 VPWR 70.3505a
Cext_2192 n961 AVSS 353.513a
Cext_2193 n963 AVSS 8.56725a
Cext_2194 n963 gain_sel[2] 201.928a
Cext_2195 n963 gain_sel[3] 0.768034a
Cext_2196 n963 VGND 69.778a
Cext_2197 n963 VPWR 77.9894a
Cext_2198 n963 AVSS 308.313a
Cext_2199 n965 n967 35.3051a
Cext_2200 n965 n968 0.542189a
Cext_2201 n965 n969 0.290079a
Cext_2202 n965 AVSS 25.2369a
Cext_2203 n965 VGND 186.356a
Cext_2204 n965 VPWR 185.711a
Cext_2205 n965 AVSS 453.687a
Cext_2206 n967 n968 108.059a
Cext_2207 n967 n969 841.697a
Cext_2208 n967 n971 998.206a
Cext_2209 n967 n973 3.66053a
Cext_2210 n967 n974 7.10874a
Cext_2211 n967 n975 21.3638a
Cext_2212 n967 n976 21.8873a
Cext_2213 n967 n977 190.193a
Cext_2214 n967 n979 5.13331a
Cext_2215 n967 n980 0.389358a
Cext_2216 n967 n981 0.186a
Cext_2217 n967 n982 0.17342a
Cext_2218 n967 n996 323.009a
Cext_2219 n967 AVSS 41.1465a
Cext_2220 n967 VGND 71.8417a
Cext_2221 n967 VPWR 103.665a
Cext_2222 n967 AVSS 389.05a
Cext_2223 n968 n969 822.563a
Cext_2224 n968 n971 7.77355a
Cext_2225 n968 n973 5.5981a
Cext_2226 n968 n974 21.4662a
Cext_2227 n968 n975 192.734a
Cext_2228 n968 n976 6.04292a
Cext_2229 n968 n977 2.07011a
Cext_2230 n968 n979 0.488725a
Cext_2231 n968 n980 0.627481a
Cext_2232 n968 n981 0.111258a
Cext_2233 n968 n982 0.213705a
Cext_2234 n968 n996 178.206a
Cext_2235 n968 AVSS 74.1706a
Cext_2236 n968 VGND 76.849a
Cext_2237 n968 VPWR 125.591a
Cext_2238 n968 AVSS 351.806a
Cext_2239 n969 n971 12.5231a
Cext_2240 n969 n973 15.7743a
Cext_2241 n969 n974 188.59a
Cext_2242 n969 n975 0.257136a
Cext_2243 n969 n976 0.109658a
Cext_2244 n969 n996 16.7434a
Cext_2245 n969 AVSS 22.1301a
Cext_2246 n969 VGND 76.3844a
Cext_2247 n969 VPWR 113.259a
Cext_2248 n969 AVSS 347.162a
Cext_2249 n97 n98 821.414a
Cext_2250 n97 AVDD 5.27408a
Cext_2251 n97 AVSS 4.03283f
Cext_2252 n97 VINP 356.728a
Cext_2253 n97 AVSS 18.0703f
Cext_2254 n971 n973 6.89144a
Cext_2255 n971 n974 6.31166a
Cext_2256 n971 n975 6.34349a
Cext_2257 n971 n976 5.18365a
Cext_2258 n971 n977 7.64423a
Cext_2259 n971 n979 4.8691a
Cext_2260 n971 n980 6.66644a
Cext_2261 n971 n981 4.94822a
Cext_2262 n971 n982 6.93479a
Cext_2263 n971 n983 6.33644a
Cext_2264 n971 n984 7.91805a
Cext_2265 n971 n985 5.71892a
Cext_2266 n971 n986 17.5488a
Cext_2267 n971 n987 10.5355a
Cext_2268 n971 n996 266.413a
Cext_2269 n971 AVSS 42.4571a
Cext_2270 n971 VGND 179.913a
Cext_2271 n971 VPWR 293.066a
Cext_2272 n971 AVSS 798.002a
Cext_2273 n973 n974 2.58586a
Cext_2274 n973 n996 0.27863a
Cext_2275 n973 AVSS 2.83804a
Cext_2276 n973 VGND 58.0217a
Cext_2277 n973 VPWR 81.1641a
Cext_2278 n973 AVSS 314.965a
Cext_2279 n974 n975 2.58586a
Cext_2280 n974 n976 0.244568a
Cext_2281 n974 n996 153.043a
Cext_2282 n974 AVSS 4.27771a
Cext_2283 n974 VGND 53.8974a
Cext_2284 n974 VPWR 68.6338a
Cext_2285 n974 AVSS 305.217a
Cext_2286 n975 n976 147.104a
Cext_2287 n975 n977 2.58586a
Cext_2288 n975 n996 48.6631a
Cext_2289 n975 AVSS 4.36783a
Cext_2290 n975 VGND 53.9527a
Cext_2291 n975 VPWR 68.7498a
Cext_2292 n975 AVSS 305.784a
Cext_2293 n976 n977 46.4044a
Cext_2294 n976 n979 247.962a
Cext_2295 n976 n980 0.663514a
Cext_2296 n976 n981 28.0433a
Cext_2297 n976 n982 0.472741a
Cext_2298 n976 n983 28.0433a
Cext_2299 n976 n984 2.183a
Cext_2300 n976 n985 27.2365a
Cext_2301 n976 n986 3.86293a
Cext_2302 n976 n987 25.1403a
Cext_2303 n976 n996 10.7788f
Cext_2304 n976 AVDD 303.297a
Cext_2305 n976 AVSS 1.24067f
Cext_2306 n976 IBIAS_IA 52.7428a
Cext_2307 n976 VCM 53.4518a
Cext_2308 n976 VGND 91.0989a
Cext_2309 n976 VPWR 204.117a
Cext_2310 n976 AVSS 9.43124f
Cext_2311 n977 n979 147.406a
Cext_2312 n977 n980 2.3169a
Cext_2313 n977 n996 7.80079a
Cext_2314 n977 AVSS 5.64364a
Cext_2315 n977 VGND 53.8621a
Cext_2316 n977 VPWR 68.7498a
Cext_2317 n977 AVSS 306.314a
Cext_2318 n979 n980 45.896a
Cext_2319 n979 n981 124.541a
Cext_2320 n979 n983 32.26a
Cext_2321 n979 n985 32.26a
Cext_2322 n979 n987 26.6799a
Cext_2323 n979 n996 172.999a
Cext_2324 n979 AVDD 347.759a
Cext_2325 n979 AVSS 1.30053f
Cext_2326 n979 IBIAS_IA 56.6665a
Cext_2327 n979 VCM 57.4909a
Cext_2328 n979 VGND 108.01a
Cext_2329 n979 VPWR 149.061a
Cext_2330 n979 AVSS 19.3232f
Cext_2331 n98 AVDD 7.75179a
Cext_2332 n98 AVSS 2.4148f
Cext_2333 n98 VINP 2.01243f
Cext_2334 n98 AVSS 13.0574f
Cext_2335 n980 n981 147.672a
Cext_2336 n980 n982 2.3169a
Cext_2337 n980 n996 7.80006a
Cext_2338 n980 AVSS 5.66011a
Cext_2339 n980 VGND 54.2882a
Cext_2340 n980 VPWR 68.9284a
Cext_2341 n980 AVSS 305.736a
Cext_2342 n981 n982 45.896a
Cext_2343 n981 n983 135.683a
Cext_2344 n981 n985 143.197a
Cext_2345 n981 n987 32.143a
Cext_2346 n981 n996 7.00793a
Cext_2347 n981 AVSS 82.5706a
Cext_2348 n981 VGND 58.1345a
Cext_2349 n981 VPWR 93.2168a
Cext_2350 n981 AVSS 789.652a
Cext_2351 n982 n983 147.914a
Cext_2352 n982 n984 2.3169a
Cext_2353 n982 n996 7.64616a
Cext_2354 n982 AVSS 5.71687a
Cext_2355 n982 VGND 54.2487a
Cext_2356 n982 VPWR 68.9284a
Cext_2357 n982 AVSS 304.25a
Cext_2358 n983 n984 44.9268a
Cext_2359 n983 n985 124.123a
Cext_2360 n983 n987 97.1168a
Cext_2361 n983 n996 6.99476a
Cext_2362 n983 AVSS 67.7073a
Cext_2363 n983 VGND 58.5346a
Cext_2364 n983 VPWR 92.1446a
Cext_2365 n983 AVSS 1.17138f
Cext_2366 n984 n985 146.75a
Cext_2367 n984 n986 2.55868a
Cext_2368 n984 n996 7.58216a
Cext_2369 n984 AVSS 5.68909a
Cext_2370 n984 VGND 54.4619a
Cext_2371 n984 VPWR 68.9284a
Cext_2372 n984 AVSS 305.459a
Cext_2373 n985 n986 43.082a
Cext_2374 n985 n987 199.5a
Cext_2375 n985 n996 9.62414a
Cext_2376 n985 AVSS 60.7039a
Cext_2377 n985 VGND 58.0907a
Cext_2378 n985 VPWR 78.9454a
Cext_2379 n985 AVSS 582.791a
Cext_2380 n986 n987 148.266a
Cext_2381 n986 n996 11.2239a
Cext_2382 n986 AVSS 9.79953a
Cext_2383 n986 VGND 54.0088a
Cext_2384 n986 VPWR 68.7498a
Cext_2385 n986 AVSS 338.61a
Cext_2386 n987 n996 15.0827a
Cext_2387 n987 AVSS 53.7412a
Cext_2388 n987 VGND 56.4336a
Cext_2389 n987 VPWR 76.4828a
Cext_2390 n987 AVSS 718.558a
Cext_2391 n996 AVDD 366.881a
Cext_2392 n996 AVSS 1.04569f
Cext_2393 n996 IBIAS_IA 55.1713a
Cext_2394 n996 VCM 55.9518a
Cext_2395 n996 VGND 94.7399a
Cext_2396 n996 VPWR 83.9433a
Cext_2397 n996 AVSS 13.5693f
Cext_2398 AVDD AVSS 50.1074f
Cext_2399 AVDD IBIAS_IA 316.232a
Cext_2400 AVDD VCM 6.61235f
Cext_2401 AVDD VINN 796.194a
Cext_2402 AVDD VINP 636.46a
Cext_2403 AVDD VOUT 933.087a
Cext_2404 AVDD AVSS 340.524f
Cext_2405 AVSS gain_sel[1] 9.35315a
Cext_2406 AVSS gain_sel[2] 888.381a
Cext_2407 AVSS gain_sel[3] 397.349a
Cext_2408 AVSS IBIAS_IA 9.83416f
Cext_2409 AVSS VCM 8.33721f
Cext_2410 AVSS VGND 1.9267f
Cext_2411 AVSS VINN 6.53905a
Cext_2412 AVSS VINP 6.53905a
Cext_2413 AVSS VOUT 30.1221f
Cext_2414 AVSS VPWR 1.28516f
Cext_2415 AVSS AVSS 380.413f
Cext_2416 gain_sel[0] gain_sel[1] 1.33438f
Cext_2417 gain_sel[0] gain_sel[2] 0.566271a
Cext_2418 gain_sel[1] gain_sel[2] 980.731a
Cext_2419 gain_sel[1] gain_sel[3] 0.671553a
Cext_2420 gain_sel[2] gain_sel[3] 781.966a
Cext_2421 IBIAS_IA gain_sel[3] 5.29963a
Cext_2422 IBIAS_IA VCM 2.88053f
Cext_2423 IBIAS_IA AVSS 63.061f
Cext_2424 VCM gain_sel[3] 4.00342a
Cext_2425 VCM VINN 137.232a
Cext_2426 VCM VINP 1.98829a
Cext_2427 VCM AVSS 59.9164f
Cext_2428 VGND gain_sel[0] 243.182a
Cext_2429 VGND gain_sel[1] 473.663a
Cext_2430 VGND gain_sel[2] 410.836a
Cext_2431 VGND gain_sel[3] 296.797a
Cext_2432 VGND VPWR 15.9168f
Cext_2433 VGND AVSS 39.9428f
Cext_2434 VINN AVSS 17.192f
Cext_2435 VINP AVSS 17.1148f
Cext_2436 VOUT AVSS 23.9205f
Cext_2437 VPWR gain_sel[0] 702.137a
Cext_2438 VPWR gain_sel[1] 166.56a
Cext_2439 VPWR gain_sel[2] 166.119a
Cext_2440 VPWR gain_sel[3] 126.675a
Cext_2441 VPWR AVSS 43.3114f
Cext_2442 AVSS gain_sel[0] 3.46207f
Cext_2443 AVSS gain_sel[1] 1.6829f
Cext_2444 AVSS gain_sel[2] 2.22346f
Cext_2445 AVSS gain_sel[3] 3.97634f
Rfl_n1001 n1001 AVSS 1T
Rfl_n1002 n1002 AVSS 1T
Rfl_n1004 n1004 AVSS 1T
Rfl_n1005 n1005 AVSS 1T
Rfl_n715 n715 AVSS 1T
Rfl_n716 n716 AVSS 1T
Rfl_n717 n717 AVSS 1T
Rfl_n939 n939 AVSS 1T
Rfl_n940 n940 AVSS 1T
Rfl_n941 n941 AVSS 1T
.ends pgia_top
