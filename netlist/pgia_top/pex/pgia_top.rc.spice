** post-layout RC netlist of pgia_top: Magic extresist -> ngspice by scripts/pex_netlist.py --magic (source: /foss/designs/sg13cmos5l_spma_ip__instramp/runs/pex/pgia_top/magic/raw.spice)
.subckt pgia_top VINP VINN VCM gain_sel[0] gain_sel[1] gain_sel[2] gain_sel[3] VOUT AVDD VPWR IBIAS_IA AVSS VGND
X0 pn156_t6 pn84_t0 AVDD_t13 AVDD_t11 sg13_lv_pmos ad=0.68p pd=4.68u as=0.68p ps=4.68u w=2u l=2u
X1 pn84 IBIAS_IA_t0 VGND VGND sg13_lv_nmos ad=0.34p pd=2.68u as=0.34p ps=2.68u w=1u l=2u
X2 pn14_t0 pn30_t1 VPWR_t43 VPWR_t29 sg13_lv_pmos ad=0.42p pd=2.99u as=0.2114p ps=1.54u w=1.12u l=0.13u
X3 AVDD_t227 pn160_t1 pn160_t2 AVDD_t97 sg13_lv_pmos ad=0.782p pd=5.28u as=0.782p ps=5.28u w=2.3u l=2u
X4 VGND_t45 pn121_t2 pn30 VGND_t44 sg13_lv_nmos ad=0.14875p pd=1.16u as=0.187p ps=1.78u w=0.55u l=0.13u
X5 pn18 pn186_t2 VGND_t111 VGND_t110 sg13_lv_nmos ad=0.2516p pd=2.16u as=0.2516p ps=2.16u w=0.74u l=0.13u
X6 pn160_t0 pn156_t13 VGND VGND sg13_lv_nmos ad=0.2958p pd=2.42u as=0.2958p ps=2.42u w=0.87u l=2u
X7 VGND_t333 VPWR_t164 VGND_t332 VGND_t331 sg13_lv_nmos ad=0.1428p pd=1.52u as=0 ps=0 w=0.42u l=1u
X8 pn20 pn35_t2 VGND_t321 VGND_t320 sg13_lv_nmos ad=0.1406p pd=1.12u as=0.2516p ps=2.16u w=0.74u l=0.13u
X9 pn122_t1 pn35_t5 VPWR_t110 VPWR_t29 sg13_lv_pmos ad=0.2856p pd=2.36u as=0.2618p ps=1.63u w=0.84u l=0.13u
X10 pn84_t18 IBIAS_IA_t6 VGND VGND sg13_lv_nmos ad=0.34p pd=2.68u as=0.34p ps=2.68u w=1u l=2u
X11 pn100 pn96 VGND rhigh l=2u w=0.5u ps=0 b=0 m=1
X12 VGND_t389 VPWR_t152 VGND_t391 VGND_t390 sg13_lv_nmos ad=79.8f pd=0.8u as=0 ps=0 w=0.42u l=1u
X13 pn110_t3 pn82_t34 AVDD_t167 AVDD_t61 sg13_lv_pmos ad=0.1005p pd=1.34u as=0.3345p ps=2.9u w=0.15u l=0.15u
X14 pn110_t1 pn82_t34 AVDD_t163 AVDD_t61 sg13_lv_pmos ad=0.1005p pd=1.34u as=0.3345p ps=2.9u w=0.15u l=0.15u
X15 VPWR_t45 pn64_t1 pn70_t0 VPWR_t5 sg13_lv_pmos ad=0.2114p pd=1.54u as=0.2856p ps=2.36u w=0.84u l=0.13u
X16 pn118_t0 pn50_t5 VGND_t419 VGND_t418 sg13_lv_nmos ad=0.1406p pd=1.12u as=0.2516p ps=2.16u w=0.74u l=0.13u
X17 VPWR_t18 VGND_t558 VPWR_t17 VPWR_t5 sg13_lv_pmos ad=0.34p pd=2.68u as=0 ps=0 w=1u l=1u
X18 pn82_t25 IBIAS_IA_t6 VGND VGND sg13_lv_nmos ad=0.34p pd=2.68u as=0.34p ps=2.68u w=1u l=2u
X19 pn217 pn9_t3 pn145_t2 AVDD_t72 sg13_lv_pmos ad=0.2128p pd=1.5u as=0.3808p ps=2.92u w=1.12u l=0.13u
X20 pn153_t1 pn153 pn85 VGND sg13_lv_nmos ad=0.544p pd=3.88u as=0.544p ps=3.88u w=1.6u l=2u
X21 VPWR_t53 pn5_t3 pn186 VPWR_t0 sg13_lv_pmos ad=0.2128p pd=1.5u as=0.3808p ps=2.92u w=1.12u l=0.13u
X22 pn35_t0 pn51_t5 pn191 VPWR_t0 sg13_lv_pmos ad=0.3808p pd=2.92u as=0.2128p ps=1.5u w=1.12u l=0.13u
X23 AVDD_t123 pn10_t3 pn216 AVDD_t57 sg13_lv_pmos ad=0.4032p pd=2.96u as=0.1176p ps=1.33u w=1.12u l=0.13u
X24 VPWR_t82 pn5_t1 pn181 VPWR_t0 sg13_lv_pmos ad=0.3808p pd=2.92u as=0.2128p ps=1.5u w=1.12u l=0.13u
X25 pn104_t0 pn106 pn176_t0 VGND sg13_lv_nmos ad=0.2856p pd=2.36u as=0.2856p ps=2.36u w=0.84u l=0.5u
X26 VPWR_t66 pn51_t2 pn206 VPWR_t29 sg13_lv_pmos ad=0.2618p pd=1.63u as=0.2856p ps=2.36u w=0.84u l=0.13u
X27 AVDD_t106 pn227_t12 pn227_t13 AVDD_t105 sg13_lv_pmos ad=2.5364p pd=15.6u as=2.5364p ps=15.6u w=7.46u l=2u
X28 pn220_t0 pn84_t0 AVDD_t23 AVDD_t22 sg13_lv_pmos ad=0.68p pd=4.68u as=0.68p ps=4.68u w=2u l=2u
X29 VGND_t529 pn130 pn62 VGND_t528 sg13_lv_nmos ad=0.2516p pd=2.16u as=0.2516p ps=2.16u w=0.74u l=0.13u
X30 pn169_t1 pn168_t2 AVDD_t5 AVDD_t4 sg13_lv_pmos ad=0.3808p pd=2.92u as=0.3808p ps=2.92u w=1.12u l=0.13u
X31 pn82_t1 IBIAS_IA_t0 VGND VGND sg13_lv_nmos ad=0.34p pd=2.68u as=0.34p ps=2.68u w=1u l=2u
X32 AVDD_t184 pn82_t32 pn82_t33 AVDD_t62 sg13_lv_pmos ad=0.3345p pd=2.9u as=0.1005p ps=1.34u w=0.15u l=0.15u
X33 pn178_t11 pn114_t18 AVDD_t199 AVDD_t198 sg13_lv_pmos ad=2.5364p pd=15.6u as=2.5364p ps=15.6u w=7.46u l=2u
X34 pn229_t1 pn87_t3 pn228_t5 AVDD_t63 sg13_lv_pmos ad=0.95p pd=5.38u as=0.95p ps=5.38u w=5u l=3u
X35 VGND_t338 VPWR_t163 VGND_t340 VGND_t339 sg13_lv_nmos ad=79.8f pd=0.8u as=0 ps=0 w=0.42u l=1u
X36 VPWR_t23 VGND_t538 VPWR_t90 VPWR_t0 sg13_lv_pmos ad=0.19p pd=1.38u as=0 ps=0 w=1u l=1u
X37 AVDD_t118 pn227_t17 pn221_t6 AVDD_t114 sg13_lv_pmos ad=2.5364p pd=15.6u as=2.5364p ps=15.6u w=7.46u l=2u
X38 pn110_t9 pn127 VGND VGND sg13_lv_nmos ad=0.95p pd=5.38u as=0.95p ps=5.38u w=5u l=3u
X39 pn114_t4 pn114_t3 AVDD_t213 AVDD_t212 sg13_lv_pmos ad=2.5364p pd=15.6u as=2.5364p ps=15.6u w=7.46u l=2u
X40 VPWR_t39 pn184_t1 pn27_t0 VPWR_t29 sg13_lv_pmos ad=0.2114p pd=1.54u as=0.2856p ps=2.36u w=0.84u l=0.13u
X41 pn200_t0 pn199_t1 VGND_t128 VGND_t531 sg13_lv_nmos ad=0.2886p pd=2.26u as=0.14875p ps=1.16u w=0.74u l=0.13u
X42 pn45 pn42_t1 VGND_t404 VGND_t403 sg13_lv_nmos ad=0.1406p pd=1.12u as=0.2516p ps=2.16u w=0.74u l=0.13u
X43 pn182_t0 pn50_t1 pn20 VGND_t428 sg13_lv_nmos ad=0.2516p pd=2.16u as=0.1406p ps=1.12u w=0.74u l=0.13u
X44 pn220 pn84_t0 AVDD_t7 AVDD_t6 sg13_lv_pmos ad=0.68p pd=4.68u as=0.68p ps=4.68u w=2u l=2u
X45 pn82_t11 IBIAS_IA_t0 VGND VGND sg13_lv_nmos ad=0.34p pd=2.68u as=0.34p ps=2.68u w=1u l=2u
X46 VPWR_t50 pn60_t1 pn24_t0 VPWR_t29 sg13_lv_pmos ad=0.2114p pd=1.54u as=0.2856p ps=2.36u w=0.84u l=0.13u
X47 pn226_t1 pn161_t12 pn221_t3 AVDD_t3 sg13_lv_pmos ad=1.2616p pd=7.02u as=1.2616p ps=7.02u w=6.64u l=2u
X48 VGND pn149 pn148_t3 VGND sg13_lv_nmos ad=3.6p pd=11.44u as=0.95p ps=5.38u w=5u l=5u
X49 pn162_t2 VOUT_t10 pn228 AVDD_t79 sg13_lv_pmos ad=0.95p pd=5.38u as=1.7p ps=10.68u w=5u l=3u
X50 pn53_t0 pn70_t1 VPWR_t45 VPWR_t5 sg13_lv_pmos ad=0.42p pd=2.99u as=0.2114p ps=1.54u w=1.12u l=0.13u
X51 VGND pn85_t0 VGND rhigh l=15u w=0.5u ps=0 b=0 m=1
X52 pn177_t4 pn82_t34 AVDD_t171 AVDD_t61 sg13_lv_pmos ad=0.1005p pd=1.34u as=0.3345p ps=2.9u w=0.15u l=0.15u
X53 pn220_t5 pn84_t2 AVDD_t29 AVDD_t11 sg13_lv_pmos ad=0.68p pd=4.68u as=0.68p ps=4.68u w=2u l=2u
X54 pn82_t22 IBIAS_IA_t6 VGND VGND sg13_lv_nmos ad=0.34p pd=2.68u as=0.34p ps=2.68u w=1u l=2u
X55 pn133_t1 pn38_t3 VPWR_t76 VPWR_t5 sg13_lv_pmos ad=0.2128p pd=1.5u as=0.3808p ps=2.92u w=1.12u l=0.13u
X56 VGND_t50 pn64_t1 pn70 VGND_t49 sg13_lv_nmos ad=0.14875p pd=1.16u as=0.187p ps=1.78u w=0.55u l=0.13u
X57 pn194_t0 pn204_t1 pn40 VGND_t57 sg13_lv_nmos ad=0.333p pd=2.38u as=0.1406p ps=1.12u w=0.74u l=0.13u
X58 pn141_t0 pn10_t2 pn212_t0 VGND sg13_lv_nmos ad=0.1026p pd=1.34u as=0.1026p ps=1.34u w=0.18u l=0.13u
X59 pn219_t8 pn151 pn149_t0 AVDD_t71 sg13_lv_pmos ad=1.7p pd=10.68u as=0.95p ps=5.38u w=5u l=3u
X60 VGND pn129 pn127_t0 VGND sg13_lv_nmos ad=3.6p pd=11.44u as=0.95p ps=5.38u w=5u l=5u
X61 pn213 pn79_t1 pn212_t7 AVDD_t73 sg13_lv_pmos ad=0.1836p pd=1.76u as=0.1836p ps=1.76u w=0.54u l=0.13u
X62 pn211 pn41_t4 VPWR_t33 VPWR_t5 sg13_lv_pmos ad=0.2128p pd=1.5u as=0.3808p ps=2.92u w=1.12u l=0.13u
X63 AVDD_t127 pn109_t6 pn101_t0 AVDD_t125 sg13_lv_pmos ad=1.955p pd=12.18u as=1.0925p ps=6.13u w=5.75u l=2u
X64 pn128_t1 pn140 pn212_t11 AVDD_t142 sg13_lv_pmos ad=0.408p pd=3.08u as=0.408p ps=3.08u w=1.2u l=0.13u
X65 pn47 pn41_t3 VGND_t20 VGND_t19 sg13_lv_nmos ad=0.13875p pd=1.115u as=0.2553p ps=2.17u w=0.74u l=0.13u
X66 AVDD_t226 pn160_t3 pn154_t1 AVDD_t222 sg13_lv_pmos ad=1.0925p pd=6.13u as=1.0925p ps=6.13u w=5.75u l=2u
X67 pn107 pn97_t0 VGND rhigh l=1.95u w=0.5u ps=0 b=0 m=1
X68 pn16 pn32_t1 VGND_t91 VGND_t289 sg13_lv_nmos ad=0.2886p pd=2.26u as=0.14875p ps=1.16u w=0.74u l=0.13u
X69 pn186_t0 pn6_t3 VPWR_t53 VPWR_t0 sg13_lv_pmos ad=0.2128p pd=1.5u as=0.2128p ps=1.5u w=1.12u l=0.13u
X70 IBIAS_IA_t7 IBIAS_IA_t6 VGND VGND sg13_lv_nmos ad=0.34p pd=2.68u as=0.34p ps=2.68u w=1u l=2u
X71 pn9 pn25_t1 VGND_t296 VGND_t301 sg13_lv_nmos ad=0.2886p pd=2.26u as=0.14875p ps=1.16u w=0.74u l=0.13u
X72 VGND_t258 pn181_t1 pn207_t0 VGND_t257 sg13_lv_nmos ad=0.14505p pd=1.15u as=0.187p ps=1.78u w=0.55u l=0.13u
X73 pn83_t7 IBIAS_IA_t6 VGND VGND sg13_lv_nmos ad=0.34p pd=2.68u as=0.34p ps=2.68u w=1u l=2u
X74 VGND_t328 VPWR_t165 VGND_t327 VGND_t326 sg13_lv_nmos ad=0.1428p pd=1.52u as=0 ps=0 w=0.42u l=1u
X75 VPWR_t101 VGND_t544 VPWR_t99 VPWR_t0 sg13_lv_pmos ad=0.19p pd=1.38u as=0 ps=0 w=1u l=1u
X76 AVDD_t39 pn91_t1 pn93_t0 AVDD_t38 sg13_lv_pmos ad=0.1918p pd=1.5u as=0.1596p ps=1.22u w=0.84u l=0.13u
X77 VGND_t366 VPWR_t157 VGND_t368 VGND_t367 sg13_lv_nmos ad=79.8f pd=0.8u as=0 ps=0 w=0.42u l=1u
X78 AVDD_t130 pn109_t4 pn106_t2 AVDD_t129 sg13_lv_pmos ad=1.564p pd=9.88u as=1.564p ps=9.88u w=4.6u l=2u
X79 AVDD_t89 pn83_t10 VOUT_t2 AVDD_t63 sg13_lv_pmos ad=0.3345p pd=2.9u as=0.1005p ps=1.34u w=0.15u l=0.15u
X80 AVDD_t109 pn227_t23 pn221_t0 AVDD_t66 sg13_lv_pmos ad=2.5364p pd=15.6u as=2.5364p ps=15.6u w=7.46u l=2u
X81 pn121_t0 pn42_t1 VPWR_t114 VPWR_t29 sg13_lv_pmos ad=0.2128p pd=1.5u as=0.3808p ps=2.92u w=1.12u l=0.13u
X82 pn232 pn15_t3 AVDD_t43 AVDD_t0 sg13_lv_pmos ad=0.1176p pd=1.33u as=0.4032p ps=2.96u w=1.12u l=0.13u
X83 AVDD_t157 pn82_t36 pn219_t2 AVDD_t71 sg13_lv_pmos ad=0.3345p pd=2.9u as=0.1005p ps=1.34u w=0.15u l=0.15u
X84 pn141_t2 pn142 VGND rhigh l=54u w=0.5u ps=0 b=0 m=1
X85 pn161 pn120_t0 VGND rhigh l=6.66u w=0.5u ps=0 b=0 m=1
X86 pn221_t3 pn161_t12 pn226 AVDD_t3 sg13_lv_pmos ad=1.2616p pd=7.02u as=1.2616p ps=7.02u w=6.64u l=2u
X87 VPWR_t84 pn5_t5 pn210 VPWR_t5 sg13_lv_pmos ad=0.4032p pd=2.96u as=0.1176p ps=1.33u w=1.12u l=0.13u
X88 pn178_t6 pn212_t12 pn2_t2 AVDD_t56 sg13_lv_pmos ad=2.2576p pd=13.96u as=1.2616p ps=7.02u w=6.64u l=2u
X89 pn228_t7 VOUT_t10 pn162_t2 AVDD_t79 sg13_lv_pmos ad=0.95p pd=5.38u as=0.95p ps=5.38u w=5u l=3u
X90 pn162_t0 pn162 VGND VGND sg13_lv_nmos ad=0.95p pd=5.38u as=1.7p ps=10.68u w=5u l=5u
X91 VGND pn127 pn110_t8 VGND sg13_lv_nmos ad=0.95p pd=5.38u as=0.95p ps=5.38u w=5u l=3u
X92 VPWR_t148 pn130 pn62_t0 VPWR_t5 sg13_lv_pmos ad=0.3808p pd=2.92u as=0.3808p ps=2.92u w=1.12u l=0.13u
X93 pn17 pn6_t1 VGND_t72 VGND_t71 sg13_lv_nmos ad=0.1406p pd=1.12u as=0.2516p ps=2.16u w=0.74u l=0.13u
X94 VGND_t402 pn42_t3 pn49 VGND_t401 sg13_lv_nmos ad=0.2516p pd=2.16u as=96.2f ps=1u w=0.74u l=0.13u
X95 pn41 pn205_t1 VGND_t303 VGND_t302 sg13_lv_nmos ad=0.1406p pd=1.12u as=0.17255p ps=1.25u w=0.74u l=0.13u
X96 VPWR_t49 pn204_t1 pn194 VPWR_t29 sg13_lv_pmos ad=0.3808p pd=2.92u as=0.2128p ps=1.5u w=1.12u l=0.13u
X97 pn144_t1 pn77_t1 pn212 AVDD_t58 sg13_lv_pmos ad=0.1836p pd=1.76u as=0.1836p ps=1.76u w=0.54u l=0.13u
X98 VPWR_t43 pn121_t2 pn30_t0 VPWR_t29 sg13_lv_pmos ad=0.2114p pd=1.54u as=0.2856p ps=2.36u w=0.84u l=0.13u
X99 pn156_t0 pn84_t0 AVDD_t18 AVDD_t17 sg13_lv_pmos ad=0.68p pd=4.68u as=0.68p ps=4.68u w=2u l=2u
X100 pn179_t0 pn51_t1 VGND_t122 VGND_t121 sg13_lv_nmos ad=0.1406p pd=1.12u as=0.2516p ps=2.16u w=0.74u l=0.13u
X101 pn227_t15 pn156_t11 VGND VGND sg13_lv_nmos ad=2.04p pd=12.68u as=2.04p ps=12.68u w=6u l=2u
X102 pn84_t12 IBIAS_IA_t0 VGND VGND sg13_lv_nmos ad=0.34p pd=2.68u as=0.34p ps=2.68u w=1u l=2u
X103 pn52 pn69_t1 VGND_t265 VGND_t304 sg13_lv_nmos ad=0.2886p pd=2.26u as=0.14875p ps=1.16u w=0.74u l=0.13u
X104 pn89_t1 pn165 pn161_t4 AVDD_t50 sg13_lv_pmos ad=0.1836p pd=1.76u as=0.1836p ps=1.76u w=0.54u l=0.13u
X105 pn163_t0 pn54_t1 VGND VGND sg13_lv_nmos ad=0.2516p pd=2.16u as=0.2516p ps=2.16u w=0.74u l=0.13u
X106 pn48_t0 pn41_t3 pn185 VPWR_t29 sg13_lv_pmos ad=0.2128p pd=1.5u as=0.2716p ps=1.605u w=1.12u l=0.13u
X107 VGND_t348 VPWR_t161 VGND_t347 VGND_t346 sg13_lv_nmos ad=0.1428p pd=1.52u as=0 ps=0 w=0.42u l=1u
X108 pn178_t1 VCM_t3 pn1_t2 AVDD_t56 sg13_lv_pmos ad=1.2616p pd=7.02u as=1.2616p ps=7.02u w=6.64u l=2u
X109 AVDD_t55 pn222_t0 pn222_t1 AVDD_t54 sg13_lv_pmos ad=1.887p pd=11.78u as=1.887p ps=11.78u w=5.55u l=0.5u
X110 pn177_t6 pn82_t34 AVDD_t168 AVDD_t61 sg13_lv_pmos ad=0.1005p pd=1.34u as=0.3345p ps=2.9u w=0.15u l=0.15u
X111 pn1_t1 VCM_t3 pn178_t1 AVDD_t56 sg13_lv_pmos ad=1.2616p pd=7.02u as=1.2616p ps=7.02u w=6.64u l=2u
X112 pn82_t17 IBIAS_IA_t6 VGND VGND sg13_lv_nmos ad=0.34p pd=2.68u as=0.34p ps=2.68u w=1u l=2u
X113 pn113_t0 pn113 VINP_t0 AVDD_t75 sg13_lv_pmos ad=0.104p pd=1.34u as=0.104p ps=1.34u w=0.2u l=2u
X114 pn92_t0 pn54_t3 VGND VGND sg13_lv_nmos ad=0.2618p pd=2.22u as=0.1463p ps=1.15u w=0.77u l=0.13u
X115 pn84_t10 pn84_t2 AVDD_t16 AVDD_t6 sg13_lv_pmos ad=0.68p pd=4.68u as=0.68p ps=4.68u w=2u l=2u
X116 pn193_t0 pn38_t2 pn39 VGND_t272 sg13_lv_nmos ad=0.2516p pd=2.16u as=0.1406p ps=1.12u w=0.74u l=0.13u
X117 pn159_t0 pn153_t3 pn226_t0 VGND sg13_lv_nmos ad=2.1794p pd=13.5u as=2.1794p ps=13.5u w=6.41u l=2u
X118 VGND pn80_t1 pn140_t1 VGND sg13_lv_nmos ad=0.2516p pd=2.16u as=0.2516p ps=2.16u w=0.74u l=0.13u
X119 pn87_t1 pn224_t5 AVDD_t65 AVDD_t64 sg13_lv_pmos ad=1.0545p pd=5.93u as=1.887p ps=11.78u w=5.55u l=0.5u
X120 pn178 pn114 AVDD_t191 AVDD_t190 sg13_lv_pmos ad=2.5364p pd=15.6u as=2.5364p ps=15.6u w=7.46u l=2u
X121 pn168_t0 pn93_t1 VGND VGND sg13_lv_nmos ad=0.2516p pd=2.16u as=0.1331p ps=1.12u w=0.74u l=0.13u
X122 pn60 pn193_t2 VGND_t495 VGND_t494 sg13_lv_nmos ad=0.2516p pd=2.16u as=0.2516p ps=2.16u w=0.74u l=0.13u
X123 AVDD_t176 pn82_t32 pn100_t5 AVDD_t62 sg13_lv_pmos ad=0.3345p pd=2.9u as=0.1005p ps=1.34u w=0.15u l=0.15u
X124 pn143 pn110_t10 VGND rhigh l=17.84u w=0.5u ps=0 b=0 m=1
X125 pn82_t7 IBIAS_IA_t0 VGND VGND sg13_lv_nmos ad=0.34p pd=2.68u as=0.34p ps=2.68u w=1u l=2u
X126 pn150_t9 pn148 VGND VGND sg13_lv_nmos ad=0.95p pd=5.38u as=1.7p ps=10.68u w=5u l=3u
X127 VGND_t356 VPWR_t159 VGND_t355 VGND_t354 sg13_lv_nmos ad=0.1428p pd=1.52u as=0 ps=0 w=0.42u l=1u
X128 VGND_t87 pn5_t2 pn203_t0 VGND_t275 sg13_lv_nmos ad=0.17255p pd=1.25u as=0.187p ps=1.78u w=0.55u l=0.13u
X129 pn148_t3 pn149 VGND VGND sg13_lv_nmos ad=0.95p pd=5.38u as=1.7p ps=10.68u w=5u l=5u
X130 AVDD_t146 pn82_t32 pn100_t7 AVDD_t62 sg13_lv_pmos ad=0.3345p pd=2.9u as=0.1005p ps=1.34u w=0.15u l=0.15u
X131 pn202_t0 pn33_t1 VGND_t319 VGND_t432 sg13_lv_nmos ad=0.2516p pd=2.16u as=0.1331p ps=1.12u w=0.74u l=0.13u
X132 pn81 pn146 VGND VGND sg13_lv_nmos ad=0.1216p pd=1.02u as=0.1331p ps=1.12u w=0.64u l=0.13u
X133 pn82_t28 IBIAS_IA_t6 VGND VGND sg13_lv_nmos ad=0.34p pd=2.68u as=0.34p ps=2.68u w=1u l=2u
X134 pn105_t0 pn100_t8 VGND rhigh l=2u w=0.5u ps=0 b=0 m=1
X135 VPWR_t65 pn50_t8 pn204 VPWR_t0 sg13_lv_pmos ad=0.2198p pd=1.53u as=0.2856p ps=2.36u w=0.84u l=0.13u
X136 VGND_t328 VPWR_t165 VGND_t330 VGND_t329 sg13_lv_nmos ad=79.8f pd=0.8u as=0 ps=0 w=0.42u l=1u
X137 pn127_t0 pn129 VGND VGND sg13_lv_nmos ad=0.95p pd=5.38u as=1.7p ps=10.68u w=5u l=5u
X138 VGND_t343 VPWR_t162 VGND_t345 VGND_t344 sg13_lv_nmos ad=79.8f pd=0.8u as=0 ps=0 w=0.42u l=1u
X139 VGND_t455 pn132 pn64 VGND_t454 sg13_lv_nmos ad=0.2516p pd=2.16u as=0.2516p ps=2.16u w=0.74u l=0.13u
X140 pn195 pn205_t1 VPWR_t104 VPWR_t29 sg13_lv_pmos ad=0.1176p pd=1.33u as=0.2618p ps=1.63u w=1.12u l=0.13u
X141 AVDD_t86 pn83_t10 VOUT_t6 AVDD_t63 sg13_lv_pmos ad=0.3345p pd=2.9u as=0.1005p ps=1.34u w=0.15u l=0.15u
X142 VINN_t0 pn126_t1 pn126_t2 AVDD_t75 sg13_lv_pmos ad=0.104p pd=1.34u as=0.104p ps=1.34u w=0.2u l=2u
X143 pn131_t0 pn209_t1 VPWR_t141 VPWR_t29 sg13_lv_pmos ad=0.2128p pd=1.5u as=0.3808p ps=2.92u w=1.12u l=0.13u
X144 VPWR_t95 VGND_t536 VPWR_t94 VPWR_t0 sg13_lv_pmos ad=0.19p pd=1.38u as=0 ps=0 w=1u l=1u
X145 VPWR_t10 VGND_t556 VPWR_t9 VPWR_t5 sg13_lv_pmos ad=0.34p pd=2.68u as=0 ps=0 w=1u l=1u
X146 pn106_t1 pn106_t0 pn103_t0 VGND sg13_lv_nmos ad=0.2856p pd=2.36u as=0.2856p ps=2.36u w=0.84u l=0.5u
X147 pn59 pn76_t1 VGND_t299 VGND_t315 sg13_lv_nmos ad=0.2886p pd=2.26u as=0.14875p ps=1.16u w=0.74u l=0.13u
X148 pn224_t2 pn155 VGND rhigh l=4u w=0.5u ps=0 b=0 m=1
X149 pn6 pn22_t1 VGND_t288 VGND_t431 sg13_lv_nmos ad=0.2886p pd=2.26u as=0.14875p ps=1.16u w=0.74u l=0.13u
X150 pn198 pn197_t1 VPWR_t64 VPWR_t29 sg13_lv_pmos ad=0.42p pd=2.99u as=0.2114p ps=1.54u w=1.12u l=0.13u
X151 VPWR_t67 pn65_t1 pn199 VPWR_t29 sg13_lv_pmos ad=0.2114p pd=1.54u as=0.2856p ps=2.36u w=0.84u l=0.13u
X152 pn185_t0 pn181_t2 pn48_t0 VPWR_t29 sg13_lv_pmos ad=0.2744p pd=1.61u as=0.2128p ps=1.5u w=1.12u l=0.13u
X153 VPWR_t77 pn38_t2 pn193 VPWR_t0 sg13_lv_pmos ad=0.3808p pd=2.92u as=0.2128p ps=1.5u w=1.12u l=0.13u
X154 AVDD_t98 pn227_t2 pn227_t3 AVDD_t97 sg13_lv_pmos ad=2.5364p pd=15.6u as=2.5364p ps=15.6u w=7.46u l=2u
X155 pn219_t4 VINN_t1 pn148_t2 AVDD_t71 sg13_lv_pmos ad=0.95p pd=5.38u as=0.95p ps=5.38u w=5u l=3u
X156 pn220_t3 pn84_t0 AVDD_t10 AVDD_t6 sg13_lv_pmos ad=0.68p pd=4.68u as=0.68p ps=4.68u w=2u l=2u
X157 pn82_t14 IBIAS_IA_t0 VGND VGND sg13_lv_nmos ad=0.34p pd=2.68u as=0.34p ps=2.68u w=1u l=2u
X158 pn83 IBIAS_IA_t0 VGND VGND sg13_lv_nmos ad=0.34p pd=2.68u as=0.34p ps=2.68u w=1u l=2u
X159 pn178_t3 pn114_t22 AVDD_t193 AVDD_t190 sg13_lv_pmos ad=2.5364p pd=15.6u as=2.5364p ps=15.6u w=7.46u l=2u
X160 VPWR_t72 pn48_t1 pn69_t0 VPWR_t5 sg13_lv_pmos ad=0.2114p pd=1.54u as=0.2856p ps=2.36u w=0.84u l=0.13u
X161 AVDD_t126 pn109 pn99_t2 AVDD_t125 sg13_lv_pmos ad=1.955p pd=12.18u as=1.0925p ps=6.13u w=5.75u l=2u
X162 pn33_t0 pn50_t4 VPWR_t122 VPWR_t29 sg13_lv_pmos ad=0.1596p pd=1.22u as=0.2856p ps=2.36u w=0.84u l=0.13u
X163 VOUT_t8 pn229_t3 VGND VGND sg13_lv_nmos ad=0.95p pd=5.38u as=3.6p ps=11.44u w=5u l=3u
X164 VGND_t376 VPWR_t155 VGND_t375 VGND_t374 sg13_lv_nmos ad=0.1428p pd=1.52u as=0 ps=0 w=0.42u l=1u
X165 VPWR_t123 pn50_t2 pn180 VPWR_t0 sg13_lv_pmos ad=0.4032p pd=2.96u as=0.1176p ps=1.33u w=1.12u l=0.13u
X166 pn153_t0 pn160_t4 AVDD_t224 AVDD_t222 sg13_lv_pmos ad=1.0925p pd=6.13u as=1.955p ps=12.18u w=5.75u l=2u
X167 AVDD_t113 pn227_t21 pn221_t11 AVDD_t112 sg13_lv_pmos ad=2.5364p pd=15.6u as=2.5364p ps=15.6u w=7.46u l=2u
X168 pn220_t4 pn84_t2 AVDD_t32 AVDD_t17 sg13_lv_pmos ad=0.68p pd=4.68u as=0.68p ps=4.68u w=2u l=2u
X169 pn35 pn5_t4 VGND_t277 VGND_t276 sg13_lv_nmos ad=0.1694p pd=1.21u as=0.2618p ps=2.22u w=0.77u l=0.13u
X170 pn214_t0 pn8_t2 pn212_t5 VGND sg13_lv_nmos ad=0.104p pd=1.34u as=0.104p ps=1.34u w=0.2u l=0.13u
X171 AVDD_t84 pn83_t10 pn228_t2 AVDD_t79 sg13_lv_pmos ad=0.3345p pd=2.9u as=0.1005p ps=1.34u w=0.15u l=0.15u
X172 pn82_t35 pn82_t34 AVDD_t172 AVDD_t61 sg13_lv_pmos ad=0.1005p pd=1.34u as=0.3345p ps=2.9u w=0.15u l=0.15u
X173 pn151_t0 pn150_t8 VGND rhigh l=2u w=0.5u ps=0 b=0 m=1
X174 pn163_t1 pn54_t1 AVDD_t216 AVDD_t60 sg13_lv_pmos ad=0.3808p pd=2.92u as=0.3808p ps=2.92u w=1.12u l=0.13u
X175 pn127_t3 pn112 VGND rhigh l=1.95u w=0.5u ps=0 b=0 m=1
X176 pn84_t13 IBIAS_IA_t0 VGND VGND sg13_lv_nmos ad=0.34p pd=2.68u as=0.34p ps=2.68u w=1u l=2u
X177 pn46 pn35_t3 VGND_t325 VGND_t324 sg13_lv_nmos ad=0.1406p pd=1.12u as=0.14505p ps=1.15u w=0.74u l=0.13u
X178 AVDD_t143 pn80_t1 pn140_t0 AVDD_t142 sg13_lv_pmos ad=0.3808p pd=2.92u as=0.3808p ps=2.92u w=1.12u l=0.13u
X179 pn92_t1 pn54_t3 pn231 AVDD_t0 sg13_lv_pmos ad=0.3808p pd=2.92u as=0.2128p ps=1.5u w=1.12u l=0.13u
X180 pn84_t8 pn84_t2 AVDD_t36 AVDD_t22 sg13_lv_pmos ad=0.68p pd=4.68u as=0.68p ps=4.68u w=2u l=2u
X181 IBIAS_IA_t8 IBIAS_IA_t6 VGND VGND sg13_lv_nmos ad=0.34p pd=2.68u as=0.34p ps=2.68u w=1u l=2u
X182 VGND pn148 pn150_t10 VGND sg13_lv_nmos ad=3.6p pd=11.44u as=0.95p ps=5.38u w=5u l=3u
X183 AVDD_t188 pn104_t5 pn120_t2 AVDD_t187 sg13_lv_pmos ad=1.887p pd=11.78u as=1.0545p ps=5.93u w=5.55u l=0.5u
X184 VPWR_t13 VGND_t541 VPWR_t26 VPWR_t0 sg13_lv_pmos ad=0.34p pd=2.68u as=0 ps=0 w=1u l=1u
X185 pn201 pn50_t5 pn118_t1 VPWR_t29 sg13_lv_pmos ad=0.1176p pd=1.33u as=0.3808p ps=2.92u w=1.12u l=0.13u
X186 AVDD_t94 pn227_t14 pn227 AVDD_t93 sg13_lv_pmos ad=2.5364p pd=15.6u as=2.5364p ps=15.6u w=7.46u l=2u
X187 pn60_t0 pn193_t2 VPWR_t132 VPWR_t5 sg13_lv_pmos ad=0.3808p pd=2.92u as=0.3808p ps=2.92u w=1.12u l=0.13u
X188 pn172 pn88_t1 VGND rhigh l=54u w=0.5u ps=0 b=0 m=1
X189 VPWR_t34 pn41_t1 pn131_t0 VPWR_t29 sg13_lv_pmos ad=0.3808p pd=2.92u as=0.2128p ps=1.5u w=1.12u l=0.13u
X190 pn157_t0 pn157 VGND VGND sg13_lv_nmos ad=0.714p pd=4.88u as=0.714p ps=4.88u w=2.1u l=0.5u
X191 pn215_t2 pn128_t2 VGND rhigh l=6.66u w=0.5u ps=0 b=0 m=1
X192 AVDD_t221 pn160_t5 pn225 AVDD_t220 sg13_lv_pmos ad=1.564p pd=9.88u as=1.564p ps=9.88u w=4.6u l=2u
X193 pn148_t1 VINN_t1 pn219_t4 AVDD_t71 sg13_lv_pmos ad=0.95p pd=5.38u as=0.95p ps=5.38u w=5u l=3u
X194 pn49 pn189_t2 pn48 VGND_t297 sg13_lv_nmos ad=96.2f pd=1u as=0.2664p ps=1.46u w=0.74u l=0.13u
X195 VGND_t74 pn6_t2 pn38 VGND_t73 sg13_lv_nmos ad=0.2516p pd=2.16u as=0.1406p ps=1.12u w=0.74u l=0.13u
X196 pn145_t0 pn8_t3 VGND VGND sg13_lv_nmos ad=0.1694p pd=1.21u as=0.1463p ps=1.15u w=0.77u l=0.13u
X197 VGND_t381 VPWR_t154 VGND_t383 VGND_t382 sg13_lv_nmos ad=79.8f pd=0.8u as=0 ps=0 w=0.42u l=1u
X198 AVDD_t119 pn227_t16 pn221_t12 AVDD_t114 sg13_lv_pmos ad=2.5364p pd=15.6u as=2.5364p ps=15.6u w=7.46u l=2u
X199 VPWR_t93 pn182_t1 pn76_t0 VPWR_t5 sg13_lv_pmos ad=0.2114p pd=1.54u as=0.2856p ps=2.36u w=0.84u l=0.13u
X200 VPWR_t2 VGND_t542 VPWR_t130 VPWR_t0 sg13_lv_pmos ad=0.19p pd=1.38u as=0 ps=0 w=1u l=1u
X201 AVDD_t80 pn83_t10 pn83_t11 AVDD_t79 sg13_lv_pmos ad=0.3345p pd=2.9u as=0.1005p ps=1.34u w=0.15u l=0.15u
X202 pn100_t10 pn97 VGND VGND sg13_lv_nmos ad=0.95p pd=5.38u as=0.95p ps=5.38u w=5u l=3u
X203 pn7_t0 pn23_t1 VPWR_t31 VPWR_t29 sg13_lv_pmos ad=0.42p pd=2.99u as=0.2114p ps=1.54u w=1.12u l=0.13u
X204 VGND pn229_t3 VOUT_t9 VGND sg13_lv_nmos ad=1.7p pd=10.68u as=0.95p ps=5.38u w=5u l=3u
X205 VPWR_t128 pn132 pn64_t0 VPWR_t5 sg13_lv_pmos ad=0.3808p pd=2.92u as=0.3808p ps=2.92u w=1.12u l=0.13u
X206 pn52_t0 pn69_t1 VPWR_t72 VPWR_t5 sg13_lv_pmos ad=0.42p pd=2.99u as=0.2114p ps=1.54u w=1.12u l=0.13u
X207 VGND_t6 pn118 pn23 VGND_t5 sg13_lv_nmos ad=0.14875p pd=1.16u as=0.187p ps=1.78u w=0.55u l=0.13u
X208 pn5 pn21_t1 VGND_t61 VGND_t60 sg13_lv_nmos ad=0.2886p pd=2.26u as=0.14875p ps=1.16u w=0.74u l=0.13u
X209 VGND_t265 pn48_t1 pn69 VGND_t264 sg13_lv_nmos ad=0.14875p pd=1.16u as=0.187p ps=1.78u w=0.55u l=0.13u
X210 VPWR_t111 pn50_t3 pn208 VPWR_t29 sg13_lv_pmos ad=0.2198p pd=1.53u as=0.2856p ps=2.36u w=0.84u l=0.13u
X211 VPWR_t112 pn35_t4 pn33_t0 VPWR_t29 sg13_lv_pmos ad=0.1918p pd=1.5u as=0.1596p ps=1.22u w=0.84u l=0.13u
X212 pn221_t10 VCM_t4 pn223 AVDD_t3 sg13_lv_pmos ad=1.2616p pd=7.02u as=1.2616p ps=7.02u w=6.64u l=2u
X213 pn181_t0 pn5_t1 pn17 VGND_t281 sg13_lv_nmos ad=0.2516p pd=2.16u as=0.1406p ps=1.12u w=0.74u l=0.13u
X214 pn82_t0 IBIAS_IA_t0 VGND VGND sg13_lv_nmos ad=0.34p pd=2.68u as=0.34p ps=2.68u w=1u l=2u
X215 pn185 pn189_t1 VPWR_t92 VPWR_t29 sg13_lv_pmos ad=0.2716p pd=1.605u as=0.3808p ps=2.92u w=1.12u l=0.13u
X216 pn114_t14 pn114_t13 AVDD_t202 AVDD_t201 sg13_lv_pmos ad=2.5364p pd=15.6u as=2.5364p ps=15.6u w=7.46u l=2u
X217 pn119_t0 pn35_t3 VPWR_t111 VPWR_t29 sg13_lv_pmos ad=0.2128p pd=1.5u as=0.2198p ps=1.53u w=1.12u l=0.13u
X218 pn51 pn68_t1 VGND_t270 VGND_t274 sg13_lv_nmos ad=0.2886p pd=2.26u as=0.14875p ps=1.16u w=0.74u l=0.13u
X219 VPWR_t32 pn62_t1 pn72_t0 VPWR_t5 sg13_lv_pmos ad=0.2114p pd=1.54u as=0.2856p ps=2.36u w=0.84u l=0.13u
X220 AVDD_t181 pn82_t32 pn175_t2 AVDD_t62 sg13_lv_pmos ad=0.3345p pd=2.9u as=0.1005p ps=1.34u w=0.15u l=0.15u
X221 pn190 pn5_t4 VPWR_t83 VPWR_t0 sg13_lv_pmos ad=0.2464p pd=1.56u as=0.3808p ps=2.92u w=1.12u l=0.13u
X222 pn82_t20 IBIAS_IA_t6 VGND VGND sg13_lv_nmos ad=0.34p pd=2.68u as=0.34p ps=2.68u w=1u l=2u
X223 pn164_t1 pn15_t1 VGND VGND sg13_lv_nmos ad=0.2516p pd=2.16u as=0.2516p ps=2.16u w=0.74u l=0.13u
X224 pn84_t3 pn84_t2 AVDD_t26 AVDD_t6 sg13_lv_pmos ad=0.68p pd=4.68u as=0.68p ps=4.68u w=2u l=2u
X225 pn119_t1 pn208_t1 pn46 VGND_t75 sg13_lv_nmos ad=0.333p pd=2.38u as=0.1406p ps=1.12u w=0.74u l=0.13u
X226 AVDD_t81 pn83_t10 pn228_t0 AVDD_t79 sg13_lv_pmos ad=0.3345p pd=2.9u as=0.1005p ps=1.34u w=0.15u l=0.15u
X227 VPWR_t42 pn121 pn188 VPWR_t0 sg13_lv_pmos ad=0.3808p pd=2.92u as=0.3808p ps=2.92u w=1.12u l=0.13u
X228 pn87_t2 pn224_t5 AVDD_t67 AVDD_t68 sg13_lv_pmos ad=1.0545p pd=5.93u as=1.0545p ps=5.93u w=5.55u l=0.5u
X229 pn2_t0 pn99_t4 VGND VGND sg13_lv_nmos ad=3.1314p pd=19.1u as=3.1314p ps=19.1u w=9.21u l=2u
X230 pn82_t4 IBIAS_IA_t0 VGND VGND sg13_lv_nmos ad=0.34p pd=2.68u as=0.34p ps=2.68u w=1u l=2u
X231 AVDD_t189 pn145 pn147_t0 AVDD_t57 sg13_lv_pmos ad=0.2856p pd=2.36u as=0.1596p ps=1.22u w=0.84u l=0.13u
X232 pn82_t10 IBIAS_IA_t0 VGND VGND sg13_lv_nmos ad=0.34p pd=2.68u as=0.34p ps=2.68u w=1u l=2u
X233 AVDD_t152 pn82_t36 pn150_t7 AVDD_t71 sg13_lv_pmos ad=0.3345p pd=2.9u as=0.1005p ps=1.34u w=0.15u l=0.15u
X234 pn82_t31 IBIAS_IA_t6 VGND VGND sg13_lv_nmos ad=0.34p pd=2.68u as=0.34p ps=2.68u w=1u l=2u
X235 pn162_t3 VOUT_t10 pn228_t7 AVDD_t79 sg13_lv_pmos ad=0.95p pd=5.38u as=0.95p ps=5.38u w=5u l=3u
X236 pn88_t2 pn164 pn161_t10 AVDD_t44 sg13_lv_pmos ad=0.1836p pd=1.76u as=0.1836p ps=1.76u w=0.54u l=0.13u
X237 pn170_t1 pn171 VGND rhigh l=13.42u w=0.5u ps=0 b=0 m=1
X238 AVDD_t148 pn82_t36 pn150_t0 AVDD_t71 sg13_lv_pmos ad=0.3345p pd=2.9u as=0.1005p ps=1.34u w=0.15u l=0.15u
X239 VGND_t371 VPWR_t156 VGND_t370 VGND_t369 sg13_lv_nmos ad=0.1428p pd=1.52u as=0 ps=0 w=0.42u l=1u
X240 pn59_t0 pn76_t1 VPWR_t93 VPWR_t5 sg13_lv_pmos ad=0.42p pd=2.99u as=0.2114p ps=1.54u w=1.12u l=0.13u
X241 VPWR_t15 VGND_t547 VPWR_t41 VPWR_t0 sg13_lv_pmos ad=0.34p pd=2.68u as=0 ps=0 w=1u l=1u
X242 pn98_t3 pn105 pn175_t6 AVDD_t62 sg13_lv_pmos ad=0.95p pd=5.38u as=1.7p ps=10.68u w=5u l=3u
X243 VPWR_t117 pn42_t3 pn185_t0 VPWR_t29 sg13_lv_pmos ad=0.3808p pd=2.92u as=0.2744p ps=1.61u w=1.12u l=0.13u
X244 pn66 pn38_t3 pn133_t0 VGND_t271 sg13_lv_nmos ad=0.1406p pd=1.12u as=0.2516p ps=2.16u w=0.74u l=0.13u
X245 VGND_t43 pn121 pn188_t0 VGND_t42 sg13_lv_nmos ad=0.2516p pd=2.16u as=0.2516p ps=2.16u w=0.74u l=0.13u
X246 VGND_t299 pn182_t1 pn76 VGND_t298 sg13_lv_nmos ad=0.14875p pd=1.16u as=0.187p ps=1.78u w=0.55u l=0.13u
X247 VPWR_t7 VGND_t550 VPWR_t6 VPWR_t5 sg13_lv_pmos ad=0.34p pd=2.68u as=0 ps=0 w=1u l=1u
X248 pn61 pn41_t4 VGND_t22 VGND_t21 sg13_lv_nmos ad=0.1406p pd=1.12u as=0.2516p ps=2.16u w=0.74u l=0.13u
X249 AVDD_t186 pn104_t5 pn120_t3 AVDD_t51 sg13_lv_pmos ad=1.0545p pd=5.93u as=1.0545p ps=5.93u w=5.55u l=0.5u
X250 pn129_t1 pn143_t1 pn177_t0 AVDD_t61 sg13_lv_pmos ad=0.95p pd=5.38u as=0.95p ps=5.38u w=5u l=3u
X251 VOUT_t9 pn229_t3 VGND VGND sg13_lv_nmos ad=0.95p pd=5.38u as=0.95p ps=5.38u w=5u l=3u
X252 pn110_t2 pn82_t34 AVDD_t164 AVDD_t61 sg13_lv_pmos ad=0.1005p pd=1.34u as=0.3345p ps=2.9u w=0.15u l=0.15u
X253 AVDD_t52 pn3_t0 pn3_t1 AVDD_t51 sg13_lv_pmos ad=2.4922p pd=15.34u as=2.4922p ps=15.34u w=7.33u l=2u
X254 pn114_t6 pn114_t5 AVDD_t208 AVDD_t207 sg13_lv_pmos ad=2.5364p pd=15.6u as=2.5364p ps=15.6u w=7.46u l=2u
X255 pn187 pn6_t4 VPWR_t52 VPWR_t0 sg13_lv_pmos ad=0.3808p pd=2.92u as=0.3808p ps=2.92u w=1.12u l=0.13u
X256 VGND_t323 pn122 pn118_t0 VGND_t445 sg13_lv_nmos ad=0.17255p pd=1.25u as=0.1406p ps=1.12u w=0.74u l=0.13u
X257 pn100_t9 pn97 VGND VGND sg13_lv_nmos ad=0.95p pd=5.38u as=1.7p ps=10.68u w=5u l=3u
X258 pn110_t7 pn82_t34 AVDD_t155 AVDD_t61 sg13_lv_pmos ad=0.1005p pd=1.34u as=0.3345p ps=2.9u w=0.15u l=0.15u
X259 VPWR_t55 pn208_t1 pn119_t0 VPWR_t29 sg13_lv_pmos ad=0.3808p pd=2.92u as=0.2128p ps=1.5u w=1.12u l=0.13u
X260 pn220_t1 pn84_t0 AVDD_t14 AVDD_t11 sg13_lv_pmos ad=0.68p pd=4.68u as=0.68p ps=4.68u w=2u l=2u
X261 pn228_t5 pn87_t3 pn229 AVDD_t63 sg13_lv_pmos ad=0.95p pd=5.38u as=0.95p ps=5.38u w=5u l=3u
X262 pn83_t0 IBIAS_IA_t0 VGND VGND sg13_lv_nmos ad=0.34p pd=2.68u as=0.34p ps=2.68u w=1u l=2u
X263 VGND_t10 pn62_t1 pn72 VGND_t9 sg13_lv_nmos ad=0.14875p pd=1.16u as=0.187p ps=1.78u w=0.55u l=0.13u
X264 pn218 pn8_t3 pn217 AVDD_t72 sg13_lv_pmos ad=0.2464p pd=1.56u as=0.2128p ps=1.5u w=1.12u l=0.13u
X265 pn189 pn209_t4 VPWR_t142 VPWR_t29 sg13_lv_pmos ad=0.3808p pd=2.92u as=0.3808p ps=2.92u w=1.12u l=0.13u
X266 pn173 pn229_t2 VGND rhigh l=1.95u w=0.5u ps=0 b=0 m=1
X267 pn91 pn15_t3 VGND VGND sg13_lv_nmos ad=0.1406p pd=1.12u as=0.2516p ps=2.16u w=0.74u l=0.13u
X268 VGND_t389 VPWR_t152 VGND_t388 VGND_t387 sg13_lv_nmos ad=0.1428p pd=1.52u as=0 ps=0 w=0.42u l=1u
X269 VGND_t303 pn50_t7 pn205_t0 VGND_t421 sg13_lv_nmos ad=0.17255p pd=1.25u as=0.187p ps=1.78u w=0.55u l=0.13u
X270 pn91_t0 pn55_t4 pn232 AVDD_t0 sg13_lv_pmos ad=0.3808p pd=2.92u as=0.1176p ps=1.33u w=1.12u l=0.13u
X271 pn82 IBIAS_IA_t6 VGND VGND sg13_lv_nmos ad=0.34p pd=2.68u as=0.34p ps=2.68u w=1u l=2u
X272 VPWR_t75 gain_sel[2]_t0 pn68_t0 VPWR_t5 sg13_lv_pmos ad=0.2114p pd=1.54u as=0.2856p ps=2.36u w=0.84u l=0.13u
X273 VPWR_t21 VGND_t557 VPWR_t18 VPWR_t5 sg13_lv_pmos ad=0.19p pd=1.38u as=0 ps=0 w=1u l=1u
X274 pn226 pn161_t12 pn221_t4 AVDD_t3 sg13_lv_pmos ad=1.2616p pd=7.02u as=2.2576p ps=13.96u w=6.64u l=2u
X275 pn50 pn67_t1 VGND_t254 VGND_t253 sg13_lv_nmos ad=0.2886p pd=2.26u as=0.14875p ps=1.16u w=0.74u l=0.13u
X276 VGND_t279 pn5_t5 pn209_t0 VGND_t278 sg13_lv_nmos ad=0.2516p pd=2.16u as=0.1406p ps=1.12u w=0.74u l=0.13u
X277 pn1 pn101 pn104_t4 VGND sg13_lv_nmos ad=2.1794p pd=13.5u as=2.1794p ps=13.5u w=6.41u l=2u
X278 pn187_t0 pn6_t4 VGND_t67 VGND_t66 sg13_lv_nmos ad=0.2516p pd=2.16u as=0.2516p ps=2.16u w=0.74u l=0.13u
X279 VPWR_t28 VGND_t551 VPWR_t27 VPWR_t5 sg13_lv_pmos ad=0.19p pd=1.38u as=0 ps=0 w=1u l=1u
X280 pn84_t1 pn84_t0 AVDD_t20 AVDD_t17 sg13_lv_pmos ad=0.68p pd=4.68u as=0.68p ps=4.68u w=2u l=2u
X281 VGND pn55_t3 dantenna l=0.78u w=0.78u
X282 pn43 pn42_t2 VGND_t258 VGND_t405 sg13_lv_nmos ad=0.1406p pd=1.12u as=0.14505p ps=1.15u w=0.74u l=0.13u
X283 pn83_t4 IBIAS_IA_t0 VGND VGND sg13_lv_nmos ad=0.34p pd=2.68u as=0.34p ps=2.68u w=1u l=2u
X284 pn10_t0 pn26_t1 VPWR_t59 VPWR_t29 sg13_lv_pmos ad=0.42p pd=2.99u as=0.2114p ps=1.54u w=1.12u l=0.13u
X285 pn92 pn200_t3 VGND VGND sg13_lv_nmos ad=0.1694p pd=1.21u as=0.2618p ps=2.22u w=0.77u l=0.13u
X286 AVDD_t149 pn82_t36 pn150_t6 AVDD_t71 sg13_lv_pmos ad=0.3345p pd=2.9u as=0.1005p ps=1.34u w=0.15u l=0.15u
X287 pn189_t0 pn209_t4 VGND_t513 VGND_t512 sg13_lv_nmos ad=0.2516p pd=2.16u as=0.2516p ps=2.16u w=0.74u l=0.13u
X288 pn164_t0 pn15_t1 AVDD_t45 AVDD_t44 sg13_lv_pmos ad=0.3808p pd=2.92u as=0.3808p ps=2.92u w=1.12u l=0.13u
X289 VGND_t85 pn188_t1 pn26 VGND_t84 sg13_lv_nmos ad=0.14875p pd=1.16u as=0.187p ps=1.78u w=0.55u l=0.13u
X290 pn176_t1 pn111 pn104_t1 AVDD_t40 sg13_lv_pmos ad=0.748p pd=5.08u as=0.748p ps=5.08u w=2.2u l=0.5u
X291 pn90 pn168 pn161_t3 VGND sg13_lv_nmos ad=0.136p pd=1.48u as=0.136p ps=1.48u w=0.4u l=0.13u
X292 pn82_t26 IBIAS_IA_t6 VGND VGND sg13_lv_nmos ad=0.34p pd=2.68u as=0.34p ps=2.68u w=1u l=2u
X293 pn121_t1 pn209_t3 pn45 VGND_t514 sg13_lv_nmos ad=0.2516p pd=2.16u as=0.1406p ps=1.12u w=0.74u l=0.13u
X294 pn128 pn120 VGND rhigh l=3.2u w=0.5u ps=0 b=0 m=1
X295 pn101_t0 pn109_t5 AVDD_t128 AVDD_t125 sg13_lv_pmos ad=1.0925p pd=6.13u as=1.955p ps=12.18u w=5.75u l=2u
X296 pn99_t3 pn109 AVDD_t136 AVDD_t125 sg13_lv_pmos ad=1.0925p pd=6.13u as=1.955p ps=12.18u w=5.75u l=2u
X297 VGND_t371 VPWR_t156 VGND_t373 VGND_t372 sg13_lv_nmos ad=79.8f pd=0.8u as=0 ps=0 w=0.42u l=1u
X298 AVDD_t117 pn227_t18 pn221_t8 AVDD_t114 sg13_lv_pmos ad=2.5364p pd=15.6u as=2.5364p ps=15.6u w=7.46u l=2u
X299 pn154_t1 pn160_t3 AVDD_t229 AVDD_t222 sg13_lv_pmos ad=1.0925p pd=6.13u as=1.955p ps=12.18u w=5.75u l=2u
X300 AVDD_t47 pn159_t1 pn159_t2 AVDD_t46 sg13_lv_pmos ad=2.4922p pd=15.34u as=2.4922p ps=15.34u w=7.33u l=2u
X301 AVDD_t219 pn160 pn224 AVDD_t218 sg13_lv_pmos ad=3.1314p pd=19.1u as=3.1314p ps=19.1u w=9.21u l=2u
X302 VPWR_t110 pn122 pn201 VPWR_t29 sg13_lv_pmos ad=0.2618p pd=1.63u as=0.1176p ps=1.33u w=1.12u l=0.13u
X303 VGND_t338 VPWR_t163 VGND_t337 VGND_t336 sg13_lv_nmos ad=0.1428p pd=1.52u as=0 ps=0 w=0.42u l=1u
X304 pn150_t10 pn148 VGND VGND sg13_lv_nmos ad=0.95p pd=5.38u as=0.95p ps=5.38u w=5u l=3u
X305 VPWR_t115 pn42_t4 pn133_t1 VPWR_t5 sg13_lv_pmos ad=0.3808p pd=2.92u as=0.2128p ps=1.5u w=1.12u l=0.13u
X306 VPWR_t23 VGND_t539 VPWR_t22 VPWR_t0 sg13_lv_pmos ad=0.34p pd=2.68u as=0 ps=0 w=1u l=1u
X307 VGND pn162_t4 pn229_t0 VGND sg13_lv_nmos ad=1.7p pd=10.68u as=0.95p ps=5.38u w=5u l=5u
X308 pn177_t0 pn143_t1 pn129_t0 AVDD_t61 sg13_lv_pmos ad=0.95p pd=5.38u as=0.95p ps=5.38u w=5u l=3u
X309 VPWR_t31 pn118 pn23_t0 VPWR_t29 sg13_lv_pmos ad=0.2114p pd=1.54u as=0.2856p ps=2.36u w=0.84u l=0.13u
X310 VGND pn229_t3 VOUT_t8 VGND sg13_lv_nmos ad=0.95p pd=5.38u as=0.95p ps=5.38u w=5u l=3u
X311 VGND pn10_t1 pn78 VGND sg13_lv_nmos ad=0.2516p pd=2.16u as=0.2516p ps=2.16u w=0.74u l=0.13u
X312 VPWR_t69 pn181_t3 pn211 VPWR_t5 sg13_lv_pmos ad=0.3808p pd=2.92u as=0.2128p ps=1.5u w=1.12u l=0.13u
X313 AVDD_t100 pn227_t8 pn227_t9 AVDD_t99 sg13_lv_pmos ad=2.5364p pd=15.6u as=2.5364p ps=15.6u w=7.46u l=2u
X314 pn101_t2 pn101_t1 pn95_t0 VGND sg13_lv_nmos ad=0.544p pd=3.88u as=0.544p ps=3.88u w=1.6u l=2u
X315 pn42 pn206_t1 VGND_t120 VGND_t313 sg13_lv_nmos ad=0.1406p pd=1.12u as=0.17255p ps=1.25u w=0.74u l=0.13u
X316 pn51_t0 pn68_t1 VPWR_t75 VPWR_t5 sg13_lv_pmos ad=0.42p pd=2.99u as=0.2114p ps=1.54u w=1.12u l=0.13u
X317 VPWR_t146 pn179_t2 pn186_t0 VPWR_t0 sg13_lv_pmos ad=0.3808p pd=2.92u as=0.2128p ps=1.5u w=1.12u l=0.13u
X318 pn170_t0 pn200_t2 pn161_t2 VGND sg13_lv_nmos ad=0.102p pd=1.28u as=0.102p ps=1.28u w=0.3u l=0.13u
X319 pn84_t6 pn84_t0 AVDD_t8 AVDD_t6 sg13_lv_pmos ad=0.68p pd=4.68u as=0.68p ps=4.68u w=2u l=2u
X320 pn2_t2 pn212_t12 pn178_t7 AVDD_t56 sg13_lv_pmos ad=1.2616p pd=7.02u as=1.2616p ps=7.02u w=6.64u l=2u
X321 pn89 pn55_t2 pn161_t1 VGND sg13_lv_nmos ad=0.1026p pd=1.34u as=0.1026p ps=1.34u w=0.18u l=0.13u
X322 VGND_t270 gain_sel[2]_t0 pn68 VGND_t269 sg13_lv_nmos ad=0.14875p pd=1.16u as=0.187p ps=1.78u w=0.55u l=0.13u
X323 pn13_t0 pn29_t1 VPWR_t133 VPWR_t29 sg13_lv_pmos ad=0.42p pd=2.99u as=0.2114p ps=1.54u w=1.12u l=0.13u
X324 pn132_t0 pn42_t2 VPWR_t70 VPWR_t29 sg13_lv_pmos ad=0.2128p pd=1.5u as=0.2198p ps=1.53u w=1.12u l=0.13u
X325 pn19 pn209_t1 pn131_t1 VGND_t515 sg13_lv_nmos ad=0.1406p pd=1.12u as=0.2516p ps=2.16u w=0.74u l=0.13u
X326 AVDD_t115 pn227_t20 pn221_t1 AVDD_t114 sg13_lv_pmos ad=2.5364p pd=15.6u as=2.5364p ps=15.6u w=7.46u l=2u
X327 pn41_t0 pn51_t3 pn195 VPWR_t29 sg13_lv_pmos ad=0.3808p pd=2.92u as=0.1176p ps=1.33u w=1.12u l=0.13u
X328 pn120_t1 pn176_t3 VGND VGND sg13_lv_nmos ad=2.856p pd=17.48u as=2.856p ps=17.48u w=8.4u l=0.5u
X329 VPWR_t25 VGND_t548 VPWR_t24 VPWR_t5 sg13_lv_pmos ad=0.34p pd=2.68u as=0 ps=0 w=1u l=1u
X330 pn178_t10 pn114_t20 AVDD_t195 AVDD_t190 sg13_lv_pmos ad=2.5364p pd=15.6u as=2.5364p ps=15.6u w=7.46u l=2u
X331 pn15 pn31_t1 VGND_t36 VGND_t510 sg13_lv_nmos ad=0.2886p pd=2.26u as=0.14875p ps=1.16u w=0.74u l=0.13u
X332 pn84_t9 pn84_t2 AVDD_t30 AVDD_t11 sg13_lv_pmos ad=0.68p pd=4.68u as=0.68p ps=4.68u w=2u l=2u
X333 pn82_t23 IBIAS_IA_t6 VGND VGND sg13_lv_nmos ad=0.34p pd=2.68u as=0.34p ps=2.68u w=1u l=2u
X334 AVDD_t90 pn83_t10 VOUT_t5 AVDD_t63 sg13_lv_pmos ad=0.3345p pd=2.9u as=0.1005p ps=1.34u w=0.15u l=0.15u
X335 AVDD_t158 pn82_t36 pn219_t1 AVDD_t71 sg13_lv_pmos ad=0.3345p pd=2.9u as=0.1005p ps=1.34u w=0.15u l=0.15u
X336 VPWR_t68 gain_sel[3]_t0 pn67_t0 VPWR_t5 sg13_lv_pmos ad=0.2114p pd=1.54u as=0.2856p ps=2.36u w=0.84u l=0.13u
X337 VPWR_t140 pn209_t3 pn121_t0 VPWR_t29 sg13_lv_pmos ad=0.3808p pd=2.92u as=0.2128p ps=1.5u w=1.12u l=0.13u
X338 pn141 pn213_t1 VGND rhigh l=54u w=0.5u ps=0 b=0 m=1
X339 pn12 pn28_t1 VGND_t28 VGND_t27 sg13_lv_nmos ad=0.2886p pd=2.26u as=0.14875p ps=1.16u w=0.74u l=0.13u
X340 pn219_t5 VINN_t1 pn148_t1 AVDD_t71 sg13_lv_pmos ad=1.7p pd=10.68u as=0.95p ps=5.38u w=5u l=3u
X341 pn83_t2 IBIAS_IA_t0 VGND VGND sg13_lv_nmos ad=0.34p pd=2.68u as=0.34p ps=2.68u w=1u l=2u
X342 pn222_t2 pn158 pn158_t1 AVDD_t97 sg13_lv_pmos ad=0.748p pd=5.08u as=0.748p ps=5.08u w=2.2u l=0.5u
X343 pn98_t1 pn98_t0 VGND VGND sg13_lv_nmos ad=0.95p pd=5.38u as=3.6p ps=11.44u w=5u l=5u
X344 pn36 pn5_t3 pn186_t1 VGND_t280 sg13_lv_nmos ad=0.1406p pd=1.12u as=0.2516p ps=2.16u w=0.74u l=0.13u
X345 pn55 pn72_t1 VGND_t10 VGND_t41 sg13_lv_nmos ad=0.2886p pd=2.26u as=0.14875p ps=1.16u w=0.74u l=0.13u
X346 pn83_t6 IBIAS_IA_t6 VGND VGND sg13_lv_nmos ad=0.34p pd=2.68u as=0.34p ps=2.68u w=1u l=2u
X347 VGND_t115 pn51_t3 pn41 VGND_t114 sg13_lv_nmos ad=0.2516p pd=2.16u as=0.1406p ps=1.12u w=0.74u l=0.13u
X348 pn156_t5 pn84_t2 AVDD_t34 AVDD_t17 sg13_lv_pmos ad=0.68p pd=4.68u as=0.68p ps=4.68u w=2u l=2u
X349 pn84_t17 IBIAS_IA_t6 VGND VGND sg13_lv_nmos ad=0.34p pd=2.68u as=0.34p ps=2.68u w=1u l=2u
X350 VGND_t427 pn50_t2 pn179_t0 VGND_t426 sg13_lv_nmos ad=0.2516p pd=2.16u as=0.1406p ps=1.12u w=0.74u l=0.13u
X351 pn122_t0 pn35_t5 VGND_t323 VGND_t322 sg13_lv_nmos ad=0.187p pd=1.78u as=0.17255p ps=1.25u w=0.55u l=0.13u
X352 pn230 pn200_t3 AVDD_t76 AVDD_t0 sg13_lv_pmos ad=0.2464p pd=1.56u as=0.3808p ps=2.92u w=1.12u l=0.13u
X353 pn177_t5 pn82_t34 AVDD_t169 AVDD_t61 sg13_lv_pmos ad=0.1005p pd=1.34u as=0.3345p ps=2.9u w=0.15u l=0.15u
X354 pn178_t7 pn212_t12 pn2_t1 AVDD_t56 sg13_lv_pmos ad=1.2616p pd=7.02u as=1.2616p ps=7.02u w=6.64u l=2u
X355 pn196 pn206_t1 VPWR_t66 VPWR_t29 sg13_lv_pmos ad=0.1176p pd=1.33u as=0.2618p ps=1.63u w=1.12u l=0.13u
X356 VGND pn148 pn150_t9 VGND sg13_lv_nmos ad=0.95p pd=5.38u as=0.95p ps=5.38u w=5u l=3u
X357 pn129_t0 pn143_t1 pn177_t2 AVDD_t61 sg13_lv_pmos ad=0.95p pd=5.38u as=1.7p ps=10.68u w=5u l=3u
X358 IBIAS_IA_t11 IBIAS_IA_t6 VGND VGND sg13_lv_nmos ad=0.34p pd=2.68u as=0.34p ps=2.68u w=1u l=2u
X359 VGND pn98_t0 pn98_t1 VGND sg13_lv_nmos ad=1.7p pd=10.68u as=0.95p ps=5.38u w=5u l=5u
X360 VGND pn8_t1 pn139_t1 VGND sg13_lv_nmos ad=0.2516p pd=2.16u as=0.2516p ps=2.16u w=0.74u l=0.13u
X361 VGND_t423 pn50_t6 pn42 VGND_t422 sg13_lv_nmos ad=0.2516p pd=2.16u as=0.1406p ps=1.12u w=0.74u l=0.13u
X362 AVDD_t177 pn82_t32 pn100_t3 AVDD_t62 sg13_lv_pmos ad=0.3345p pd=2.9u as=0.1005p ps=1.34u w=0.15u l=0.15u
X363 pn127_t1 pn96_t1 pn177 AVDD_t61 sg13_lv_pmos ad=0.95p pd=5.38u as=1.7p ps=10.68u w=5u l=3u
X364 pn178_t4 pn114_t17 AVDD_t200 AVDD_t187 sg13_lv_pmos ad=2.5364p pd=15.6u as=2.5364p ps=15.6u w=7.46u l=2u
X365 VGND_t26 pn41_t1 pn19 VGND_t25 sg13_lv_nmos ad=0.2516p pd=2.16u as=0.1406p ps=1.12u w=0.74u l=0.13u
X366 pn171_t0 pn172_t2 VGND rhigh l=26.95u w=0.5u ps=0 b=0 m=1
X367 AVDD_t173 pn82_t32 pn100_t6 AVDD_t62 sg13_lv_pmos ad=0.3345p pd=2.9u as=0.1005p ps=1.34u w=0.15u l=0.15u
X368 VGND pn99 pn1_t0 VGND sg13_lv_nmos ad=3.1314p pd=19.1u as=3.1314p ps=19.1u w=9.21u l=2u
X369 pn144_t0 pn11_t2 pn212_t4 VGND sg13_lv_nmos ad=0.1026p pd=1.34u as=0.1026p ps=1.34u w=0.18u l=0.13u
X370 pn147_t1 pn145 pn81 VGND sg13_lv_nmos ad=0.2176p pd=1.96u as=0.1216p ps=1.02u w=0.64u l=0.13u
X371 pn171_t2 pn53_t2 pn161_t11 VGND sg13_lv_nmos ad=0.104p pd=1.34u as=0.104p ps=1.34u w=0.2u l=0.13u
X372 pn83_t1 IBIAS_IA_t0 VGND VGND sg13_lv_nmos ad=0.34p pd=2.68u as=0.34p ps=2.68u w=1u l=2u
X373 AVDD_t122 pn10_t1 pn78_t0 AVDD_t49 sg13_lv_pmos ad=0.3808p pd=2.92u as=0.3808p ps=2.92u w=1.12u l=0.13u
X374 pn38_t0 pn6_t2 pn192 VPWR_t0 sg13_lv_pmos ad=0.3808p pd=2.92u as=0.1176p ps=1.33u w=1.12u l=0.13u
X375 pn50_t0 pn67_t1 VPWR_t68 VPWR_t5 sg13_lv_pmos ad=0.42p pd=2.99u as=0.2114p ps=1.54u w=1.12u l=0.13u
X376 AVDD_t91 pn83_t10 VOUT_t3 AVDD_t63 sg13_lv_pmos ad=0.3345p pd=2.9u as=0.1005p ps=1.34u w=0.15u l=0.15u
X377 pn221_t2 pn161_t12 pn226_t1 AVDD_t3 sg13_lv_pmos ad=2.2576p pd=13.96u as=1.2616p ps=7.02u w=6.64u l=2u
X378 VGND pn154_t4 pn226_t2 VGND sg13_lv_nmos ad=3.1314p pd=19.1u as=3.1314p ps=19.1u w=9.21u l=2u
X379 VGND_t254 gain_sel[3]_t0 pn67 VGND_t521 sg13_lv_nmos ad=0.14875p pd=1.16u as=0.187p ps=1.78u w=0.55u l=0.13u
X380 VGND_t120 pn51_t2 pn206_t0 VGND_t119 sg13_lv_nmos ad=0.17255p pd=1.25u as=0.187p ps=1.78u w=0.55u l=0.13u
X381 pn156_t8 pn84_t2 AVDD_t25 AVDD_t6 sg13_lv_pmos ad=0.68p pd=4.68u as=0.68p ps=4.68u w=2u l=2u
X382 pn82_t18 IBIAS_IA_t6 VGND VGND sg13_lv_nmos ad=0.34p pd=2.68u as=0.34p ps=2.68u w=1u l=2u
X383 AVDD_t87 pn83_t10 VOUT_t4 AVDD_t63 sg13_lv_pmos ad=0.3345p pd=2.9u as=0.1005p ps=1.34u w=0.15u l=0.15u
X384 pn175_t8 pn105 pn98_t4 AVDD_t62 sg13_lv_pmos ad=1.7p pd=10.68u as=0.95p ps=5.38u w=5u l=3u
X385 pn84_t7 pn84_t0 AVDD_t24 AVDD_t22 sg13_lv_pmos ad=0.68p pd=4.68u as=0.68p ps=4.68u w=2u l=2u
X386 pn37 pn6_t3 pn36 VGND_t70 sg13_lv_nmos ad=0.1406p pd=1.12u as=0.1406p ps=1.12u w=0.74u l=0.13u
X387 pn82_t2 IBIAS_IA_t0 VGND VGND sg13_lv_nmos ad=0.34p pd=2.68u as=0.34p ps=2.68u w=1u l=2u
X388 VPWR_t59 pn188_t1 pn26_t0 VPWR_t29 sg13_lv_pmos ad=0.2114p pd=1.54u as=0.2856p ps=2.36u w=0.84u l=0.13u
X389 pn198_t0 pn197_t1 VGND_t113 VGND_t483 sg13_lv_nmos ad=0.2886p pd=2.26u as=0.14875p ps=1.16u w=0.74u l=0.13u
X390 pn82_t8 IBIAS_IA_t0 VGND VGND sg13_lv_nmos ad=0.34p pd=2.68u as=0.34p ps=2.68u w=1u l=2u
X391 pn11 pn27_t1 VGND_t40 VGND_t55 sg13_lv_nmos ad=0.2886p pd=2.26u as=0.14875p ps=1.16u w=0.74u l=0.13u
X392 pn44 pn41_t2 VGND_t24 VGND_t23 sg13_lv_nmos ad=0.1406p pd=1.12u as=0.2516p ps=2.16u w=0.74u l=0.13u
X393 AVDD_t104 pn227_t0 pn227_t1 AVDD_t103 sg13_lv_pmos ad=2.5364p pd=15.6u as=2.5364p ps=15.6u w=7.46u l=2u
X394 VGND_t128 pn65_t1 pn199_t0 VGND_t127 sg13_lv_nmos ad=0.14875p pd=1.16u as=0.187p ps=1.78u w=0.55u l=0.13u
X395 VGND pn97 pn100_t10 VGND sg13_lv_nmos ad=3.6p pd=11.44u as=0.95p ps=5.38u w=5u l=3u
X396 pn184_t0 pn211_t1 pn4_t0 VGND_t282 sg13_lv_nmos ad=0.2516p pd=2.16u as=0.1406p ps=1.12u w=0.74u l=0.15u
X397 pn82_t29 IBIAS_IA_t6 VGND VGND sg13_lv_nmos ad=0.34p pd=2.68u as=0.34p ps=2.68u w=1u l=2u
X398 AVDD_t225 pn160_t3 pn154_t0 AVDD_t222 sg13_lv_pmos ad=1.955p pd=12.18u as=1.0925p ps=6.13u w=5.75u l=2u
X399 pn214_t1 pn215_t1 VGND rhigh l=13.42u w=0.5u ps=0 b=0 m=1
X400 pn8 pn24_t1 VGND_t59 VGND_t58 sg13_lv_nmos ad=0.2886p pd=2.26u as=0.14875p ps=1.16u w=0.74u l=0.13u
X401 pn58 pn75_t1 VGND_t38 VGND_t37 sg13_lv_nmos ad=0.2886p pd=2.26u as=0.14875p ps=1.16u w=0.74u l=0.13u
X402 pn16_t0 pn32_t1 VPWR_t62 VPWR_t29 sg13_lv_pmos ad=0.42p pd=2.99u as=0.2114p ps=1.54u w=1.12u l=0.13u
X403 pn82_t12 IBIAS_IA_t0 VGND VGND sg13_lv_nmos ad=0.34p pd=2.68u as=0.34p ps=2.68u w=1u l=2u
X404 VGND_t91 pn133_t2 pn32 VGND_t90 sg13_lv_nmos ad=0.14875p pd=1.16u as=0.187p ps=1.78u w=0.55u l=0.13u
X405 pn9_t0 pn25_t1 VPWR_t91 VPWR_t29 sg13_lv_pmos ad=0.42p pd=2.99u as=0.2114p ps=1.54u w=1.12u l=0.13u
X406 VGND_t296 pn18_t1 pn25 VGND_t295 sg13_lv_nmos ad=0.14875p pd=1.16u as=0.187p ps=1.78u w=0.55u l=0.13u
X407 VPWR_t64 pn186_t3 pn197 VPWR_t29 sg13_lv_pmos ad=0.2114p pd=1.54u as=0.2856p ps=2.36u w=0.84u l=0.13u
X408 pn225_t1 pn225_t0 pn157_t1 VGND sg13_lv_nmos ad=0.2856p pd=2.36u as=0.2856p ps=2.36u w=0.84u l=0.5u
X409 VPWR_t3 VGND_t534 VPWR_t8 VPWR_t0 sg13_lv_pmos ad=0.34p pd=2.68u as=0 ps=0 w=1u l=1u
X410 VGND_t497 pn193_t1 pn29 VGND_t496 sg13_lv_nmos ad=0.14875p pd=1.16u as=0.187p ps=1.78u w=0.55u l=0.13u
X411 AVDD_t174 pn82_t32 pn100_t4 AVDD_t62 sg13_lv_pmos ad=0.3345p pd=2.9u as=0.1005p ps=1.34u w=0.15u l=0.15u
X412 pn171_t1 pn167 pn161_t7 AVDD_t1 sg13_lv_pmos ad=0.204p pd=1.88u as=0.204p ps=1.88u w=0.6u l=0.13u
X413 pn213_t0 pn9_t2 pn212_t1 VGND sg13_lv_nmos ad=0.1026p pd=1.34u as=0.1026p ps=1.34u w=0.18u l=0.13u
X414 pn84_t4 pn84_t0 AVDD_t12 AVDD_t11 sg13_lv_pmos ad=0.68p pd=4.68u as=0.68p ps=4.68u w=2u l=2u
X415 pn114_t2 pn114_t1 AVDD_t211 AVDD_t41 sg13_lv_pmos ad=2.5364p pd=15.6u as=2.5364p ps=15.6u w=7.46u l=2u
X416 VGND pn11_t3 dantenna l=0.78u w=0.78u
X417 IBIAS_IA_t1 IBIAS_IA_t0 VGND VGND sg13_lv_nmos ad=0.34p pd=2.68u as=0.34p ps=2.68u w=1u l=2u
X418 AVDD_t139 pn8_t1 pn139_t0 AVDD_t138 sg13_lv_pmos ad=0.3808p pd=2.92u as=0.3808p ps=2.92u w=1.12u l=0.13u
X419 pn150 pn143_t0 VGND rhigh l=2u w=0.5u ps=0 b=0 m=1
X420 pn130_t0 pn41_t2 VPWR_t35 VPWR_t29 sg13_lv_pmos ad=0.2128p pd=1.5u as=0.3808p ps=2.92u w=1.12u l=0.13u
X421 AVDD_t108 pn227_t4 pn227_t5 AVDD_t107 sg13_lv_pmos ad=2.5364p pd=15.6u as=2.5364p ps=15.6u w=7.46u l=2u
X422 pn223 VCM_t4 pn221 AVDD_t3 sg13_lv_pmos ad=1.2616p pd=7.02u as=2.2576p ps=13.96u w=6.64u l=2u
X423 pn108_t1 pn111_t0 pn111_t1 AVDD_t41 sg13_lv_pmos ad=0.748p pd=5.08u as=0.748p ps=5.08u w=2.2u l=0.5u
X424 VPWR_t14 VGND_t540 VPWR_t13 VPWR_t0 sg13_lv_pmos ad=0.19p pd=1.38u as=0 ps=0 w=1u l=1u
X425 pn178_t0 VCM_t3 pn1_t1 AVDD_t56 sg13_lv_pmos ad=2.2576p pd=13.96u as=1.2616p ps=7.02u w=6.64u l=2u
X426 pn130_t1 pn38_t1 pn44 VGND_t273 sg13_lv_nmos ad=0.2516p pd=2.16u as=0.1406p ps=1.12u w=0.74u l=0.13u
X427 pn55_t0 pn72_t1 VPWR_t32 VPWR_t5 sg13_lv_pmos ad=0.42p pd=2.99u as=0.2114p ps=1.54u w=1.12u l=0.13u
X428 pn97_t3 pn98 VGND VGND sg13_lv_nmos ad=0.95p pd=5.38u as=1.7p ps=10.68u w=5u l=5u
X429 VPWR_t11 VGND_t554 VPWR_t46 VPWR_t5 sg13_lv_pmos ad=0.34p pd=2.68u as=0 ps=0 w=1u l=1u
X430 pn83_t3 IBIAS_IA_t0 VGND VGND sg13_lv_nmos ad=0.34p pd=2.68u as=0.34p ps=2.68u w=1u l=2u
X431 pn97_t1 VINP_t1 pn175 AVDD_t62 sg13_lv_pmos ad=0.95p pd=5.38u as=1.7p ps=10.68u w=5u l=3u
X432 pn175_t7 pn105 pn98_t3 AVDD_t62 sg13_lv_pmos ad=0.95p pd=5.38u as=0.95p ps=5.38u w=5u l=3u
X433 pn82_t24 IBIAS_IA_t6 VGND VGND sg13_lv_nmos ad=0.34p pd=2.68u as=0.34p ps=2.68u w=1u l=2u
X434 pn14 pn30_t1 VGND_t45 VGND_t266 sg13_lv_nmos ad=0.2886p pd=2.26u as=0.14875p ps=1.16u w=0.74u l=0.13u
X435 pn156_t3 pn84_t2 AVDD_t37 AVDD_t22 sg13_lv_pmos ad=0.68p pd=4.68u as=0.68p ps=4.68u w=2u l=2u
X436 pn202 pn33_t1 VPWR_t112 VPWR_t29 sg13_lv_pmos ad=0.3808p pd=2.92u as=0.1918p ps=1.5u w=1.12u l=0.13u
X437 VPWR_t38 pn131_t2 pn75_t0 VPWR_t5 sg13_lv_pmos ad=0.2114p pd=1.54u as=0.2856p ps=2.36u w=0.84u l=0.13u
X438 pn90_t2 pn169 pn161_t9 AVDD_t4 sg13_lv_pmos ad=0.408p pd=3.08u as=0.408p ps=3.08u w=1.2u l=0.13u
X439 VGND pn156 pn156_t9 VGND sg13_lv_nmos ad=0.2958p pd=2.42u as=0.2958p ps=2.42u w=0.87u l=2u
X440 AVDD_t182 pn82_t32 pn175_t1 AVDD_t62 sg13_lv_pmos ad=0.3345p pd=2.9u as=0.1005p ps=1.34u w=0.15u l=0.15u
X441 VGND_t381 VPWR_t154 VGND_t380 VGND_t379 sg13_lv_nmos ad=0.1428p pd=1.52u as=0 ps=0 w=0.42u l=1u
X442 pn99_t1 pn99_t0 VGND VGND sg13_lv_nmos ad=3.1314p pd=19.1u as=3.1314p ps=19.1u w=9.21u l=2u
X443 pn114_t16 pn114_t15 AVDD_t215 AVDD_t214 sg13_lv_pmos ad=2.5364p pd=15.6u as=2.5364p ps=15.6u w=7.46u l=2u
X444 pn215 pn138 pn212_t9 AVDD_t141 sg13_lv_pmos ad=0.306p pd=2.48u as=0.306p ps=2.48u w=0.9u l=0.13u
X445 AVDD_t82 pn83_t10 pn228_t3 AVDD_t79 sg13_lv_pmos ad=0.3345p pd=2.9u as=0.1005p ps=1.34u w=0.15u l=0.15u
X446 pn158_t0 pn156_t12 VGND VGND sg13_lv_nmos ad=0.5916p pd=4.16u as=0.5916p ps=4.16u w=1.74u l=2u
X447 pn86 pn156_t10 VGND VGND sg13_lv_nmos ad=1.088p pd=7.08u as=1.088p ps=7.08u w=3.2u l=2u
X448 AVDD_t153 pn82_t36 pn150_t2 AVDD_t71 sg13_lv_pmos ad=0.3345p pd=2.9u as=0.1005p ps=1.34u w=0.15u l=0.15u
X449 VGND_t83 pn131 pn63 VGND_t82 sg13_lv_nmos ad=0.2516p pd=2.16u as=0.2516p ps=2.16u w=0.74u l=0.13u
X450 pn6_t0 pn22_t1 VPWR_t86 VPWR_t0 sg13_lv_pmos ad=0.42p pd=2.99u as=0.2114p ps=1.54u w=1.12u l=0.13u
X451 VPWR_t78 pn38_t1 pn130_t0 VPWR_t29 sg13_lv_pmos ad=0.3808p pd=2.92u as=0.2128p ps=1.5u w=1.12u l=0.13u
X452 pn174_t0 pn89_t0 VGND rhigh l=54u w=0.5u ps=0 b=0 m=1
X453 VGND_t288 gain_sel[0]_t0 pn22 VGND_t287 sg13_lv_nmos ad=0.14875p pd=1.16u as=0.187p ps=1.78u w=0.55u l=0.13u
X454 VGND_t117 pn50_t8 pn204_t0 VGND_t420 sg13_lv_nmos ad=0.14505p pd=1.15u as=0.187p ps=1.78u w=0.55u l=0.13u
X455 pn177_t1 pn143_t1 pn129_t1 AVDD_t61 sg13_lv_pmos ad=1.7p pd=10.68u as=0.95p ps=5.38u w=5u l=3u
X456 VGND_t400 pn42_t4 pn66 VGND_t399 sg13_lv_nmos ad=0.2516p pd=2.16u as=0.1406p ps=1.12u w=0.74u l=0.13u
X457 pn54 pn71_t1 VGND_t507 VGND_t506 sg13_lv_nmos ad=0.2886p pd=2.26u as=0.14875p ps=1.16u w=0.74u l=0.13u
X458 VPWR_t138 VGND_t532 VPWR_t137 VPWR_t29 sg13_lv_pmos ad=0.34p pd=2.68u as=0 ps=0 w=1u l=1u
X459 VCM_t2 pn113_t1 pn113_t2 AVDD_t75 sg13_lv_pmos ad=0.104p pd=1.34u as=0.104p ps=1.34u w=0.2u l=2u
X460 pn97_t2 VINP_t1 pn175_t4 AVDD_t62 sg13_lv_pmos ad=0.95p pd=5.38u as=0.95p ps=5.38u w=5u l=3u
X461 pn175_t5 VINP_t1 pn97_t2 AVDD_t62 sg13_lv_pmos ad=1.7p pd=10.68u as=0.95p ps=5.38u w=5u l=3u
X462 pn211_t0 pn181_t3 pn61 VGND_t255 sg13_lv_nmos ad=0.2516p pd=2.16u as=0.1406p ps=1.12u w=0.74u l=0.13u
X463 pn82_t5 IBIAS_IA_t0 VGND VGND sg13_lv_nmos ad=0.34p pd=2.68u as=0.34p ps=2.68u w=1u l=2u
X464 VGND_t89 pn133 pn65 VGND_t88 sg13_lv_nmos ad=0.2516p pd=2.16u as=0.2516p ps=2.16u w=0.74u l=0.13u
X465 pn58_t0 pn75_t1 VPWR_t38 VPWR_t5 sg13_lv_pmos ad=0.42p pd=2.99u as=0.2114p ps=1.54u w=1.12u l=0.13u
X466 pn154_t2 pn154 VGND VGND sg13_lv_nmos ad=3.1314p pd=19.1u as=3.1314p ps=19.1u w=9.21u l=2u
X467 pn223_t1 pn153_t2 pn224_t3 VGND sg13_lv_nmos ad=2.1794p pd=13.5u as=2.1794p ps=13.5u w=6.41u l=2u
X468 pn110_t5 pn82_t34 AVDD_t165 AVDD_t61 sg13_lv_pmos ad=0.1005p pd=1.34u as=0.3345p ps=2.9u w=0.15u l=0.15u
X469 VGND_t38 pn131_t2 pn75 VGND_t81 sg13_lv_nmos ad=0.14875p pd=1.16u as=0.187p ps=1.78u w=0.55u l=0.13u
X470 VGND_t353 VPWR_t160 VGND_t352 VGND_t351 sg13_lv_nmos ad=0.1428p pd=1.52u as=0 ps=0 w=0.42u l=1u
X471 pn83_t5 IBIAS_IA_t6 VGND VGND sg13_lv_nmos ad=0.34p pd=2.68u as=0.34p ps=2.68u w=1u l=2u
X472 pn4_t0 pn194_t1 VGND_t52 VGND_t51 sg13_lv_nmos ad=0.1406p pd=1.12u as=0.1406p ps=1.12u w=0.74u l=0.15u
X473 pn167_t0 pn53_t1 VGND VGND sg13_lv_nmos ad=0.2516p pd=2.16u as=0.2516p ps=2.16u w=0.74u l=0.13u
X474 IBIAS_IA_t9 IBIAS_IA_t6 VGND VGND sg13_lv_nmos ad=0.34p pd=2.68u as=0.34p ps=2.68u w=1u l=2u
X475 pn224_t4 pn158_t2 pn86_t1 AVDD_t230 sg13_lv_pmos ad=0.748p pd=5.08u as=0.748p ps=5.08u w=2.2u l=0.5u
X476 pn110_t6 pn82_t34 AVDD_t161 AVDD_t61 sg13_lv_pmos ad=0.1005p pd=1.34u as=0.3345p ps=2.9u w=0.15u l=0.15u
X477 VPWR_t70 pn181_t1 pn207 VPWR_t29 sg13_lv_pmos ad=0.2198p pd=1.53u as=0.2856p ps=2.36u w=0.84u l=0.13u
X478 VPWR_t62 pn133_t2 pn32_t0 VPWR_t29 sg13_lv_pmos ad=0.2114p pd=1.54u as=0.2856p ps=2.36u w=0.84u l=0.13u
X479 VGND_t361 VPWR_t158 VGND_t360 VGND_t359 sg13_lv_nmos ad=0.1428p pd=1.52u as=0 ps=0 w=0.42u l=1u
X480 pn82_t15 IBIAS_IA_t0 VGND VGND sg13_lv_nmos ad=0.34p pd=2.68u as=0.34p ps=2.68u w=1u l=2u
X481 VPWR_t91 pn18_t1 pn25_t0 VPWR_t29 sg13_lv_pmos ad=0.2114p pd=1.54u as=0.2856p ps=2.36u w=0.84u l=0.13u
X482 VGND pn55_t4 pn91 VGND sg13_lv_nmos ad=0.2516p pd=2.16u as=0.1406p ps=1.12u w=0.74u l=0.13u
X483 VPWR_t133 pn193_t1 pn29_t0 VPWR_t29 sg13_lv_pmos ad=0.2114p pd=1.54u as=0.2856p ps=2.36u w=0.84u l=0.13u
X484 AVDD_t137 pn147 pn80_t0 AVDD_t57 sg13_lv_pmos ad=0.1918p pd=1.5u as=0.3808p ps=2.92u w=1.12u l=0.13u
X485 pn146_t0 pn11_t4 VGND VGND sg13_lv_nmos ad=0.1406p pd=1.12u as=0.2516p ps=2.16u w=0.74u l=0.13u
X486 pn83_t8 IBIAS_IA_t6 VGND VGND sg13_lv_nmos ad=0.34p pd=2.68u as=0.34p ps=2.68u w=1u l=2u
X487 VGND_t333 VPWR_t164 VGND_t335 VGND_t334 sg13_lv_nmos ad=79.8f pd=0.8u as=0 ps=0 w=0.42u l=1u
X488 AVDD_t154 pn82_t36 pn150_t1 AVDD_t71 sg13_lv_pmos ad=0.3345p pd=2.9u as=0.1005p ps=1.34u w=0.15u l=0.15u
X489 pn84_t5 pn84_t2 AVDD_t33 AVDD_t17 sg13_lv_pmos ad=0.68p pd=4.68u as=0.68p ps=4.68u w=2u l=2u
X490 pn132_t1 pn207_t1 pn43 VGND_t4 sg13_lv_nmos ad=0.333p pd=2.38u as=0.1406p ps=1.12u w=0.74u l=0.13u
X491 pn111_t2 pn220_t13 VGND VGND sg13_lv_nmos ad=0.5916p pd=4.16u as=0.5916p ps=4.16u w=1.74u l=2u
X492 pn3 pn101_t3 pn2 VGND sg13_lv_nmos ad=2.1794p pd=13.5u as=2.1794p ps=13.5u w=6.41u l=2u
X493 VPWR_t85 pn211_t1 pn184 VPWR_t29 sg13_lv_pmos ad=0.3808p pd=2.92u as=0.2128p ps=1.5u w=1.12u l=0.15u
X494 AVDD_t150 pn82_t36 pn150_t5 AVDD_t71 sg13_lv_pmos ad=0.3345p pd=2.9u as=0.1005p ps=1.34u w=0.15u l=0.15u
X495 AVDD_t53 pn3_t2 pn104_t2 AVDD_t51 sg13_lv_pmos ad=2.4922p pd=15.34u as=2.4922p ps=15.34u w=7.33u l=2u
X496 pn94 pn92_t2 pn93 VGND sg13_lv_nmos ad=0.1216p pd=1.02u as=0.2176p ps=1.96u w=0.64u l=0.13u
X497 pn84_t11 pn84_t0 AVDD_t15 AVDD_t11 sg13_lv_pmos ad=0.68p pd=4.68u as=0.68p ps=4.68u w=2u l=2u
X498 IBIAS_IA_t2 IBIAS_IA_t0 VGND VGND sg13_lv_nmos ad=0.34p pd=2.68u as=0.34p ps=2.68u w=1u l=2u
X499 VGND pn149_t2 pn149_t3 VGND sg13_lv_nmos ad=1.7p pd=10.68u as=0.95p ps=5.38u w=5u l=5u
X500 pn221_t9 VCM_t4 pn223_t2 AVDD_t3 sg13_lv_pmos ad=2.2576p pd=13.96u as=1.2616p ps=7.02u w=6.64u l=2u
X501 pn5_t0 pn21_t1 VPWR_t51 VPWR_t0 sg13_lv_pmos ad=0.42p pd=2.99u as=0.2114p ps=1.54u w=1.12u l=0.13u
X502 pn178_t5 pn114_t23 AVDD_t192 AVDD_t190 sg13_lv_pmos ad=2.5364p pd=15.6u as=2.5364p ps=15.6u w=7.46u l=2u
X503 VGND_t61 gain_sel[1]_t0 pn21 VGND_t300 sg13_lv_nmos ad=0.14875p pd=1.16u as=0.187p ps=1.78u w=0.55u l=0.13u
X504 pn42_t0 pn50_t6 pn196 VPWR_t29 sg13_lv_pmos ad=0.3808p pd=2.92u as=0.1176p ps=1.33u w=1.12u l=0.13u
X505 VGND pn162 pn162_t0 VGND sg13_lv_nmos ad=3.6p pd=11.44u as=0.95p ps=5.38u w=5u l=5u
X506 VPWR_t58 pn131 pn63_t0 VPWR_t5 sg13_lv_pmos ad=0.3808p pd=2.92u as=0.3808p ps=2.92u w=1.12u l=0.13u
X507 VPWR_t134 pn63_t1 pn71_t0 VPWR_t5 sg13_lv_pmos ad=0.2114p pd=1.54u as=0.2856p ps=2.36u w=0.84u l=0.13u
X508 VGND pn129_t2 pn129_t3 VGND sg13_lv_nmos ad=1.7p pd=10.68u as=0.95p ps=5.38u w=5u l=5u
X509 VGND_t366 VPWR_t157 VGND_t365 VGND_t364 sg13_lv_nmos ad=0.1428p pd=1.52u as=0 ps=0 w=0.42u l=1u
X510 pn128_t0 pn80_t2 pn212_t3 VGND sg13_lv_nmos ad=0.136p pd=1.48u as=0.136p ps=1.48u w=0.4u l=0.13u
X511 pn57 pn74_t1 VGND_t268 VGND_t267 sg13_lv_nmos ad=0.2886p pd=2.26u as=0.14875p ps=1.16u w=0.74u l=0.13u
X512 pn156_t1 pn84_t0 AVDD_t21 AVDD_t17 sg13_lv_pmos ad=0.68p pd=4.68u as=0.68p ps=4.68u w=2u l=2u
X513 pn213_t2 pn214_t2 VGND rhigh l=26.95u w=0.5u ps=0 b=0 m=1
X514 pn48 pn181_t2 pn47 VGND_t256 sg13_lv_nmos ad=0.2664p pd=1.46u as=0.13875p ps=1.115u w=0.74u l=0.13u
X515 pn114_t8 pn114_t7 AVDD_t204 AVDD_t203 sg13_lv_pmos ad=2.5364p pd=15.6u as=2.5364p ps=15.6u w=7.46u l=2u
X516 AVDD_t70 pn224_t5 pn87_t2 AVDD_t69 sg13_lv_pmos ad=1.887p pd=11.78u as=1.0545p ps=5.93u w=5.55u l=0.5u
X517 pn84_t14 IBIAS_IA_t0 VGND VGND sg13_lv_nmos ad=0.34p pd=2.68u as=0.34p ps=2.68u w=1u l=2u
X518 pn175_t4 VINP_t1 pn97_t1 AVDD_t62 sg13_lv_pmos ad=0.95p pd=5.38u as=0.95p ps=5.38u w=5u l=3u
X519 pn110_t4 pn82_t34 AVDD_t162 AVDD_t61 sg13_lv_pmos ad=0.1005p pd=1.34u as=0.3345p ps=2.9u w=0.15u l=0.15u
X520 VGND_t325 pn50_t3 pn208_t0 VGND_t425 sg13_lv_nmos ad=0.14505p pd=1.15u as=0.187p ps=1.78u w=0.55u l=0.13u
X521 pn82_t27 IBIAS_IA_t6 VGND VGND sg13_lv_nmos ad=0.34p pd=2.68u as=0.34p ps=2.68u w=1u l=2u
X522 VPWR_t60 pn5_t2 pn203 VPWR_t0 sg13_lv_pmos ad=0.2618p pd=1.63u as=0.2856p ps=2.36u w=0.84u l=0.13u
X523 VPWR_t61 pn133 pn65_t0 VPWR_t5 sg13_lv_pmos ad=0.3808p pd=2.92u as=0.3808p ps=2.92u w=1.12u l=0.13u
X524 VGND pn147 pn80 VGND sg13_lv_nmos ad=0.1331p pd=1.12u as=0.2516p ps=2.16u w=0.74u l=0.13u
X525 VGND pn7_t3 pn145_t0 VGND sg13_lv_nmos ad=0.2618p pd=2.22u as=0.1694p ps=1.21u w=0.77u l=0.13u
X526 VPWR_t30 pn207_t1 pn132_t0 VPWR_t29 sg13_lv_pmos ad=0.3808p pd=2.92u as=0.2128p ps=1.5u w=1.12u l=0.13u
X527 pn212_t8 pn110 VGND rhigh l=6.66u w=0.5u ps=0 b=0 m=1
X528 pn1_t2 VCM_t3 pn178_t2 AVDD_t56 sg13_lv_pmos ad=1.2616p pd=7.02u as=2.2576p ps=13.96u w=6.64u l=2u
X529 pn229 pn87_t3 pn228_t4 AVDD_t63 sg13_lv_pmos ad=0.95p pd=5.38u as=1.7p ps=10.68u w=5u l=3u
X530 pn167_t1 pn53_t1 AVDD_t2 AVDD_t1 sg13_lv_pmos ad=0.3808p pd=2.92u as=0.3808p ps=2.92u w=1.12u l=0.13u
X531 AVDD_t48 pn159 pn224_t1 AVDD_t46 sg13_lv_pmos ad=2.4922p pd=15.34u as=2.4922p ps=15.34u w=7.33u l=2u
X532 VPWR_t103 VGND_t549 VPWR_t7 VPWR_t5 sg13_lv_pmos ad=0.19p pd=1.38u as=0 ps=0 w=1u l=1u
X533 VGND pn98 pn97_t3 VGND sg13_lv_nmos ad=3.6p pd=11.44u as=0.95p ps=5.38u w=5u l=5u
X534 AVDD_t159 pn82_t36 pn219_t3 AVDD_t71 sg13_lv_pmos ad=0.3345p pd=2.9u as=0.1005p ps=1.34u w=0.15u l=0.15u
X535 pn120_t2 pn104_t5 AVDD_t186 AVDD_t187 sg13_lv_pmos ad=1.0545p pd=5.93u as=1.0545p ps=5.93u w=5.55u l=0.5u
X536 pn156_t4 pn84_t2 AVDD_t28 AVDD_t11 sg13_lv_pmos ad=0.68p pd=4.68u as=0.68p ps=4.68u w=2u l=2u
X537 pn82_t21 IBIAS_IA_t6 VGND VGND sg13_lv_nmos ad=0.34p pd=2.68u as=0.34p ps=2.68u w=1u l=2u
X538 pn177_t7 pn96_t1 pn127_t1 AVDD_t61 sg13_lv_pmos ad=0.95p pd=5.38u as=0.95p ps=5.38u w=5u l=3u
X539 pn178_t12 pn114_t21 AVDD_t194 AVDD_t190 sg13_lv_pmos ad=2.5364p pd=15.6u as=2.5364p ps=15.6u w=7.46u l=2u
X540 VPWR_t86 gain_sel[0]_t0 pn22_t0 VPWR_t0 sg13_lv_pmos ad=0.2114p pd=1.54u as=0.2856p ps=2.36u w=0.84u l=0.13u
X541 pn156_t7 pn84_t0 AVDD_t9 AVDD_t6 sg13_lv_pmos ad=0.68p pd=4.68u as=0.68p ps=4.68u w=2u l=2u
X542 pn54_t0 pn71_t1 VPWR_t134 VPWR_t5 sg13_lv_pmos ad=0.42p pd=2.99u as=0.2114p ps=1.54u w=1.12u l=0.13u
X543 pn172_t0 pn163 pn161_t5 AVDD_t60 sg13_lv_pmos ad=0.1836p pd=1.76u as=0.1836p ps=1.76u w=0.54u l=0.13u
X544 pn200 pn199_t1 VPWR_t67 VPWR_t29 sg13_lv_pmos ad=0.42p pd=2.99u as=0.2114p ps=1.54u w=1.12u l=0.13u
X545 VGND_t507 pn63_t1 pn71 VGND_t520 sg13_lv_nmos ad=0.14875p pd=1.16u as=0.187p ps=1.78u w=0.55u l=0.13u
X546 VPWR_t88 VGND_t535 VPWR_t87 VPWR_t0 sg13_lv_pmos ad=0.34p pd=2.68u as=0 ps=0 w=1u l=1u
X547 pn90_t1 pn87_t0 VGND rhigh l=3.2u w=0.5u ps=0 b=0 m=1
X548 pn108_t0 pn108 AVDD_t121 AVDD_t120 sg13_lv_pmos ad=1.887p pd=11.78u as=1.887p ps=11.78u w=5.55u l=0.5u
X549 AVDD_t134 pn109_t3 pn104_t3 AVDD_t133 sg13_lv_pmos ad=3.1314p pd=19.1u as=3.1314p ps=19.1u w=9.21u l=2u
X550 pn177_t3 pn82_t34 AVDD_t170 AVDD_t61 sg13_lv_pmos ad=0.1005p pd=1.34u as=0.3345p ps=2.9u w=0.15u l=0.15u
X551 VGND_t343 VPWR_t162 VGND_t342 VGND_t341 sg13_lv_nmos ad=0.1428p pd=1.52u as=0 ps=0 w=0.42u l=1u
X552 VPWR_t74 pn130_t2 pn74_t0 VPWR_t5 sg13_lv_pmos ad=0.2114p pd=1.54u as=0.2856p ps=2.36u w=0.84u l=0.13u
X553 IBIAS_IA_t4 IBIAS_IA_t0 VGND VGND sg13_lv_nmos ad=0.34p pd=2.68u as=0.34p ps=2.68u w=1u l=2u
X554 VGND pn220_t8 pn220_t9 VGND sg13_lv_nmos ad=0.2958p pd=2.42u as=0.2958p ps=2.42u w=0.87u l=2u
X555 pn182 pn35_t2 VPWR_t109 VPWR_t29 sg13_lv_pmos ad=0.2128p pd=1.5u as=0.3808p ps=2.92u w=1.12u l=0.13u
X556 VPWR_t94 VGND_t537 VPWR_t113 VPWR_t0 sg13_lv_pmos ad=0.34p pd=2.68u as=0 ps=0 w=1u l=1u
X557 pn172_t1 pn54_t2 pn161_t6 VGND sg13_lv_nmos ad=0.1026p pd=1.34u as=0.1026p ps=1.34u w=0.18u l=0.13u
X558 VGND_t54 pn187_t1 pn35 VGND_t53 sg13_lv_nmos ad=0.1463p pd=1.15u as=0.1694p ps=1.21u w=0.77u l=0.13u
X559 pn56 pn73_t1 VGND_t430 VGND_t429 sg13_lv_nmos ad=0.2886p pd=2.26u as=0.14875p ps=1.16u w=0.74u l=0.13u
X560 AVDD_t96 pn227_t10 pn227_t11 AVDD_t95 sg13_lv_pmos ad=2.5364p pd=15.6u as=2.5364p ps=15.6u w=7.46u l=2u
X561 AVDD_t178 pn82_t32 pn100_t2 AVDD_t62 sg13_lv_pmos ad=0.3345p pd=2.9u as=0.1005p ps=1.34u w=0.15u l=0.15u
X562 pn165_t0 pn55_t1 VGND VGND sg13_lv_nmos ad=0.2516p pd=2.16u as=0.2516p ps=2.16u w=0.74u l=0.13u
X563 pn109_t0 pn220_t12 VGND VGND sg13_lv_nmos ad=0.2958p pd=2.42u as=0.2958p ps=2.42u w=0.87u l=2u
X564 pn220_t7 pn84_t2 AVDD_t35 AVDD_t17 sg13_lv_pmos ad=0.68p pd=4.68u as=0.68p ps=4.68u w=2u l=2u
X565 pn84_t16 IBIAS_IA_t6 VGND VGND sg13_lv_nmos ad=0.34p pd=2.68u as=0.34p ps=2.68u w=1u l=2u
X566 VGND_t52 pn209_t2 pn4 VGND_t511 sg13_lv_nmos ad=0.1406p pd=1.12u as=0.2516p ps=2.16u w=0.74u l=0.15u
X567 pn104 pn102 VGND rhigh l=4u w=0.5u ps=0 b=0 m=1
X568 pn127_t2 pn96_t1 pn177_t7 AVDD_t61 sg13_lv_pmos ad=0.95p pd=5.38u as=0.95p ps=5.38u w=5u l=3u
X569 pn149_t0 pn151 pn219_t7 AVDD_t71 sg13_lv_pmos ad=0.95p pd=5.38u as=0.95p ps=5.38u w=5u l=3u
X570 AVDD_t111 pn227_t22 pn221_t5 AVDD_t110 sg13_lv_pmos ad=2.5364p pd=15.6u as=2.5364p ps=15.6u w=7.46u l=2u
X571 AVDD_t67 pn224_t5 pn87_t1 AVDD_t66 sg13_lv_pmos ad=1.0545p pd=5.93u as=1.0545p ps=5.93u w=5.55u l=0.5u
X572 AVDD_t131 pn109 pn99_t3 AVDD_t125 sg13_lv_pmos ad=1.0925p pd=6.13u as=1.0925p ps=6.13u w=5.75u l=2u
X573 pn18_t0 pn186_t2 VPWR_t63 VPWR_t29 sg13_lv_pmos ad=0.3808p pd=2.92u as=0.3808p ps=2.92u w=1.12u l=0.13u
X574 pn99_t2 pn109 AVDD_t131 AVDD_t125 sg13_lv_pmos ad=1.0925p pd=6.13u as=1.0925p ps=6.13u w=5.75u l=2u
X575 pn93_t0 pn92_t2 AVDD_t42 AVDD_t38 sg13_lv_pmos ad=0.1596p pd=1.22u as=0.2856p ps=2.36u w=0.84u l=0.13u
X576 AVDD_t92 pn83_t10 VOUT_t0 AVDD_t63 sg13_lv_pmos ad=0.3345p pd=2.9u as=0.1005p ps=1.34u w=0.15u l=0.15u
X577 pn34 pn50_t4 pn33 VGND_t424 sg13_lv_nmos ad=0.1216p pd=1.02u as=0.2176p ps=1.96u w=0.64u l=0.13u
X578 pn154_t0 pn160_t3 AVDD_t226 AVDD_t222 sg13_lv_pmos ad=1.0925p pd=6.13u as=1.0925p ps=6.13u w=5.75u l=2u
X579 AVDD_t88 pn83_t10 VOUT_t1 AVDD_t63 sg13_lv_pmos ad=0.3345p pd=2.9u as=0.1005p ps=1.34u w=0.15u l=0.15u
X580 pn83_t9 IBIAS_IA_t6 VGND VGND sg13_lv_nmos ad=0.34p pd=2.68u as=0.34p ps=2.68u w=1u l=2u
X581 pn210 pn6_t5 pn209 VPWR_t5 sg13_lv_pmos ad=0.1176p pd=1.33u as=0.3808p ps=2.92u w=1.12u l=0.13u
X582 pn216 pn11_t4 pn146_t1 AVDD_t57 sg13_lv_pmos ad=0.1176p pd=1.33u as=0.3808p ps=2.92u w=1.12u l=0.13u
X583 pn88 pn15_t2 pn161_t0 VGND sg13_lv_nmos ad=0.1026p pd=1.34u as=0.1026p ps=1.34u w=0.18u l=0.13u
X584 AVDD_t156 pn82_t36 pn219_t0 AVDD_t71 sg13_lv_pmos ad=0.3345p pd=2.9u as=0.1005p ps=1.34u w=0.15u l=0.15u
X585 pn82_t16 IBIAS_IA_t6 VGND VGND sg13_lv_nmos ad=0.34p pd=2.68u as=0.34p ps=2.68u w=1u l=2u
X586 VGND_t348 VPWR_t161 VGND_t350 VGND_t349 sg13_lv_nmos ad=79.8f pd=0.8u as=0 ps=0 w=0.42u l=1u
X587 pn144 pn142_t0 VGND rhigh l=54u w=0.5u ps=0 b=0 m=1
X588 VPWR_t99 VGND_t545 VPWR_t98 VPWR_t0 sg13_lv_pmos ad=0.34p pd=2.68u as=0 ps=0 w=1u l=1u
X589 AVDD_t85 pn83_t10 VOUT_t7 AVDD_t63 sg13_lv_pmos ad=0.3345p pd=2.9u as=0.1005p ps=1.34u w=0.15u l=0.15u
X590 VGND_t527 pn179_t2 pn37 VGND_t526 sg13_lv_nmos ad=0.2886p pd=2.26u as=0.1406p ps=1.12u w=0.74u l=0.13u
X591 pn126_t0 pn126 VCM_t1 AVDD_t75 sg13_lv_pmos ad=0.104p pd=1.34u as=0.104p ps=1.34u w=0.2u l=2u
X592 AVDD_t145 pn7_t3 pn218 AVDD_t72 sg13_lv_pmos ad=0.3808p pd=2.92u as=0.2464p ps=1.56u w=1.12u l=0.13u
X593 pn184 pn194_t1 pn183 VPWR_t29 sg13_lv_pmos ad=0.2128p pd=1.5u as=0.2128p ps=1.5u w=1.12u l=0.15u
X594 VGND_t356 VPWR_t159 VGND_t358 VGND_t357 sg13_lv_nmos ad=79.8f pd=0.8u as=0 ps=0 w=0.42u l=1u
X595 pn229_t0 pn162_t4 VGND VGND sg13_lv_nmos ad=0.95p pd=5.38u as=3.6p ps=11.44u w=5u l=5u
X596 VPWR_t51 gain_sel[1]_t0 pn21_t0 VPWR_t0 sg13_lv_pmos ad=0.2114p pd=1.54u as=0.2856p ps=2.36u w=0.84u l=0.13u
X597 pn57_t0 pn74_t1 VPWR_t74 VPWR_t5 sg13_lv_pmos ad=0.42p pd=2.99u as=0.2114p ps=1.54u w=1.12u l=0.13u
X598 pn110_t8 pn127 VGND VGND sg13_lv_nmos ad=0.95p pd=5.38u as=1.7p ps=10.68u w=5u l=3u
X599 pn215_t0 pn7_t2 pn212_t6 VGND sg13_lv_nmos ad=0.102p pd=1.28u as=0.102p ps=1.28u w=0.3u l=0.13u
X600 AVDD_t102 pn227_t6 pn227_t7 AVDD_t101 sg13_lv_pmos ad=2.5364p pd=15.6u as=2.5364p ps=15.6u w=7.46u l=2u
X601 VGND_t268 pn130_t2 pn74 VGND_t530 sg13_lv_nmos ad=0.14875p pd=1.16u as=0.187p ps=1.78u w=0.55u l=0.13u
X602 pn98_t4 pn105 pn175_t7 AVDD_t62 sg13_lv_pmos ad=0.95p pd=5.38u as=0.95p ps=5.38u w=5u l=3u
X603 VGND pn7_t1 pn138_t1 VGND sg13_lv_nmos ad=0.2516p pd=2.16u as=0.2516p ps=2.16u w=0.74u l=0.13u
X604 VPWR_t121 pn50_t1 pn182 VPWR_t29 sg13_lv_pmos ad=0.3808p pd=2.92u as=0.2128p ps=1.5u w=1.12u l=0.13u
X605 VGND_t113 pn186_t3 pn197_t0 VGND_t112 sg13_lv_nmos ad=0.14875p pd=1.16u as=0.187p ps=1.78u w=0.55u l=0.13u
X606 AVDD_t179 pn82_t32 pn100_t0 AVDD_t62 sg13_lv_pmos ad=0.3345p pd=2.9u as=0.1005p ps=1.34u w=0.15u l=0.15u
X607 pn7 pn23_t1 VGND_t6 VGND_t314 sg13_lv_nmos ad=0.2886p pd=2.26u as=0.14875p ps=1.16u w=0.74u l=0.13u
X608 pn39 pn179_t1 VGND_t525 VGND_t524 sg13_lv_nmos ad=0.1406p pd=1.12u as=0.2516p ps=2.16u w=0.74u l=0.13u
X609 VGND pn53_t3 pn92 VGND sg13_lv_nmos ad=0.1463p pd=1.15u as=0.1694p ps=1.21u w=0.77u l=0.13u
X610 pn170_t2 pn166 pn161_t8 AVDD_t77 sg13_lv_pmos ad=0.306p pd=2.48u as=0.306p ps=2.48u w=0.9u l=0.13u
X611 pn82_t3 IBIAS_IA_t0 VGND VGND sg13_lv_nmos ad=0.34p pd=2.68u as=0.34p ps=2.68u w=1u l=2u
X612 pn191 pn187_t1 pn190 VPWR_t0 sg13_lv_pmos ad=0.2128p pd=1.5u as=0.2464p ps=1.56u w=1.12u l=0.13u
X613 AVDD_t116 pn227_t19 pn221_t7 AVDD_t114 sg13_lv_pmos ad=2.5364p pd=15.6u as=2.5364p ps=15.6u w=7.46u l=2u
X614 pn82_t9 IBIAS_IA_t0 VGND VGND sg13_lv_nmos ad=0.34p pd=2.68u as=0.34p ps=2.68u w=1u l=2u
X615 pn15_t0 pn31_t1 VPWR_t37 VPWR_t29 sg13_lv_pmos ad=0.42p pd=2.99u as=0.2114p ps=1.54u w=1.12u l=0.13u
X616 VPWR_t124 pn132_t2 pn73_t0 VPWR_t5 sg13_lv_pmos ad=0.2114p pd=1.54u as=0.2856p ps=2.36u w=0.84u l=0.13u
X617 AVDD_t175 pn82_t32 pn100_t1 AVDD_t62 sg13_lv_pmos ad=0.3345p pd=2.9u as=0.1005p ps=1.34u w=0.15u l=0.15u
X618 VGND pn95 VGND rhigh l=15u w=0.5u ps=0 b=0 m=1
X619 VPWR_t10 VGND_t555 VPWR_t19 VPWR_t5 sg13_lv_pmos ad=0.19p pd=1.38u as=0 ps=0 w=1u l=1u
X620 pn109_t2 pn109_t1 AVDD_t132 AVDD_t41 sg13_lv_pmos ad=0.782p pd=5.28u as=0.782p ps=5.28u w=2.3u l=2u
X621 VPWR_t2 VGND_t543 VPWR_t1 VPWR_t0 sg13_lv_pmos ad=0.34p pd=2.68u as=0 ps=0 w=1u l=1u
X622 pn224_t0 pn225_t2 pn86_t0 VGND sg13_lv_nmos ad=0.2856p pd=2.36u as=0.2856p ps=2.36u w=0.84u l=0.5u
X623 VGND_t36 pn202_t1 pn31 VGND_t35 sg13_lv_nmos ad=0.14875p pd=1.16u as=0.187p ps=1.78u w=0.55u l=0.13u
X624 pn166_t0 pn200_t1 VGND VGND sg13_lv_nmos ad=0.2516p pd=2.16u as=0.2516p ps=2.16u w=0.74u l=0.13u
X625 VGND_t394 VPWR_t151 VGND_t393 VGND_t392 sg13_lv_nmos ad=0.1428p pd=1.52u as=0 ps=0 w=0.42u l=1u
X626 pn12_t0 pn28_t1 VPWR_t36 VPWR_t29 sg13_lv_pmos ad=0.42p pd=2.99u as=0.2114p ps=1.54u w=1.12u l=0.13u
X627 VGND_t319 pn35_t4 pn34 VGND_t318 sg13_lv_nmos ad=0.1331p pd=1.12u as=0.1216p ps=1.02u w=0.64u l=0.13u
X628 pn168_t1 pn93_t1 AVDD_t39 AVDD_t38 sg13_lv_pmos ad=0.3808p pd=2.92u as=0.1918p ps=1.5u w=1.12u l=0.13u
X629 pn219_t7 pn151 pn149_t1 AVDD_t71 sg13_lv_pmos ad=0.95p pd=5.38u as=0.95p ps=5.38u w=5u l=3u
X630 VGND_t28 pn119 pn28 VGND_t46 sg13_lv_nmos ad=0.14875p pd=1.16u as=0.187p ps=1.78u w=0.55u l=0.13u
X631 VGND pn9_t1 pn79 VGND sg13_lv_nmos ad=0.2516p pd=2.16u as=0.2516p ps=2.16u w=0.74u l=0.13u
X632 pn82_t13 IBIAS_IA_t0 VGND VGND sg13_lv_nmos ad=0.34p pd=2.68u as=0.34p ps=2.68u w=1u l=2u
X633 pn165_t1 pn55_t1 AVDD_t124 AVDD_t50 sg13_lv_pmos ad=0.3808p pd=2.92u as=0.3808p ps=2.92u w=1.12u l=0.13u
X634 VGND_t361 VPWR_t158 VGND_t363 VGND_t362 sg13_lv_nmos ad=79.8f pd=0.8u as=0 ps=0 w=0.42u l=1u
X635 pn149_t3 pn149_t2 VGND VGND sg13_lv_nmos ad=0.95p pd=5.38u as=3.6p ps=11.44u w=5u l=5u
X636 pn114_t10 pn114_t9 AVDD_t210 AVDD_t209 sg13_lv_pmos ad=2.5364p pd=15.6u as=2.5364p ps=15.6u w=7.46u l=2u
X637 pn214 pn139 pn212_t10 AVDD_t138 sg13_lv_pmos ad=0.204p pd=1.88u as=0.204p ps=1.88u w=0.6u l=0.13u
X638 VGND_t376 VPWR_t155 VGND_t378 VGND_t377 sg13_lv_nmos ad=79.8f pd=0.8u as=0 ps=0 w=0.42u l=1u
X639 pn156_t2 pn84_t2 AVDD_t31 AVDD_t11 sg13_lv_pmos ad=0.68p pd=4.68u as=0.68p ps=4.68u w=2u l=2u
X640 pn84_t15 IBIAS_IA_t6 VGND VGND sg13_lv_nmos ad=0.34p pd=2.68u as=0.34p ps=2.68u w=1u l=2u
X641 pn129_t3 pn129_t2 VGND VGND sg13_lv_nmos ad=0.95p pd=5.38u as=3.6p ps=11.44u w=5u l=5u
X642 AVDD_t160 pn82_t36 pn82_t37 AVDD_t71 sg13_lv_pmos ad=0.3345p pd=2.9u as=0.1005p ps=1.34u w=0.15u l=0.15u
X643 pn40 pn51_t4 VGND_t117 VGND_t116 sg13_lv_nmos ad=0.1406p pd=1.12u as=0.14505p ps=1.15u w=0.74u l=0.13u
X644 pn223_t0 pn154_t3 VGND VGND sg13_lv_nmos ad=3.1314p pd=19.1u as=3.1314p ps=19.1u w=9.21u l=2u
X645 pn193 pn179_t1 VPWR_t147 VPWR_t0 sg13_lv_pmos ad=0.2128p pd=1.5u as=0.3808p ps=2.92u w=1.12u l=0.13u
X646 pn90_t0 pn170 VGND rhigh l=6.66u w=0.5u ps=0 b=0 m=1
X647 IBIAS_IA_t10 IBIAS_IA_t6 VGND VGND sg13_lv_nmos ad=0.34p pd=2.68u as=0.34p ps=2.68u w=1u l=2u
X648 pn181 pn6_t1 VPWR_t54 VPWR_t0 sg13_lv_pmos ad=0.2128p pd=1.5u as=0.3808p ps=2.92u w=1.12u l=0.13u
X649 pn56_t0 pn73_t1 VPWR_t124 VPWR_t5 sg13_lv_pmos ad=0.42p pd=2.99u as=0.2114p ps=1.54u w=1.12u l=0.13u
X650 pn228_t8 VOUT_t10 pn162_t3 AVDD_t79 sg13_lv_pmos ad=1.7p pd=10.68u as=0.95p ps=5.38u w=5u l=3u
X651 AVDD_t183 pn82_t32 pn175_t0 AVDD_t62 sg13_lv_pmos ad=0.3345p pd=2.9u as=0.1005p ps=1.34u w=0.15u l=0.15u
X652 VGND pn127 pn110_t9 VGND sg13_lv_nmos ad=3.6p pd=11.44u as=0.95p ps=5.38u w=5u l=3u
X653 VGND_t430 pn132_t2 pn73 VGND_t456 sg13_lv_nmos ad=0.14875p pd=1.16u as=0.187p ps=1.78u w=0.55u l=0.13u
X654 pn114_t12 pn114_t11 AVDD_t206 AVDD_t205 sg13_lv_pmos ad=2.5364p pd=15.6u as=2.5364p ps=15.6u w=7.46u l=2u
X655 VGND pn11_t1 pn77 VGND sg13_lv_nmos ad=0.2516p pd=2.16u as=0.2516p ps=2.16u w=0.74u l=0.13u
X656 VPWR_t104 pn50_t7 pn205 VPWR_t29 sg13_lv_pmos ad=0.2618p pd=1.63u as=0.2856p ps=2.36u w=0.84u l=0.13u
X657 pn220_t2 pn84_t0 AVDD_t19 AVDD_t17 sg13_lv_pmos ad=0.68p pd=4.68u as=0.68p ps=4.68u w=2u l=2u
X658 pn103_t1 pn103 VGND VGND sg13_lv_nmos ad=0.714p pd=4.88u as=0.714p ps=4.88u w=2.1u l=0.5u
X659 AVDD_t83 pn83_t10 pn228_t1 AVDD_t79 sg13_lv_pmos ad=0.3345p pd=2.9u as=0.1005p ps=1.34u w=0.15u l=0.15u
X660 IBIAS_IA_t5 IBIAS_IA_t0 VGND VGND sg13_lv_nmos ad=0.34p pd=2.68u as=0.34p ps=2.68u w=1u l=2u
X661 AVDD_t144 pn7_t1 pn138_t0 AVDD_t141 sg13_lv_pmos ad=0.3808p pd=2.92u as=0.3808p ps=2.92u w=1.12u l=0.13u
X662 pn149_t1 pn151 pn219_t6 AVDD_t71 sg13_lv_pmos ad=0.95p pd=5.38u as=1.7p ps=10.68u w=5u l=3u
X663 pn231 pn53_t3 pn230 AVDD_t0 sg13_lv_pmos ad=0.2128p pd=1.5u as=0.2464p ps=1.56u w=1.12u l=0.13u
X664 pn11_t0 pn27_t1 VPWR_t39 VPWR_t29 sg13_lv_pmos ad=0.42p pd=2.99u as=0.2114p ps=1.54u w=1.12u l=0.13u
X665 pn174 pn88_t0 VGND rhigh l=54u w=0.5u ps=0 b=0 m=1
X666 AVDD_t223 pn160_t4 pn153_t0 AVDD_t222 sg13_lv_pmos ad=1.955p pd=12.18u as=1.0925p ps=6.13u w=5.75u l=2u
X667 pn148_t2 VINN_t1 pn219 AVDD_t71 sg13_lv_pmos ad=0.95p pd=5.38u as=1.7p ps=10.68u w=5u l=3u
X668 pn114_t0 pn220_t10 VGND VGND sg13_lv_nmos ad=2.04p pd=12.68u as=2.04p ps=12.68u w=6u l=2u
X669 VGND_t40 pn184_t1 pn27 VGND_t39 sg13_lv_nmos ad=0.14875p pd=1.16u as=0.187p ps=1.78u w=0.55u l=0.13u
X670 pn166_t1 pn200_t1 AVDD_t78 AVDD_t77 sg13_lv_pmos ad=0.3808p pd=2.92u as=0.3808p ps=2.92u w=1.12u l=0.13u
X671 IBIAS_IA_t3 IBIAS_IA_t0 VGND VGND sg13_lv_nmos ad=0.34p pd=2.68u as=0.34p ps=2.68u w=1u l=2u
X672 pn8_t0 pn24_t1 VPWR_t50 VPWR_t29 sg13_lv_pmos ad=0.42p pd=2.99u as=0.2114p ps=1.54u w=1.12u l=0.13u
X673 pn194 pn51_t4 VPWR_t65 VPWR_t29 sg13_lv_pmos ad=0.2128p pd=1.5u as=0.2198p ps=1.53u w=1.12u l=0.13u
X674 pn120_t3 pn104_t5 AVDD_t185 AVDD_t51 sg13_lv_pmos ad=1.0545p pd=5.93u as=1.887p ps=11.78u w=5.55u l=0.5u
X675 VPWR_t4 VGND_t533 VPWR_t3 VPWR_t0 sg13_lv_pmos ad=0.19p pd=1.38u as=0 ps=0 w=1u l=1u
X676 AVDD_t74 pn9_t1 pn79_t0 AVDD_t73 sg13_lv_pmos ad=0.3808p pd=2.92u as=0.3808p ps=2.92u w=1.12u l=0.13u
X677 VGND_t59 pn60_t1 pn24 VGND_t263 sg13_lv_nmos ad=0.14875p pd=1.16u as=0.187p ps=1.78u w=0.55u l=0.13u
X678 pn10 pn26_t1 VGND_t85 VGND_t509 sg13_lv_nmos ad=0.2886p pd=2.26u as=0.14875p ps=1.16u w=0.74u l=0.13u
X679 pn38 pn203_t1 VGND_t87 VGND_t86 sg13_lv_nmos ad=0.1406p pd=1.12u as=0.17255p ps=1.25u w=0.74u l=0.13u
X680 pn220_t6 pn84_t2 AVDD_t27 AVDD_t6 sg13_lv_pmos ad=0.68p pd=4.68u as=0.68p ps=4.68u w=2u l=2u
X681 pn82_t19 IBIAS_IA_t6 VGND VGND sg13_lv_nmos ad=0.34p pd=2.68u as=0.34p ps=2.68u w=1u l=2u
X682 VGND pn9_t3 pn145_t1 VGND sg13_lv_nmos ad=0.1463p pd=1.15u as=0.2618p ps=2.22u w=0.77u l=0.13u
X683 pn176_t2 pn220_t11 VGND VGND sg13_lv_nmos ad=1.088p pd=7.08u as=1.088p ps=7.08u w=3.2u l=2u
X684 VPWR_t27 VGND_t552 VPWR_t56 VPWR_t5 sg13_lv_pmos ad=0.34p pd=2.68u as=0 ps=0 w=1u l=1u
X685 pn183 pn209_t2 VPWR_t143 VPWR_t29 sg13_lv_pmos ad=0.2128p pd=1.5u as=0.3808p ps=2.92u w=1.12u l=0.15u
X686 pn53 pn70_t1 VGND_t50 VGND_t56 sg13_lv_nmos ad=0.2886p pd=2.26u as=0.14875p ps=1.16u w=0.74u l=0.13u
X687 pn110_t0 pn82_t34 AVDD_t166 AVDD_t61 sg13_lv_pmos ad=0.1005p pd=1.34u as=0.3345p ps=2.9u w=0.15u l=0.15u
X688 pn178_t9 pn114_t19 AVDD_t197 AVDD_t196 sg13_lv_pmos ad=2.5364p pd=15.6u as=2.5364p ps=15.6u w=7.46u l=2u
X689 pn169_t0 pn168_t2 VGND VGND sg13_lv_nmos ad=0.2516p pd=2.16u as=0.2516p ps=2.16u w=0.74u l=0.13u
X690 pn209_t0 pn6_t5 VGND_t69 VGND_t68 sg13_lv_nmos ad=0.1406p pd=1.12u as=0.2516p ps=2.16u w=0.74u l=0.13u
X691 pn82_t30 IBIAS_IA_t6 VGND VGND sg13_lv_nmos ad=0.34p pd=2.68u as=0.34p ps=2.68u w=1u l=2u
X692 VCM_t0 pn96_t0 VGND rhigh l=17.84u w=0.5u ps=0 b=0 m=1
X693 pn141_t1 pn78_t1 pn212_t2 AVDD_t49 sg13_lv_pmos ad=0.1836p pd=1.76u as=0.1836p ps=1.76u w=0.54u l=0.13u
X694 pn177_t8 pn96_t1 pn127_t2 AVDD_t61 sg13_lv_pmos ad=1.7p pd=10.68u as=0.95p ps=5.38u w=5u l=3u
X695 AVDD_t180 pn82_t32 pn175_t3 AVDD_t62 sg13_lv_pmos ad=0.3345p pd=2.9u as=0.1005p ps=1.34u w=0.15u l=0.15u
X696 VPWR_t16 VGND_t546 VPWR_t15 VPWR_t0 sg13_lv_pmos ad=0.19p pd=1.38u as=0 ps=0 w=1u l=1u
X697 pn35_t1 pn51_t5 VGND_t54 VGND_t118 sg13_lv_nmos ad=0.2618p pd=2.22u as=0.1463p ps=1.15u w=0.77u l=0.13u
X698 pn223_t2 VCM_t4 pn221_t10 AVDD_t3 sg13_lv_pmos ad=1.2616p pd=7.02u as=1.2616p ps=7.02u w=6.64u l=2u
X699 VPWR_t12 VGND_t553 VPWR_t11 VPWR_t5 sg13_lv_pmos ad=0.19p pd=1.38u as=0 ps=0 w=1u l=1u
X700 VGND pn10_t3 pn146_t0 VGND sg13_lv_nmos ad=0.2516p pd=2.16u as=0.1406p ps=1.12u w=0.74u l=0.13u
X701 pn82_t6 IBIAS_IA_t0 VGND VGND sg13_lv_nmos ad=0.34p pd=2.68u as=0.34p ps=2.68u w=1u l=2u
X702 VPWR_t37 pn202_t1 pn31_t0 VPWR_t29 sg13_lv_pmos ad=0.2114p pd=1.54u as=0.2856p ps=2.36u w=0.84u l=0.13u
X703 pn180 pn51_t1 pn179 VPWR_t0 sg13_lv_pmos ad=0.1176p pd=1.33u as=0.3808p ps=2.92u w=1.12u l=0.13u
X704 VGND_t386 VPWR_t153 VGND_t385 VGND_t384 sg13_lv_nmos ad=0.1428p pd=1.52u as=0 ps=0 w=0.42u l=1u
X705 pn228_t6 pn87_t3 pn229_t1 AVDD_t63 sg13_lv_pmos ad=1.7p pd=10.68u as=0.95p ps=5.38u w=5u l=3u
X706 pn147_t0 pn146 AVDD_t137 AVDD_t57 sg13_lv_pmos ad=0.1596p pd=1.22u as=0.1918p ps=1.5u w=0.84u l=0.13u
X707 AVDD_t59 pn11_t1 pn77_t0 AVDD_t58 sg13_lv_pmos ad=0.3808p pd=2.92u as=0.3808p ps=2.92u w=1.12u l=0.13u
X708 VPWR_t36 pn119 pn28_t0 VPWR_t29 sg13_lv_pmos ad=0.2114p pd=1.54u as=0.2856p ps=2.36u w=0.84u l=0.13u
X709 pn87 pn86_t2 VGND VGND sg13_lv_nmos ad=2.856p pd=17.48u as=2.856p ps=17.48u w=8.4u l=0.5u
X710 VGND pn91_t1 pn94 VGND sg13_lv_nmos ad=0.1331p pd=1.12u as=0.1216p ps=1.02u w=0.64u l=0.13u
X711 AVDD_t151 pn82_t36 pn150_t4 AVDD_t71 sg13_lv_pmos ad=0.3345p pd=2.9u as=0.1005p ps=1.34u w=0.15u l=0.15u
X712 pn2_t1 pn212_t12 pn178_t8 AVDD_t56 sg13_lv_pmos ad=1.2616p pd=7.02u as=2.2576p ps=13.96u w=6.64u l=2u
X713 pn13 pn29_t1 VGND_t497 VGND_t508 sg13_lv_nmos ad=0.2886p pd=2.26u as=0.14875p ps=1.16u w=0.74u l=0.13u
X714 pn192 pn203_t1 VPWR_t60 VPWR_t0 sg13_lv_pmos ad=0.1176p pd=1.33u as=0.2618p ps=1.63u w=1.12u l=0.13u
X715 AVDD_t147 pn82_t36 pn150_t3 AVDD_t71 sg13_lv_pmos ad=0.3345p pd=2.9u as=0.1005p ps=1.34u w=0.15u l=0.15u
X716 pn152 pn148_t0 VGND rhigh l=1.95u w=0.5u ps=0 b=0 m=1
X717 VGND pn97 pn100_t9 VGND sg13_lv_nmos ad=0.95p pd=5.38u as=0.95p ps=5.38u w=5u l=3u
R0 pn95 pn95_t0 51.8954
R1 pn103_n0 pn103_t0 17.8873
R2 pn103 pn103_n0 15.3273
R3 pn103_n0 pn103_t1 2.94685
R4 pn98_n2 pn98_n1 20.4994
R5 pn98 pn98_n0 7.46769
R6 pn98_n4 pn98_n3 6.49706
R7 pn98_n1 pn98_t3 5.69814
R8 pn98 pn98_n0 4.06269
R9 pn98_n1 pn98_t4 3.79957
R10 pn98_n2 pn98_t1 2.37994
R11 pn98 pn98_n4 1.71109
R12 pn98_n3 pn98_n2 1.44439
R13 pn98_n3 pn98_t0 0.998763
R14 pn98_n4 pn98_n0 0.649379
R15 pn97_n2 pn97_t0 20.2699
R16 pn97 pn97_n2 14.7447
R17 pn97_n1 pn97_t3 12.3766
R18 pn97_n1 pn97_n0 10.4592
R19 pn97_n0 pn97_t2 5.69696
R20 pn97_n0 pn97_t1 3.79898
R21 pn97_n2 pn97_n1 2.6427
R22 pn105 pn105_t0 28.9863
R23 pn175_n4 pn175_t3 17.0005
R24 pn175_n3 pn175_t2 17.0005
R25 pn175_n2 pn175_t1 17.0005
R26 pn175_n1 pn175_t0 17.0005
R27 pn175 pn175_n7 7.13857
R28 pn175_n0 pn175_t8 7.13531
R29 pn175_n7 pn175_n6 4.648
R30 pn175_n5 pn175_t6 2.48767
R31 pn175_n0 pn175_t7 2.48764
R32 pn175_n6 pn175_t5 2.48758
R33 pn175_n7 pn175_t4 2.4875
R34 pn175_n6 pn175_n5 2.31737
R35 pn175_n1 pn175_n0 2.29383
R36 pn175_n5 pn175_n4 1.14571
R37 pn175_n4 pn175_n3 0.043
R38 pn175_n3 pn175_n2 0.043
R39 pn175_n2 pn175_n1 0.043
R40 pn100_n9 pn100_t8 45.066
R41 pn100 pn100_n9 20.3084
R42 pn100_n0 pn100_t0 17.3511
R43 pn100_n6 pn100_t7 17.0005
R44 pn100_n5 pn100_t6 17.0005
R45 pn100_n4 pn100_t4 17.0005
R46 pn100_n3 pn100_t1 17.0005
R47 pn100_n2 pn100_t5 17.0005
R48 pn100_n1 pn100_t3 17.0005
R49 pn100_n0 pn100_t2 17.0005
R50 pn100_n7 pn100_n6 10.7841
R51 pn100_n9 pn100_n8 6.66603
R52 pn100_n8 pn100_t9 3.07834
R53 pn100_n7 pn100_t10 2.48503
R54 pn100_n8 pn100_n7 0.606387
R55 pn100_n6 pn100_n5 0.351125
R56 pn100_n5 pn100_n4 0.351125
R57 pn100_n4 pn100_n3 0.351125
R58 pn100_n3 pn100_n2 0.351125
R59 pn100_n2 pn100_n1 0.351125
R60 pn100_n1 pn100_n0 0.351125
R61 pn108_n0 pn108_t1 18.0747
R62 pn108 pn108_n0 16.3377
R63 pn108_n0 pn108_t0 0.703075
R64 pn99_n3 pn99_n2 22.354
R65 pn99_n2 pn99_n0 14.2797
R66 pn99 pn99_n3 6.97281
R67 pn99_n3 pn99_t4 6.15134
R68 pn99_n1 pn99_t0 5.64649
R69 pn99_n0 pn99_t2 3.66293
R70 pn99_n0 pn99_t3 3.53937
R71 pn99_n2 pn99_n1 2.93535
R72 pn99_n1 pn99_t1 0.193614
R73 VINP_n0 VINP_t0 44.4499
R74 VINP_n0 VINP_t1 35.7248
R75 VINP VINP_n0 2.1708
R76 pn113_n1 pn113_t0 17.0005
R77 pn113_n0 pn113_t2 17.0005
R78 pn113 pn113_n1 5.26421
R79 pn113_n0 pn113_t1 5.26209
R80 pn113_n1 pn113_n0 0.410885
R81 pn1_n1 pn1_n0 21.5278
R82 pn1 pn1_n1 3.90257
R83 pn1_n0 pn1_t1 3.53948
R84 pn1_n0 pn1_t2 2.48724
R85 pn1_n1 pn1_t0 1.1658
R86 pn3 pn3_n1 23.0356
R87 pn3_n0 pn3_t2 5.15494
R88 pn3_n0 pn3_t0 4.5618
R89 pn3_n1 pn3_t1 1.82622
R90 pn3_n1 pn3_n0 0.5912
R91 pn106_n1 pn106_t2 65.8274
R92 pn106 pn106_n1 63.1062
R93 pn106_n1 pn106_n0 23.8719
R94 pn106_n0 pn106_t0 15.2505
R95 pn106_n0 pn106_t1 8.50305
R96 pn101_n1 pn101_t0 47.2307
R97 pn101_n2 pn101_n1 37.4277
R98 pn101 pn101_n2 6.78892
R99 pn101_n2 pn101_t3 6.4752
R100 pn101_n0 pn101_t2 4.23857
R101 pn101_n0 pn101_t1 4.2251
R102 pn101_n1 pn101_n0 1.85896
R103 pn109_n1 pn109_t0 25.9904
R104 pn109_t4 pn109_n7 15.4265
R105 pn109_n1 pn109_n0 12.9235
R106 pn109_n7 pn109_n6 9.44417
R107 pn109_n3 pn109_n2 9.07539
R108 pn109_n4 pn109_n2 9.05326
R109 pn109_n6 pn109_n5 9.0005
R110 pn109_n9 pn109_t4 7.15961
R111 pn109 pn109_n9 5.80793
R112 pn109_n4 pn109_t3 5.0034
R113 pn109_t3 pn109_n3 4.99428
R114 pn109_n0 pn109_t2 3.79089
R115 pn109_n0 pn109_t1 2.48849
R116 pn109_n9 pn109_n8 2.47027
R117 pn109_n7 pn109_n1 0.648767
R118 pn109_n5 pn109_n3 0.108864
R119 pn109_n5 pn109_n4 0.0942444
R120 pn109_n6 pn109_n2 0.00343333
R121 pn109_n8 pn109_t5 0.00174998
R122 pn109_n8 pn109_t6 0.00124997
R123 pn177_n4 pn177_t6 17.0005
R124 pn177_n3 pn177_t5 17.0005
R125 pn177_n2 pn177_t3 17.0005
R126 pn177_n1 pn177_t4 17.0005
R127 pn177 pn177_n7 7.13167
R128 pn177_n0 pn177_t1 7.13144
R129 pn177_n7 pn177_n6 4.648
R130 pn177_n7 pn177_t7 2.48419
R131 pn177_n6 pn177_t8 2.48391
R132 pn177_n0 pn177_t0 2.48313
R133 pn177_n5 pn177_t2 2.48281
R134 pn177_n6 pn177_n5 2.31737
R135 pn177_n1 pn177_n0 2.29383
R136 pn177_n5 pn177_n4 1.14571
R137 pn177_n4 pn177_n3 0.043
R138 pn177_n3 pn177_n2 0.043
R139 pn177_n2 pn177_n1 0.043
R140 pn96 pn96_n0 48.6233
R141 pn96_n0 pn96_t0 19.5288
R142 pn96_n0 pn96_t1 17
R143 pn126_n1 pn126_t0 17.0005
R144 pn126_n0 pn126_t2 17.0005
R145 pn126_n0 pn126_t1 5.26499
R146 pn126 pn126_n1 5.25786
R147 pn126_n1 pn126_n0 0.410885
R148 pn129_n1 pn129_n0 20.4994
R149 pn129 pn129_n2 7.62305
R150 pn129_n0 pn129_t0 5.70137
R151 pn129_n0 pn129_t1 3.8035
R152 pn129_n1 pn129_t3 2.37709
R153 pn129_n2 pn129_n1 1.44439
R154 pn129_n2 pn129_t2 0.998763
R155 pn110 pn110_n9 25.6277
R156 pn110_n9 pn110_t10 19.5476
R157 pn110_n0 pn110_t3 17.3511
R158 pn110_n6 pn110_t7 17.0005
R159 pn110_n5 pn110_t6 17.0005
R160 pn110_n4 pn110_t4 17.0005
R161 pn110_n3 pn110_t1 17.0005
R162 pn110_n2 pn110_t2 17.0005
R163 pn110_n1 pn110_t5 17.0005
R164 pn110_n0 pn110_t0 17.0005
R165 pn110_n7 pn110_n6 10.7841
R166 pn110_n9 pn110_n8 6.71396
R167 pn110_n8 pn110_t8 3.07511
R168 pn110_n7 pn110_t9 2.48104
R169 pn110_n8 pn110_n7 0.606387
R170 pn110_n6 pn110_n5 0.351125
R171 pn110_n5 pn110_n4 0.351125
R172 pn110_n4 pn110_n3 0.351125
R173 pn110_n3 pn110_n2 0.351125
R174 pn110_n2 pn110_n1 0.351125
R175 pn110_n1 pn110_n0 0.351125
R176 pn127_n2 pn127_t3 20.2699
R177 pn127 pn127_n2 14.7447
R178 pn127_n1 pn127_t0 12.3739
R179 pn127_n1 pn127_n0 10.4592
R180 pn127_n0 pn127_t2 5.70086
R181 pn127_n0 pn127_t1 3.80369
R182 pn127_n2 pn127_n1 2.6427
R183 pn176_n2 pn176_n1 37.3562
R184 pn176_n1 pn176_t2 35.7232
R185 pn176_n0 pn176_t3 24.0005
R186 pn176_n0 pn176_t0 13.562
R187 pn176_n1 pn176_n0 4.80997
R188 pn176 pn176_n2 0.00175055
R189 pn176_n2 pn176_t1 0.00124943
R190 pn111 pn111_n1 95.3284
R191 pn111_n1 pn111_n0 20.1156
R192 pn111_n1 pn111_t2 16.1539
R193 pn111_n0 pn111_t0 15.0005
R194 pn111_n0 pn111_t1 3.64475
R195 pn104_n0 pn104_t3 44.5226
R196 pn104_n3 pn104_t0 27.6562
R197 pn104 pn104_n4 24.3167
R198 pn104_n4 pn104_t4 23.4613
R199 pn104_n2 pn104_t2 21.8383
R200 pn104_n2 pn104_n1 20.8686
R201 pn104_n1 pn104_n0 19.9402
R202 pn104_n0 pn104_t5 11.4058
R203 pn104_n1 pn104_t1 4.69053
R204 pn104_n3 pn104_n2 0.523367
R205 pn104_n4 pn104_n3 0.391367
R206 pn2 pn2_n1 25.8154
R207 pn2_n1 pn2_n0 23.5569
R208 pn2_n0 pn2_t2 2.66122
R209 pn2_n0 pn2_t1 1.61057
R210 pn2_n1 pn2_t0 1.17748
R211 pn178 pn178_n21 17.0005
R212 pn178 pn178_n9 17.0005
R213 pn178 pn178_n8 17.0005
R214 pn178 pn178_n7 17.0005
R215 pn178 pn178_n6 17.0005
R216 pn178 pn178_n5 17.0005
R217 pn178 pn178_n4 17.0005
R218 pn178 pn178_n3 17.0005
R219 pn178 pn178_n2 17.0005
R220 pn178 pn178_n1 17.0005
R221 pn178_n14 pn178_n13 15.89
R222 pn178_n13 pn178_n12 11.3042
R223 pn178 pn178_n0 8.44211
R224 pn178_n12 pn178_t2 5.50201
R225 pn178_n12 pn178_t0 5.50133
R226 pn178_n10 pn178_t6 5.41606
R227 pn178_n10 pn178_t8 5.41584
R228 pn178 pn178_n0 2.66231
R229 pn178_n14 pn178_t4 2.26564
R230 pn178_n21 pn178_n20 2.21425
R231 pn178_n19 pn178_t3 2.136
R232 pn178_n18 pn178_t12 2.13534
R233 pn178_n15 pn178_t11 2.13489
R234 pn178_n20 pn178_t5 2.13449
R235 pn178_n16 pn178_t9 2.13444
R236 pn178_n17 pn178_t10 2.13429
R237 pn178_n20 pn178_n19 1.98738
R238 pn178_n19 pn178_n18 1.98738
R239 pn178_n18 pn178_n17 1.98738
R240 pn178_n17 pn178_n16 1.98738
R241 pn178_n16 pn178_n15 1.98738
R242 pn178_n12 pn178_t1 1.72608
R243 pn178_n13 pn178_n11 1.6462
R244 pn178_n15 pn178_n14 1.38512
R245 pn178_n11 pn178_t7 1.17428
R246 pn178_n11 pn178_n10 0.400457
R247 pn178_n1 pn178_n0 0.352522
R248 pn178_n5 pn178_n4 0.237688
R249 pn178_n21 pn178_n9 0.23425
R250 pn178_n9 pn178_n8 0.23425
R251 pn178_n8 pn178_n7 0.23425
R252 pn178_n7 pn178_n6 0.23425
R253 pn178_n6 pn178_n5 0.23425
R254 pn178_n4 pn178_n3 0.23425
R255 pn178_n3 pn178_n2 0.23425
R256 pn178_n2 pn178_n1 0.23425
R257 pn114_n8 pn114_t0 48.9993
R258 pn114_n7 pn114_t15 4.95984
R259 pn114_n9 pn114_t15 4.95984
R260 pn114_n0 pn114_t14 4.12278
R261 pn114_n6 pn114_n5 3.81754
R262 pn114_n17 pn114_n16 3.36038
R263 pn114 pn114_n23 3.20298
R264 pn114_n17 pn114_t17 2.42277
R265 pn114_n16 pn114_t13 2.42272
R266 pn114_n23 pn114_t23 2.41279
R267 pn114_n22 pn114_t22 2.41279
R268 pn114_n21 pn114_t21 2.41279
R269 pn114_n20 pn114_t20 2.41279
R270 pn114_n19 pn114_t19 2.41279
R271 pn114_n18 pn114_t18 2.41279
R272 pn114_n15 pn114_t7 2.41279
R273 pn114_n14 pn114_t11 2.41279
R274 pn114_n13 pn114_t5 2.41279
R275 pn114_n12 pn114_t9 2.41279
R276 pn114_n11 pn114_t1 2.41279
R277 pn114_n10 pn114_t3 2.41279
R278 pn114_n7 pn114_n6 2.36688
R279 pn114_n4 pn114_t2 2.13574
R280 pn114_n5 pn114_t4 2.13557
R281 pn114_n2 pn114_t6 2.13537
R282 pn114_n1 pn114_t12 2.13524
R283 pn114_n3 pn114_t10 2.13484
R284 pn114_n0 pn114_t8 2.13445
R285 pn114_n1 pn114_n0 1.98738
R286 pn114_n2 pn114_n1 1.98738
R287 pn114_n3 pn114_n2 1.98738
R288 pn114_n4 pn114_n3 1.98738
R289 pn114_n5 pn114_n4 1.98738
R290 pn114_n23 pn114_n22 0.790191
R291 pn114_n22 pn114_n21 0.790191
R292 pn114_n21 pn114_n20 0.790191
R293 pn114_n20 pn114_n19 0.790191
R294 pn114_n19 pn114_n18 0.790191
R295 pn114_n15 pn114_n14 0.790191
R296 pn114_n14 pn114_n13 0.790191
R297 pn114_n13 pn114_n12 0.790191
R298 pn114_n12 pn114_n11 0.790191
R299 pn114_n11 pn114_n10 0.790191
R300 pn114_n16 pn114_n15 0.778958
R301 pn114_n18 pn114_n17 0.777179
R302 pn114_n10 pn114_n9 0.652195
R303 pn114_n6 pn114_t16 0.306077
R304 pn114_n8 pn114_n7 0.188087
R305 pn114_n9 pn114_n8 0.0942483
R306 pn138 pn138_n0 16.9681
R307 pn138_n0 pn138_t1 8.72848
R308 pn138_n0 pn138_t0 5.99445
R309 pn139 pn139_n0 17.1579
R310 pn139_n0 pn139_t1 8.73326
R311 pn139_n0 pn139_t0 5.98966
R312 pn79_n0 pn79_t1 17.1716
R313 pn79 pn79_n0 8.69261
R314 pn79_n0 pn79_t0 6.03031
R315 pn78_n0 pn78_t1 17.1716
R316 pn78 pn78_n0 8.69261
R317 pn78_n0 pn78_t0 6.03031
R318 pn212_n22 pn212_n21 47.3
R319 pn212_n15 pn212_n14 46.2417
R320 pn212_n17 pn212_n16 46.1848
R321 pn212_n21 pn212_n20 46.1641
R322 pn212_n19 pn212_n18 46.1641
R323 pn212_n13 pn212_n12 18.8794
R324 pn212_n12 pn212_t3 17.9905
R325 pn212_n14 pn212_t6 17.853
R326 pn212_n16 pn212_t5 17.7564
R327 pn212_n20 pn212_t0 17.6189
R328 pn212_n18 pn212_t1 17.6189
R329 pn212_n22 pn212_t4 17.6189
R330 pn212_n16 pn212_t10 17.5436
R331 pn212_n11 pn212_n10 17.5169
R332 pn212 pn212_n22 17.3993
R333 pn212_n20 pn212_t2 17.3993
R334 pn212_n18 pn212_t7 17.3993
R335 pn212_n11 pn212_t8 15.0012
R336 pn212_n15 pn212_n13 10.9033
R337 pn212_n5 pn212_n4 9.05448
R338 pn212_n7 pn212_n6 9.0476
R339 pn212_n1 pn212_n0 9.0335
R340 pn212_n8 pn212_n0 9.03277
R341 pn212_n10 pn212_n9 9.0005
R342 pn212_n8 pn212_n7 9.0005
R343 pn212_n4 pn212_n1 9.0005
R344 pn212_n9 pn212_n2 9.0005
R345 pn212_n3 pn212_n2 9.0005
R346 pn212_n14 pn212_t9 8.91864
R347 pn212_n6 pn212_t12 7.4777
R348 pn212_t12 pn212_n5 7.4777
R349 pn212_n12 pn212_t11 6.3601
R350 pn212_n19 pn212_n17 4.25237
R351 pn212_n13 pn212_n11 3.02307
R352 pn212_n17 pn212_n15 2.10223
R353 pn212_n21 pn212_n19 1.19803
R354 pn212_n6 pn212_n3 0.0971047
R355 pn212_n5 pn212_n3 0.0916048
R356 pn212_n9 pn212_n1 0.0775
R357 pn212_n4 pn212_n2 0.0775
R358 pn212_n9 pn212_n8 0.0767667
R359 pn212_n7 pn212_n2 0.0767667
R360 pn212_n10 pn212_n0 0.00196667
R361 pn77_n0 pn77_t1 17.1716
R362 pn77 pn77_n0 8.69261
R363 pn77_n0 pn77_t0 6.03031
R364 pn140 pn140_n0 17.0396
R365 pn140_n0 pn140_t1 8.70696
R366 pn140_n0 pn140_t0 6.01597
R367 pn128 pn128_n1 48.5
R368 pn128_n0 pn128_t0 17.0005
R369 pn128_n1 pn128_t2 15.0005
R370 pn128_n0 pn128_t1 7.48717
R371 pn128_n1 pn128_n0 0.4295
R372 pn215_n1 pn215_t0 17.0005
R373 pn215_n0 pn215_t2 15.2123
R374 pn215_n0 pn215_t1 15.006
R375 pn215 pn215_n1 9.87426
R376 pn215_n1 pn215_n0 0.435
R377 pn214 pn214_n1 18.4133
R378 pn214_n1 pn214_t0 17.0005
R379 pn214_n0 pn214_t2 15.1472
R380 pn214_n0 pn214_t1 15.0647
R381 pn214_n1 pn214_n0 0.435
R382 pn213_n0 pn213_t1 19.0109
R383 pn213 pn213_n1 17.8908
R384 pn213_n1 pn213_t0 17.1518
R385 pn213_n0 pn213_t2 15.2242
R386 pn213_n1 pn213_n0 0.452417
R387 pn141_n0 pn141_t0 18.2277
R388 pn141_n0 pn141_t1 17.0005
R389 pn141_n1 pn141_t2 15.2572
R390 pn141 pn141_n1 15.0005
R391 pn141_n1 pn141_n0 5.803
R392 pn142 pn142_t0 30.2572
R393 pn144 pn144_n0 37.7132
R394 pn144_n0 pn144_t1 17.7155
R395 pn144_n0 pn144_t0 17.3271
R396 pn80_n1 pn80_n0 48.5119
R397 pn80_n0 pn80_t2 25.106
R398 pn80_n0 pn80_t1 24.8013
R399 pn80 pn80_n1 8.54725
R400 pn80_n1 pn80_t0 6.14002
R401 pn145 pn145_n1 27.7006
R402 pn145_n0 pn145_t1 9.08096
R403 pn145_n0 pn145_t0 8.55846
R404 pn145_n1 pn145_t2 5.66872
R405 pn145_n1 pn145_n0 1.19484
R406 pn146 pn146_n0 34.0955
R407 pn146_n0 pn146_t0 9.41086
R408 pn146_n0 pn146_t1 5.73212
R409 pn147_n0 pn147_t1 17.5197
R410 pn147 pn147_n0 15.4519
R411 pn147_n0 pn147_t0 8.76789
R412 pn16 pn16_t0 14.8745
R413 pn14 pn14_t0 14.8745
R414 pn13 pn13_t0 14.8752
R415 pn12 pn12_t0 14.8752
R416 pn11_n3 pn11_n2 152.661
R417 pn11_n2 pn11_n1 65.8798
R418 pn11_n0 pn11_t1 34.6215
R419 pn11_n2 pn11_t4 33.4862
R420 pn11_n0 pn11_t2 15.0005
R421 pn11 pn11_n3 8.48259
R422 pn11_n3 pn11_t0 6.39367
R423 pn11_n1 pn11_t3 4.49609
R424 pn11_n1 pn11_n0 0.618163
R425 pn10_n2 pn10_n1 153.043
R426 pn10_n1 pn10_n0 47.7155
R427 pn10_n0 pn10_t1 33.638
R428 pn10_n1 pn10_t3 33.6062
R429 pn10_n0 pn10_t2 15.9878
R430 pn10 pn10_n2 8.48259
R431 pn10_n2 pn10_t0 6.39367
R432 pn4 pn4_t0 17.6419
R433 pn9_n2 pn9_n1 154.429
R434 pn9_n1 pn9_n0 63.3186
R435 pn9_n0 pn9_t1 34.6239
R436 pn9_n1 pn9_t3 33.7314
R437 pn9_n0 pn9_t2 15.0019
R438 pn9 pn9_n2 8.48259
R439 pn9_n2 pn9_t0 6.39367
R440 pn8_n2 pn8_n1 154.867
R441 pn8_n1 pn8_n0 40.9424
R442 pn8_n0 pn8_t1 34.7523
R443 pn8_n1 pn8_t3 33.8528
R444 pn8_n0 pn8_t2 15.0005
R445 pn8 pn8_n2 8.48259
R446 pn8_n2 pn8_t0 6.39367
R447 pn7_n2 pn7_n1 156.138
R448 pn7_n1 pn7_t3 35.2795
R449 pn7_n0 pn7_t1 33.748
R450 pn7_n1 pn7_n0 20.1299
R451 pn7_n0 pn7_t2 16.0111
R452 pn7 pn7_n2 8.48259
R453 pn7_n2 pn7_t0 6.39367
R454 pn32 pn32_n0 17.4551
R455 pn32_n0 pn32_t1 15.0005
R456 pn32_n0 pn32_t0 9.342
R457 pn31 pn31_n0 17.4551
R458 pn31_n0 pn31_t1 15.0005
R459 pn31_n0 pn31_t0 9.342
R460 pn30 pn30_n0 17.4551
R461 pn30_n0 pn30_t1 15.0005
R462 pn30_n0 pn30_t0 9.342
R463 pn29 pn29_n0 17.4551
R464 pn29_n0 pn29_t1 15.0005
R465 pn29_n0 pn29_t0 9.342
R466 pn28 pn28_n0 17.4551
R467 pn28_n0 pn28_t1 15.0005
R468 pn28_n0 pn28_t0 9.342
R469 pn27 pn27_n0 17.4551
R470 pn27_n0 pn27_t1 15.0005
R471 pn27_n0 pn27_t0 9.342
R472 pn26 pn26_n0 17.4551
R473 pn26_n0 pn26_t1 15.0005
R474 pn26_n0 pn26_t0 9.342
R475 pn25 pn25_n0 17.4551
R476 pn25_n0 pn25_t1 15.0005
R477 pn25_n0 pn25_t0 9.342
R478 pn24 pn24_n0 17.4551
R479 pn24_n0 pn24_t1 15.0005
R480 pn24_n0 pn24_t0 9.342
R481 pn23 pn23_n0 17.4551
R482 pn23_n0 pn23_t1 15.0005
R483 pn23_n0 pn23_t0 9.342
R484 pn184_n0 pn184_t1 56.2363
R485 pn184_n0 pn184_t0 8.59621
R486 pn184 pn184_n0 6.54263
R487 pn18_n0 pn18_t1 54.3066
R488 pn18 pn18_n0 8.82792
R489 pn18_n0 pn18_t0 6.08575
R490 pn22 pn22_n0 17.4551
R491 pn22_n0 pn22_t1 15.0005
R492 pn22_n0 pn22_t0 9.342
R493 gain_sel[0] gain_sel[0]_t0 56.3979
R494 pn21 pn21_n0 17.4551
R495 pn21_n0 pn21_t1 15.0005
R496 pn21_n0 pn21_t0 9.342
R497 gain_sel[1] gain_sel[1]_t0 46.5563
R498 pn119 pn119_n0 57.4756
R499 pn119_n0 pn119_t0 9.90675
R500 pn119_n0 pn119_t1 8.48515
R501 pn202_n0 pn202_t1 34.3504
R502 pn202_n0 pn202_t0 9.04787
R503 pn202 pn202_n0 5.64125
R504 pn208_n0 pn208_t0 17.9742
R505 pn208_n0 pn208_t1 15.0005
R506 pn208 pn208_n0 9.49602
R507 pn33 pn33_n0 17.5197
R508 pn33_n0 pn33_t1 15.4519
R509 pn33_n0 pn33_t0 8.76789
R510 pn118 pn118_n0 61.7949
R511 pn118_n0 pn118_t0 9.10445
R512 pn118_n0 pn118_t1 5.97331
R513 pn185 pn185_t0 17.5315
R514 pn122_n0 pn122_t0 17.4067
R515 pn122 pn122_n0 15.0005
R516 pn122_n0 pn122_t1 9.09953
R517 pn198 pn198_t0 14.8755
R518 pn199_n0 pn199_t0 17.4569
R519 pn199_n0 pn199_t1 15.0005
R520 pn199 pn199_n0 9.34201
R521 pn197_n0 pn197_t0 17.4569
R522 pn197_n0 pn197_t1 15.0005
R523 pn197 pn197_n0 9.34201
R524 pn207_n0 pn207_t0 17.9742
R525 pn207_n0 pn207_t1 15.0005
R526 pn207 pn207_n0 9.49602
R527 pn189_n1 pn189_n0 18.4229
R528 pn189_n0 pn189_t2 17.0702
R529 pn189_n0 pn189_t1 15.066
R530 pn189_n1 pn189_t0 8.82891
R531 pn189 pn189_n1 6.08509
R532 pn206_n0 pn206_t0 17.4067
R533 pn206_n0 pn206_t1 15.0005
R534 pn206 pn206_n0 9.09953
R535 pn194_n0 pn194_t1 36.5214
R536 pn194 pn194_n0 9.90675
R537 pn194_n0 pn194_t0 8.48515
R538 pn188_n0 pn188_t1 59.2166
R539 pn188_n0 pn188_t0 9.30223
R540 pn188 pn188_n0 5.61278
R541 pn186_n1 pn186_t3 60.4543
R542 pn186_n1 pn186_t2 33.8175
R543 pn186_n2 pn186_n1 23.5776
R544 pn186_n0 pn186_t1 9.43962
R545 pn186_n0 pn186_t0 6.00967
R546 pn186 pn186_n2 5.63096
R547 pn186_n2 pn186_n0 0.276412
R548 pn205_n0 pn205_t0 17.4067
R549 pn205_n0 pn205_t1 15.0005
R550 pn205 pn205_n0 9.09953
R551 pn204_n0 pn204_t0 17.9742
R552 pn204_n0 pn204_t1 15.0005
R553 pn204 pn204_n0 9.49602
R554 pn121 pn121_n1 41.1831
R555 pn121_n1 pn121_t2 36.4939
R556 pn121_n1 pn121_n0 18.0448
R557 pn121_n0 pn121_t1 9.2295
R558 pn121_n0 pn121_t0 5.67687
R559 pn203_n0 pn203_t0 17.4067
R560 pn203_n0 pn203_t1 15.0005
R561 pn203 pn203_n0 9.09953
R562 pn179_n0 pn179_t1 44.9827
R563 pn179_n0 pn179_t2 25.4931
R564 pn179_n1 pn179_n0 9.18226
R565 pn179_n1 pn179_t0 9.14407
R566 pn179 pn179_n1 5.97115
R567 pn35_n3 pn35_n2 45.2192
R568 pn35_n0 pn35_t3 34.0908
R569 pn35_n0 pn35_t4 33.0207
R570 pn35_n2 pn35_t2 24.029
R571 pn35_n1 pn35_t5 24.0183
R572 pn35_n1 pn35_n0 9.6341
R573 pn35_n4 pn35_t1 9.07996
R574 pn35 pn35_n4 8.55847
R575 pn35_n3 pn35_t0 5.75815
R576 pn35_n2 pn35_n1 2.01266
R577 pn35_n4 pn35_n3 1.107
R578 pn187_n0 pn187_t1 34.7746
R579 pn187_n0 pn187_t0 9.30223
R580 pn187 pn187_n0 5.61278
R581 pn59 pn59_t0 14.8745
R582 pn58 pn58_t0 14.8745
R583 pn57 pn57_t0 14.8745
R584 pn56 pn56_t0 14.8745
R585 pn52 pn52_t0 14.8752
R586 pn76 pn76_n0 17.4551
R587 pn76_n0 pn76_t1 15.0005
R588 pn76_n0 pn76_t0 9.342
R589 pn182_n0 pn182_t1 56.1789
R590 pn182_n0 pn182_t0 9.30231
R591 pn182 pn182_n0 5.60405
R592 pn75 pn75_n0 17.4551
R593 pn75_n0 pn75_t1 15.0005
R594 pn75_n0 pn75_t0 9.342
R595 pn74 pn74_n0 17.4551
R596 pn74_n0 pn74_t1 15.0005
R597 pn74_n0 pn74_t0 9.342
R598 pn73 pn73_n0 17.4551
R599 pn73_n0 pn73_t1 15.0005
R600 pn73_n0 pn73_t0 9.342
R601 pn72 pn72_n0 17.4551
R602 pn72_n0 pn72_t1 15.0005
R603 pn72_n0 pn72_t0 9.342
R604 pn71 pn71_n0 17.4551
R605 pn71_n0 pn71_t1 15.0005
R606 pn71_n0 pn71_t0 9.342
R607 pn70 pn70_n0 17.4551
R608 pn70_n0 pn70_t1 15.0005
R609 pn70_n0 pn70_t0 9.342
R610 pn69 pn69_n0 17.4551
R611 pn69_n0 pn69_t1 15.0005
R612 pn69_n0 pn69_t0 9.342
R613 pn48_n0 pn48_t1 55.1685
R614 pn48 pn48_n0 9.33661
R615 pn48_n0 pn48_t0 8.51611
R616 pn42_n1 pn42_t1 34.8153
R617 pn42_n2 pn42_t3 33.2409
R618 pn42_n0 pn42_t4 25.6539
R619 pn42_n0 pn42_t2 24.2165
R620 pn42_n3 pn42_n2 20.2093
R621 pn42_n1 pn42_n0 9.0005
R622 pn42 pn42_n3 8.82142
R623 pn42_n3 pn42_t0 6.22982
R624 pn42_n2 pn42_n1 0.6341
R625 pn38_n0 pn38_t1 36.5073
R626 pn38_n0 pn38_t3 33.7617
R627 pn38_n2 pn38_n1 28.233
R628 pn38_n1 pn38_t2 24.0255
R629 pn38_n1 pn38_n0 17.7623
R630 pn38 pn38_n2 9.39653
R631 pn38_n2 pn38_t0 5.69145
R632 pn65_n0 pn65_t1 56.3293
R633 pn65 pn65_n0 8.48434
R634 pn65_n0 pn65_t0 6.43033
R635 pn64_n0 pn64_t1 54.1802
R636 pn64 pn64_n0 9.02978
R637 pn64_n0 pn64_t0 5.88488
R638 pn63_n0 pn63_t1 55.8657
R639 pn63 pn63_n0 9.20605
R640 pn63_n0 pn63_t0 5.70862
R641 pn62_n0 pn62_t1 57.3187
R642 pn62 pn62_n0 8.82891
R643 pn62_n0 pn62_t0 6.08575
R644 pn211_n0 pn211_t1 36.2196
R645 pn211_n0 pn211_t0 8.74038
R646 pn211 pn211_n0 6.16599
R647 pn133_n1 pn133_t2 43.1027
R648 pn133 pn133_n1 33.7622
R649 pn133_n1 pn133_n0 18.0005
R650 pn133_n0 pn133_t0 8.74038
R651 pn133_n0 pn133_t1 6.16599
R652 pn132_n1 pn132_t2 38.3155
R653 pn132 pn132_n1 35.5423
R654 pn132_n1 pn132_n0 18.046
R655 pn132_n0 pn132_t0 9.90675
R656 pn132_n0 pn132_t1 8.48515
R657 pn131_n1 pn131_t2 38.8699
R658 pn131 pn131_n1 35.8767
R659 pn131_n1 pn131_n0 22.9783
R660 pn131_n0 pn131_t1 8.74038
R661 pn131_n0 pn131_t0 6.16555
R662 pn130_n1 pn130_t2 38.0691
R663 pn130 pn130_n1 37.0735
R664 pn130_n1 pn130_n0 18.5519
R665 pn130_n0 pn130_t1 8.73938
R666 pn130_n0 pn130_t0 6.16599
R667 pn181_n1 pn181_t3 36.6745
R668 pn181_n0 pn181_t1 34.1945
R669 pn181_n0 pn181_t2 33.4331
R670 pn181_n2 pn181_n1 21.9981
R671 pn181_n2 pn181_t0 9.30231
R672 pn181 pn181_n2 5.60405
R673 pn181_n1 pn181_n0 3.3797
R674 pn41_n0 pn41_t1 34.8739
R675 pn41_n2 pn41_t4 34.6891
R676 pn41_n0 pn41_t2 33.6625
R677 pn41_n1 pn41_t3 33.0602
R678 pn41_n3 pn41_n2 18.4229
R679 pn41 pn41_n3 9.10345
R680 pn41_n3 pn41_t0 5.97331
R681 pn41_n2 pn41_n1 2.3237
R682 pn41_n1 pn41_n0 1.5757
R683 pn60_n0 pn60_t1 55.9069
R684 pn60 pn60_n0 8.48434
R685 pn60_n0 pn60_t0 6.43033
R686 pn193_n0 pn193_t1 52.7039
R687 pn193_n1 pn193_n0 30.8255
R688 pn193_n0 pn193_t2 24.0022
R689 pn193_n1 pn193_t0 8.73938
R690 pn193 pn193_n1 6.16533
R691 pn209_n1 pn209_t3 36.4545
R692 pn209_n1 pn209_t1 33.7617
R693 pn209_n3 pn209_t2 33.4282
R694 pn209_n3 pn209_n2 31.2682
R695 pn209_n4 pn209_n3 26.2431
R696 pn209_n2 pn209_t4 24.0022
R697 pn209 pn209_n0 17.0005
R698 pn209_n2 pn209_n1 12.0071
R699 pn209_n0 pn209_t0 9.41086
R700 pn209 pn209_n4 8.58906
R701 pn209_n4 pn209_n0 0.0589375
R702 pn5_n1 pn5_t2 33.2001
R703 pn5_n2 pn5_t3 33.197
R704 pn5_n3 pn5_t4 33.1905
R705 pn5_n0 pn5_t1 25.6857
R706 pn5_n0 pn5_t5 25.6723
R707 pn5_n4 pn5_n3 24.278
R708 pn5_n1 pn5_n0 9.8453
R709 pn5 pn5_n4 9.25233
R710 pn5_n4 pn5_t0 5.6237
R711 pn5_n3 pn5_n2 1.0565
R712 pn5_n2 pn5_n1 1.0565
R713 pn6_n2 pn6_t3 33.0376
R714 pn6_n3 pn6_t4 33.0022
R715 pn6_n0 pn6_t1 25.8329
R716 pn6_n0 pn6_t5 25.4566
R717 pn6_n1 pn6_t2 24.0169
R718 pn6_n4 pn6_n3 22.9844
R719 pn6_n2 pn6_n1 10.2677
R720 pn6 pn6_n4 9.25233
R721 pn6_n4 pn6_t0 5.6237
R722 pn6_n3 pn6_n2 2.1125
R723 pn6_n1 pn6_n0 0.1655
R724 pn51_n2 pn51_t1 35.2191
R725 pn51_n0 pn51_t2 33.7791
R726 pn51_n1 pn51_t4 33.2165
R727 pn51_n0 pn51_t3 33.1986
R728 pn51_n3 pn51_t5 33.1901
R729 pn51_n4 pn51_n3 23.7933
R730 pn51 pn51_n4 8.48259
R731 pn51_n4 pn51_t0 6.3941
R732 pn51_n2 pn51_n1 3.5909
R733 pn51_n1 pn51_n0 1.4789
R734 pn51_n3 pn51_n2 0.6341
R735 pn50_n6 pn50_t2 35.9659
R736 pn50_n1 pn50_t3 34.8017
R737 pn50_n2 pn50_t5 33.753
R738 pn50_n3 pn50_t6 33.7443
R739 pn50_n0 pn50_t1 25.2553
R740 pn50_n7 pn50_n6 25.0283
R741 pn50_n4 pn50_t7 24.0183
R742 pn50_n5 pn50_t8 24.0095
R743 pn50_n5 pn50_n4 19.0565
R744 pn50_n0 pn50_t4 17.6231
R745 pn50_n6 pn50_n5 12.7617
R746 pn50_n4 pn50_n3 11.6344
R747 pn50_n1 pn50_n0 9.0005
R748 pn50 pn50_n7 8.48259
R749 pn50_n3 pn50_n2 6.7589
R750 pn50_n7 pn50_t0 6.3941
R751 pn50_n2 pn50_n1 1.0565
R752 pn68 pn68_n0 17.4551
R753 pn68_n0 pn68_t1 15.0005
R754 pn68_n0 pn68_t0 9.342
R755 gain_sel[2] gain_sel[2]_t0 50.3163
R756 pn67 pn67_n0 17.4551
R757 pn67_n0 pn67_t1 15.0005
R758 pn67_n0 pn67_t0 9.342
R759 gain_sel[3] gain_sel[3]_t0 58.4683
R760 pn143_n0 pn143_t1 43.8882
R761 pn143_n0 pn143_t0 20.9105
R762 pn143 pn143_n0 19.5272
R763 IBIAS_IA IBIAS_IA_n10 110.062
R764 IBIAS_IA_n0 IBIAS_IA_t11 18.0455
R765 IBIAS_IA_n9 IBIAS_IA_t0 17.704
R766 IBIAS_IA_n2 IBIAS_IA_t5 16.6426
R767 IBIAS_IA_n3 IBIAS_IA_t4 16.6426
R768 IBIAS_IA_n6 IBIAS_IA_t3 16.6426
R769 IBIAS_IA_n7 IBIAS_IA_t2 16.6426
R770 IBIAS_IA_n8 IBIAS_IA_t1 16.6426
R771 IBIAS_IA_n9 IBIAS_IA_t6 16.4665
R772 IBIAS_IA_n0 IBIAS_IA_t10 15.4055
R773 IBIAS_IA_n1 IBIAS_IA_t9 15.4055
R774 IBIAS_IA_n4 IBIAS_IA_t8 15.4055
R775 IBIAS_IA_n5 IBIAS_IA_t7 15.4055
R776 IBIAS_IA_n10 IBIAS_IA_n9 9.0005
R777 IBIAS_IA_n6 IBIAS_IA_n5 3.0805
R778 IBIAS_IA_n2 IBIAS_IA_n1 3.0805
R779 IBIAS_IA_n8 IBIAS_IA_n7 2.6405
R780 IBIAS_IA_n7 IBIAS_IA_n6 2.6405
R781 IBIAS_IA_n5 IBIAS_IA_n4 2.6405
R782 IBIAS_IA_n3 IBIAS_IA_n2 2.6405
R783 IBIAS_IA_n1 IBIAS_IA_n0 2.6405
R784 IBIAS_IA_n10 IBIAS_IA_n8 2.27383
R785 IBIAS_IA_n4 IBIAS_IA_n3 2.2005
R786 pn149_n2 pn149_n1 20.4994
R787 pn149 pn149_n0 7.46769
R788 pn149_n4 pn149_n3 6.49706
R789 pn149_n1 pn149_t1 5.69813
R790 pn149 pn149_n0 4.06269
R791 pn149_n1 pn149_t0 3.80041
R792 pn149_n2 pn149_t3 2.38005
R793 pn149 pn149_n4 1.71109
R794 pn149_n3 pn149_n2 1.44439
R795 pn149_n3 pn149_t2 0.998763
R796 pn149_n4 pn149_n0 0.649379
R797 pn148_n2 pn148_t0 20.2699
R798 pn148 pn148_n2 14.7447
R799 pn148_n1 pn148_t3 12.3778
R800 pn148_n1 pn148_n0 10.4592
R801 pn148_n0 pn148_t1 5.69716
R802 pn148_n0 pn148_t2 3.79879
R803 pn148_n2 pn148_n1 2.6427
R804 pn151 pn151_t0 28.9845
R805 VINN_n0 VINN_t0 45.1023
R806 VINN_n0 VINN_t1 35.7325
R807 VINN VINN_n0 2.1708
R808 pn219_n4 pn219_t0 17.0005
R809 pn219_n3 pn219_t2 17.0005
R810 pn219_n2 pn219_t1 17.0005
R811 pn219_n1 pn219_t3 17.0005
R812 pn219 pn219_n7 7.13857
R813 pn219_n0 pn219_t8 7.13447
R814 pn219_n7 pn219_n6 4.648
R815 pn219_n7 pn219_t4 2.48792
R816 pn219_n0 pn219_t7 2.48732
R817 pn219_n6 pn219_t5 2.48683
R818 pn219_n5 pn219_t6 2.48674
R819 pn219_n6 pn219_n5 2.31737
R820 pn219_n1 pn219_n0 2.29383
R821 pn219_n5 pn219_n4 1.14571
R822 pn219_n4 pn219_n3 0.043
R823 pn219_n3 pn219_n2 0.043
R824 pn219_n2 pn219_n1 0.043
R825 pn150_n9 pn150_t8 45.065
R826 pn150 pn150_n9 20.3098
R827 pn150_n0 pn150_t1 17.3511
R828 pn150_n6 pn150_t3 17.0005
R829 pn150_n5 pn150_t0 17.0005
R830 pn150_n4 pn150_t6 17.0005
R831 pn150_n3 pn150_t5 17.0005
R832 pn150_n2 pn150_t4 17.0005
R833 pn150_n1 pn150_t7 17.0005
R834 pn150_n0 pn150_t2 17.0005
R835 pn150_n7 pn150_n6 10.7841
R836 pn150_n9 pn150_n8 6.66603
R837 pn150_n8 pn150_t9 3.07861
R838 pn150_n7 pn150_t10 2.48468
R839 pn150_n8 pn150_n7 0.606387
R840 pn150_n6 pn150_n5 0.351125
R841 pn150_n5 pn150_n4 0.351125
R842 pn150_n4 pn150_n3 0.351125
R843 pn150_n3 pn150_n2 0.351125
R844 pn150_n2 pn150_n1 0.351125
R845 pn150_n1 pn150_n0 0.351125
R846 pn82_n5 pn82_n4 119.403
R847 pn82_n3 pn82_n1 32.2265
R848 pn82_n3 pn82_n2 29.9906
R849 pn82_n4 pn82_n0 21.6306
R850 pn82_n1 pn82_t33 17.2776
R851 pn82_n2 pn82_t35 17.2776
R852 pn82_n0 pn82_t37 17.2776
R853 pn82 pn82_n36 16.6974
R854 pn82_n5 pn82_t15 16.2301
R855 pn82_n6 pn82_t14 16.2301
R856 pn82_n7 pn82_t13 16.2301
R857 pn82_n8 pn82_t12 16.2301
R858 pn82_n9 pn82_t11 16.2301
R859 pn82_n10 pn82_t10 16.2301
R860 pn82_n11 pn82_t9 16.2301
R861 pn82_n12 pn82_t8 16.2301
R862 pn82_n13 pn82_t7 16.2301
R863 pn82_n22 pn82_t6 16.2301
R864 pn82_n23 pn82_t5 16.2301
R865 pn82_n24 pn82_t4 16.2301
R866 pn82_n25 pn82_t3 16.2301
R867 pn82_n26 pn82_t2 16.2301
R868 pn82_n27 pn82_t1 16.2301
R869 pn82_n28 pn82_t0 16.2301
R870 pn82_n14 pn82_t31 15.818
R871 pn82_n15 pn82_t30 15.818
R872 pn82_n16 pn82_t29 15.818
R873 pn82_n17 pn82_t28 15.818
R874 pn82_n18 pn82_t27 15.818
R875 pn82_n19 pn82_t26 15.818
R876 pn82_n20 pn82_t25 15.818
R877 pn82_n21 pn82_t24 15.818
R878 pn82_n29 pn82_t23 15.818
R879 pn82_n30 pn82_t22 15.818
R880 pn82_n31 pn82_t21 15.818
R881 pn82_n32 pn82_t20 15.818
R882 pn82_n33 pn82_t19 15.818
R883 pn82_n34 pn82_t18 15.818
R884 pn82_n35 pn82_t17 15.818
R885 pn82_n36 pn82_t16 15.818
R886 pn82_n4 pn82_n3 11.4991
R887 pn82_n2 pn82_t34 5.34468
R888 pn82_n0 pn82_t36 5.34468
R889 pn82_n1 pn82_t32 5.3439
R890 pn82_n36 pn82_n35 0.8805
R891 pn82_n35 pn82_n34 0.8805
R892 pn82_n34 pn82_n33 0.8805
R893 pn82_n33 pn82_n32 0.8805
R894 pn82_n32 pn82_n31 0.8805
R895 pn82_n31 pn82_n30 0.8805
R896 pn82_n30 pn82_n29 0.8805
R897 pn82_n28 pn82_n27 0.8805
R898 pn82_n27 pn82_n26 0.8805
R899 pn82_n26 pn82_n25 0.8805
R900 pn82_n25 pn82_n24 0.8805
R901 pn82_n24 pn82_n23 0.8805
R902 pn82_n23 pn82_n22 0.8805
R903 pn82_n21 pn82_n20 0.8805
R904 pn82_n20 pn82_n19 0.8805
R905 pn82_n19 pn82_n18 0.8805
R906 pn82_n18 pn82_n17 0.8805
R907 pn82_n17 pn82_n16 0.8805
R908 pn82_n16 pn82_n15 0.8805
R909 pn82_n15 pn82_n14 0.8805
R910 pn82_n13 pn82_n12 0.8805
R911 pn82_n12 pn82_n11 0.8805
R912 pn82_n11 pn82_n10 0.8805
R913 pn82_n10 pn82_n9 0.8805
R914 pn82_n9 pn82_n8 0.8805
R915 pn82_n8 pn82_n7 0.8805
R916 pn82_n7 pn82_n6 0.8805
R917 pn82_n6 pn82_n5 0.8805
R918 pn82_n29 pn82_n28 0.4405
R919 pn82_n22 pn82_n21 0.4405
R920 pn82_n14 pn82_n13 0.4405
R921 pn220_n7 pn220_n6 79.9579
R922 pn220_n2 pn220_t10 25.7258
R923 pn220 pn220_n15 17.0005
R924 pn220 pn220_n1 17.0005
R925 pn220_t12 pn220_t13 16.8939
R926 pn220_t8 pn220_t12 16.8895
R927 pn220_n3 pn220_t8 15.0005
R928 pn220_t10 pn220_t11 14.0016
R929 pn220_n8 pn220_t7 13.1965
R930 pn220_n10 pn220_t4 13.1965
R931 pn220_n12 pn220_t5 13.1965
R932 pn220_n14 pn220_t6 13.1965
R933 pn220_n7 pn220_t0 13.1956
R934 pn220_n9 pn220_t2 13.1956
R935 pn220_n11 pn220_t1 13.1956
R936 pn220_n13 pn220_t3 13.1956
R937 pn220_n15 pn220_n14 11.338
R938 pn220_n6 pn220_n5 9.07096
R939 pn220_n4 pn220_n2 9.0005
R940 pn220 pn220_n0 8.90987
R941 pn220_n3 pn220_t9 8.81129
R942 pn220 pn220_n0 8.44296
R943 pn220_n5 pn220_t8 7.49231
R944 pn220_n14 pn220_n13 1.3205
R945 pn220_n13 pn220_n12 1.3205
R946 pn220_n12 pn220_n11 1.3205
R947 pn220_n11 pn220_n10 1.3205
R948 pn220_n10 pn220_n9 1.3205
R949 pn220_n9 pn220_n8 1.3205
R950 pn220_n8 pn220_n7 1.3205
R951 pn220_n1 pn220_n0 0.350827
R952 pn220_n15 pn220_n1 0.23425
R953 pn220_n5 pn220_n4 0.108892
R954 pn220_n6 pn220_n2 0.0389734
R955 pn220_n4 pn220_n3 0.0152561
R956 pn84_n17 pn84_n16 23.0594
R957 pn84_n0 pn84_t18 19.283
R958 pn84_n15 pn84_t0 17.979
R959 pn84_n15 pn84_t2 17.154
R960 pn84_n0 pn84_t17 16.643
R961 pn84_n3 pn84_t16 16.643
R962 pn84_n4 pn84_t15 16.643
R963 pn84_n1 pn84_t14 15.4051
R964 pn84_n2 pn84_t13 15.4051
R965 pn84_n5 pn84_t12 15.4051
R966 pn84 pn84_n17 15.4041
R967 pn84_n6 pn84_t7 14.9281
R968 pn84_n7 pn84_t1 13.6081
R969 pn84_n9 pn84_t11 13.6081
R970 pn84_n11 pn84_t4 13.6081
R971 pn84_n13 pn84_t6 13.6081
R972 pn84_n6 pn84_t8 12.784
R973 pn84_n8 pn84_t5 12.784
R974 pn84_n10 pn84_t9 12.784
R975 pn84_n12 pn84_t3 12.784
R976 pn84_n14 pn84_t10 12.784
R977 pn84_n16 pn84_n15 9.0005
R978 pn84_n3 pn84_n2 3.9605
R979 pn84_n4 pn84_n3 3.5205
R980 pn84_n2 pn84_n1 3.5205
R981 pn84_n5 pn84_n4 3.0805
R982 pn84_n1 pn84_n0 3.0805
R983 pn84_n17 pn84_n5 2.6405
R984 pn84_n14 pn84_n13 1.3205
R985 pn84_n13 pn84_n12 1.3205
R986 pn84_n12 pn84_n11 1.3205
R987 pn84_n11 pn84_n10 1.3205
R988 pn84_n10 pn84_n9 1.3205
R989 pn84_n9 pn84_n8 1.3205
R990 pn84_n8 pn84_n7 1.3205
R991 pn84_n7 pn84_n6 1.3205
R992 pn84_n16 pn84_n14 0.953833
R993 pn85 pn85_t0 51.8954
R994 pn157_n0 pn157_t1 17.8873
R995 pn157 pn157_n0 15.3273
R996 pn157_n0 pn157_t0 2.94632
R997 pn156_n15 pn156_n14 80.1253
R998 pn156_n6 pn156_t11 25.7258
R999 pn156_t13 pn156_t12 16.8947
R1000 pn156 pn156_n4 15.0156
R1001 pn156 pn156_n0 15.0005
R1002 pn156 pn156_n2 15.0005
R1003 pn156_n7 pn156_t3 14.929
R1004 pn156_t11 pn156_t10 14.0016
R1005 pn156_n8 pn156_t5 13.609
R1006 pn156_n10 pn156_t2 13.609
R1007 pn156_n12 pn156_t4 13.609
R1008 pn156_n14 pn156_t8 13.609
R1009 pn156_n7 pn156_t1 12.7831
R1010 pn156_n9 pn156_t0 12.7831
R1011 pn156_n11 pn156_t6 12.7831
R1012 pn156_n13 pn156_t7 12.7831
R1013 pn156_n16 pn156_n15 9.07096
R1014 pn156_n4 pn156_n3 9.03277
R1015 pn156_n3 pn156_n1 9.00197
R1016 pn156_n6 pn156_n5 9.0005
R1017 pn156_n0 pn156_t9 8.81129
R1018 pn156_n3 pn156_t13 8.61113
R1019 pn156 pn156_n1 7.55268
R1020 pn156 pn156_n16 7.49231
R1021 pn156_n14 pn156_n13 1.3205
R1022 pn156_n13 pn156_n12 1.3205
R1023 pn156_n12 pn156_n11 1.3205
R1024 pn156_n11 pn156_n10 1.3205
R1025 pn156_n10 pn156_n9 1.3205
R1026 pn156_n9 pn156_n8 1.3205
R1027 pn156_n8 pn156_n7 1.3205
R1028 pn156_n16 pn156_n5 0.108892
R1029 pn156_n4 pn156_n2 0.078875
R1030 pn156_n2 pn156_n1 0.065125
R1031 pn156_n15 pn156_n6 0.0389734
R1032 pn156_n5 pn156_n0 0.0152561
R1033 pn159_n0 pn159_t0 23.0352
R1034 pn159 pn159_n1 5.15561
R1035 pn159_n1 pn159_t1 4.56061
R1036 pn159_n0 pn159_t2 1.82377
R1037 pn159_n1 pn159_n0 0.5912
R1038 pn223_n1 pn223_n0 21.5278
R1039 pn223_n0 pn223_t1 3.90497
R1040 pn223_n1 pn223_t2 3.54281
R1041 pn223 pn223_n1 2.48315
R1042 pn223_n0 pn223_t0 1.16534
R1043 VCM_n8 VCM_n1 101.764
R1044 VCM VCM_n15 77.9436
R1045 VCM_n15 VCM_n14 52.6696
R1046 VCM_n8 VCM_n7 42.7607
R1047 VCM_n15 VCM_n8 38.8828
R1048 VCM_n1 VCM_t0 21.4816
R1049 VCM_n0 VCM_t1 17.2206
R1050 VCM_n0 VCM_t2 17.2163
R1051 VCM_n4 VCM_t3 12.7904
R1052 VCM_n11 VCM_t4 12.7904
R1053 VCM_n5 VCM_n2 9.0912
R1054 VCM_n12 VCM_n9 9.0912
R1055 VCM_n4 VCM_n3 9.05697
R1056 VCM_n11 VCM_n10 9.05697
R1057 VCM_n3 VCM_n2 9.0137
R1058 VCM_n10 VCM_n9 9.0137
R1059 VCM_n7 VCM_n6 9.0005
R1060 VCM_n14 VCM_n13 9.0005
R1061 VCM_n1 VCM_n0 5.34299
R1062 VCM_n5 VCM_n4 4.52153
R1063 VCM_n12 VCM_n11 4.52153
R1064 VCM_n6 VCM_n3 0.0775
R1065 VCM_n13 VCM_n10 0.0775
R1066 VCM_n6 VCM_n5 0.0388129
R1067 VCM_n13 VCM_n12 0.0388129
R1068 VCM_n7 VCM_n2 0.00123333
R1069 VCM_n14 VCM_n9 0.00123333
R1070 pn222_n1 pn222_n0 18.0733
R1071 pn222_n0 pn222_t0 16.3394
R1072 pn222_n0 pn222_t1 0.703186
R1073 pn222 pn222_n1 0.00240162
R1074 pn222_n1 pn222_t2 0.00159825
R1075 pn154_n2 pn154_n0 22.354
R1076 pn154_n2 pn154_n1 14.2797
R1077 pn154_n0 pn154_t3 6.97267
R1078 pn154_n0 pn154_t4 6.15134
R1079 pn154 pn154_n3 5.64906
R1080 pn154_n1 pn154_t0 3.66253
R1081 pn154_n1 pn154_t1 3.54134
R1082 pn154_n3 pn154_n2 2.93356
R1083 pn154_n3 pn154_t2 0.19404
R1084 pn86_n1 pn86_t1 37.3573
R1085 pn86 pn86_n1 35.7213
R1086 pn86_n0 pn86_t2 24.0005
R1087 pn86_n0 pn86_t0 13.562
R1088 pn86_n1 pn86_n0 4.80997
R1089 pn158_n0 pn158_t2 95.3284
R1090 pn158_n1 pn158_n0 20.1156
R1091 pn158_n0 pn158_t0 16.1539
R1092 pn158 pn158_n1 15.0005
R1093 pn158_n1 pn158_t1 3.64157
R1094 pn224 pn224_n4 44.5178
R1095 pn224_n1 pn224_t0 27.6562
R1096 pn224_n0 pn224_t2 24.3167
R1097 pn224_n0 pn224_t3 23.4578
R1098 pn224_n2 pn224_t1 21.8368
R1099 pn224_n3 pn224_n2 20.8686
R1100 pn224_n4 pn224_n3 19.9402
R1101 pn224_n4 pn224_t5 11.401
R1102 pn224_n3 pn224_t4 4.69053
R1103 pn224_n2 pn224_n1 0.523367
R1104 pn224_n1 pn224_n0 0.391367
R1105 pn226_n0 pn226_t0 25.8136
R1106 pn226_n1 pn226_n0 23.557
R1107 pn226_n1 pn226_t1 2.65971
R1108 pn226 pn226_n1 1.61005
R1109 pn226_n0 pn226_t2 1.17697
R1110 pn120_n2 pn120_n1 126.001
R1111 pn120_n2 pn120_t0 61.6924
R1112 pn120 pn120_n2 39.3356
R1113 pn120_n1 pn120_n0 21.3188
R1114 pn120_n0 pn120_t3 2.71311
R1115 pn120_n1 pn120_t1 2.66704
R1116 pn120_n0 pn120_t2 2.34074
R1117 pn153_n1 pn153_t0 47.2297
R1118 pn153_n1 pn153_n0 37.4277
R1119 pn153_n0 pn153_t2 6.78973
R1120 pn153_n0 pn153_t3 6.47445
R1121 pn153_n2 pn153_t1 4.23839
R1122 pn153 pn153_n2 4.22391
R1123 pn153_n2 pn153_n1 1.85858
R1124 pn225 pn225_n1 65.8331
R1125 pn225_n1 pn225_t2 63.1062
R1126 pn225_n1 pn225_n0 23.8719
R1127 pn225_n0 pn225_t0 15.2505
R1128 pn225_n0 pn225_t1 8.50305
R1129 pn160_n4 pn160_t0 25.9904
R1130 pn160_n5 pn160_t5 15.4267
R1131 pn160_n4 pn160_n3 12.9235
R1132 pn160_n6 pn160_n5 9.44417
R1133 pn160_n1 pn160_n0 9.07539
R1134 pn160_n8 pn160_n1 9.05326
R1135 pn160_n7 pn160_n6 9.0005
R1136 pn160_t5 pn160_n2 7.16221
R1137 pn160_n2 pn160_t3 5.80793
R1138 pn160 pn160_n8 5.0034
R1139 pn160 pn160_n0 4.99428
R1140 pn160_n3 pn160_t2 3.79089
R1141 pn160_n3 pn160_t1 2.48849
R1142 pn160_n2 pn160_t4 2.46963
R1143 pn160_n5 pn160_n4 0.648767
R1144 pn160_n7 pn160_n0 0.108864
R1145 pn160_n8 pn160_n7 0.0942444
R1146 pn160_n6 pn160_n1 0.00343333
R1147 pn221_n9 pn221_n8 15.89
R1148 pn221_n10 pn221_n9 11.3042
R1149 pn221_n10 pn221_t9 5.49468
R1150 pn221 pn221_n10 5.49195
R1151 pn221_n0 pn221_t4 5.40878
R1152 pn221_n0 pn221_t2 5.4084
R1153 pn221_n2 pn221_t12 4.12122
R1154 pn221_n8 pn221_t0 2.26695
R1155 pn221_n5 pn221_t1 2.13527
R1156 pn221_n2 pn221_t6 2.13506
R1157 pn221_n6 pn221_t11 2.13484
R1158 pn221_n4 pn221_t7 2.13474
R1159 pn221_n3 pn221_t8 2.13386
R1160 pn221_n7 pn221_t5 2.13378
R1161 pn221_n7 pn221_n6 1.98738
R1162 pn221_n6 pn221_n5 1.98738
R1163 pn221_n5 pn221_n4 1.98738
R1164 pn221_n4 pn221_n3 1.98738
R1165 pn221_n3 pn221_n2 1.98738
R1166 pn221_n10 pn221_t10 1.72314
R1167 pn221_n9 pn221_n1 1.64649
R1168 pn221_n8 pn221_n7 1.38512
R1169 pn221_n1 pn221_t3 1.17135
R1170 pn221_n1 pn221_n0 0.400175
R1171 pn227_n6 pn227_t15 48.9998
R1172 pn227_n22 pn227_t14 4.95984
R1173 pn227_t14 pn227_n21 4.95984
R1174 pn227_n0 pn227_t5 4.12214
R1175 pn227_n23 pn227_n5 3.81591
R1176 pn227_n14 pn227_n13 3.36038
R1177 pn227_n7 pn227_t16 3.20148
R1178 pn227_n14 pn227_t4 2.42277
R1179 pn227_n13 pn227_t23 2.42272
R1180 pn227_n20 pn227_t10 2.41279
R1181 pn227_n19 pn227_t2 2.41279
R1182 pn227_n18 pn227_t8 2.41279
R1183 pn227_n17 pn227_t6 2.41279
R1184 pn227_n16 pn227_t0 2.41279
R1185 pn227_n15 pn227_t12 2.41279
R1186 pn227_n12 pn227_t22 2.41279
R1187 pn227_n11 pn227_t21 2.41279
R1188 pn227_n10 pn227_t20 2.41279
R1189 pn227_n9 pn227_t19 2.41279
R1190 pn227_n8 pn227_t18 2.41279
R1191 pn227_n7 pn227_t17 2.41279
R1192 pn227_n23 pn227_n22 2.37189
R1193 pn227_n1 pn227_t1 2.13558
R1194 pn227_n4 pn227_t3 2.13549
R1195 pn227_n0 pn227_t13 2.135
R1196 pn227_n5 pn227_t11 2.13444
R1197 pn227_n3 pn227_t9 2.13417
R1198 pn227_n2 pn227_t7 2.13404
R1199 pn227_n5 pn227_n4 1.98738
R1200 pn227_n4 pn227_n3 1.98738
R1201 pn227_n3 pn227_n2 1.98738
R1202 pn227_n2 pn227_n1 1.98738
R1203 pn227_n1 pn227_n0 1.98738
R1204 pn227_n20 pn227_n19 0.790191
R1205 pn227_n19 pn227_n18 0.790191
R1206 pn227_n18 pn227_n17 0.790191
R1207 pn227_n17 pn227_n16 0.790191
R1208 pn227_n16 pn227_n15 0.790191
R1209 pn227_n12 pn227_n11 0.790191
R1210 pn227_n11 pn227_n10 0.790191
R1211 pn227_n10 pn227_n9 0.790191
R1212 pn227_n9 pn227_n8 0.790191
R1213 pn227_n8 pn227_n7 0.790191
R1214 pn227_n13 pn227_n12 0.778958
R1215 pn227_n15 pn227_n14 0.777179
R1216 pn227_n21 pn227_n20 0.65392
R1217 pn227 pn227_n23 0.307615
R1218 pn227_n22 pn227_n6 0.188087
R1219 pn227_n21 pn227_n6 0.0942483
R1220 pn165 pn165_n0 17.1716
R1221 pn165_n0 pn165_t0 8.69261
R1222 pn165_n0 pn165_t1 6.03031
R1223 pn164 pn164_n0 17.1716
R1224 pn164_n0 pn164_t1 8.69261
R1225 pn164_n0 pn164_t0 6.03031
R1226 pn163 pn163_n0 17.1716
R1227 pn163_n0 pn163_t0 8.69261
R1228 pn163_n0 pn163_t1 6.03031
R1229 pn167 pn167_n0 17.1579
R1230 pn167_n0 pn167_t0 8.73326
R1231 pn167_n0 pn167_t1 5.98966
R1232 pn166 pn166_n0 16.9681
R1233 pn166_n0 pn166_t0 8.72848
R1234 pn166_n0 pn166_t1 5.99445
R1235 pn161_n13 pn161_n11 47.3
R1236 pn161_n19 pn161_n18 46.2417
R1237 pn161_n17 pn161_n16 46.1848
R1238 pn161_n15 pn161_n14 46.1641
R1239 pn161_n13 pn161_n12 46.1641
R1240 pn161_n21 pn161_n20 18.8794
R1241 pn161_n20 pn161_t3 17.9905
R1242 pn161_n18 pn161_t2 17.853
R1243 pn161_n16 pn161_t11 17.7564
R1244 pn161_n14 pn161_t6 17.6189
R1245 pn161_n12 pn161_t0 17.6189
R1246 pn161_n11 pn161_t1 17.6189
R1247 pn161_n16 pn161_t7 17.5436
R1248 pn161_n22 pn161_n10 17.5169
R1249 pn161_n14 pn161_t5 17.3993
R1250 pn161_n12 pn161_t10 17.3993
R1251 pn161_n11 pn161_t4 17.3993
R1252 pn161 pn161_n22 15.0012
R1253 pn161_n21 pn161_n19 10.9033
R1254 pn161_n4 pn161_n3 9.05448
R1255 pn161_n7 pn161_n6 9.0476
R1256 pn161_n1 pn161_n0 9.0335
R1257 pn161_n8 pn161_n0 9.03277
R1258 pn161_n10 pn161_n9 9.0005
R1259 pn161_n9 pn161_n2 9.0005
R1260 pn161_n8 pn161_n7 9.0005
R1261 pn161_n3 pn161_n1 9.0005
R1262 pn161_n5 pn161_n2 9.0005
R1263 pn161_n18 pn161_t8 8.91864
R1264 pn161_n4 pn161_t12 7.4777
R1265 pn161_n6 pn161_t12 7.4777
R1266 pn161_n20 pn161_t9 6.3601
R1267 pn161_n17 pn161_n15 4.25237
R1268 pn161_n22 pn161_n21 3.02307
R1269 pn161_n19 pn161_n17 2.10223
R1270 pn161_n15 pn161_n13 1.19803
R1271 pn161_n6 pn161_n5 0.0971047
R1272 pn161_n5 pn161_n4 0.0916048
R1273 pn161_n9 pn161_n1 0.0775
R1274 pn161_n3 pn161_n2 0.0775
R1275 pn161_n9 pn161_n8 0.0767667
R1276 pn161_n7 pn161_n2 0.0767667
R1277 pn161_n10 pn161_n0 0.00196667
R1278 pn169 pn169_n0 17.0396
R1279 pn169_n0 pn169_t0 8.70696
R1280 pn169_n0 pn169_t1 6.01597
R1281 pn171_n0 pn171_t1 18.4133
R1282 pn171_n0 pn171_t2 17.0005
R1283 pn171_n1 pn171_t0 15.1472
R1284 pn171 pn171_n1 15.0647
R1285 pn171_n1 pn171_n0 0.435
R1286 pn170_n0 pn170_t0 17.0005
R1287 pn170 pn170_n1 15.2123
R1288 pn170_n1 pn170_t1 15.006
R1289 pn170_n0 pn170_t2 9.87426
R1290 pn170_n1 pn170_n0 0.435
R1291 pn90_n0 pn90_t1 48.5
R1292 pn90 pn90_n1 17.0005
R1293 pn90_n0 pn90_t0 15.0005
R1294 pn90_n1 pn90_t2 7.4876
R1295 pn90_n1 pn90_n0 0.4295
R1296 pn229_n0 pn229_t2 20.2699
R1297 pn229_n0 pn229_t3 14.7473
R1298 pn229_n1 pn229_t0 12.3771
R1299 pn229_n2 pn229_n1 10.4592
R1300 pn229 pn229_n2 5.69745
R1301 pn229_n2 pn229_t1 3.79898
R1302 pn229_n1 pn229_n0 2.6427
R1303 pn162_n1 pn162_n0 20.4994
R1304 pn162_n2 pn162 15.0005
R1305 pn162_n3 pn162 7.46905
R1306 pn162_n2 pn162_t4 7.05784
R1307 pn162_n0 pn162_t3 5.69807
R1308 pn162_n6 pn162 4.9422
R1309 pn162_n7 pn162_n6 4.13405
R1310 pn162_n0 pn162_t2 3.80064
R1311 pn162_n4 pn162 3.66876
R1312 pn162_n1 pn162_t0 2.38026
R1313 pn162_n5 pn162_n1 1.21595
R1314 pn162_n4 pn162_n3 0.388852
R1315 pn162_n5 pn162_n4 0.274959
R1316 pn162_n3 pn162_n2 0.196893
R1317 pn162_n6 pn162_n5 0.192983
R1318 pn162_n7 pn162 0.00162886
R1319 pn162_n7 pn162 0.00137113
R1320 pn172 pn172_n1 19.0109
R1321 pn172_n0 pn172_t0 17.8908
R1322 pn172_n0 pn172_t1 17.1518
R1323 pn172_n1 pn172_t2 15.2242
R1324 pn172_n1 pn172_n0 0.452417
R1325 pn88 pn88_n1 18.2277
R1326 pn88_n1 pn88_t2 17.0005
R1327 pn88_n0 pn88_t0 15.2572
R1328 pn88_n0 pn88_t1 15.0005
R1329 pn88_n1 pn88_n0 5.803
R1330 pn87_n2 pn87_n1 125.977
R1331 pn87_n1 pn87_t0 39.3356
R1332 pn87_n1 pn87_t3 27.0474
R1333 pn87_n2 pn87_n0 21.3188
R1334 pn87_n0 pn87_t2 2.71301
R1335 pn87 pn87_n2 2.66586
R1336 pn87_n0 pn87_t1 2.3407
R1337 pn89_n0 pn89_t0 37.7132
R1338 pn89_n0 pn89_t1 17.7155
R1339 pn89 pn89_n0 17.3271
R1340 pn174 pn174_t0 30.2572
R1341 VOUT_n9 VOUT_t10 80.5508
R1342 VOUT_n0 VOUT_t7 17.3511
R1343 VOUT_n0 VOUT_t6 17.0005
R1344 VOUT_n1 VOUT_t4 17.0005
R1345 VOUT_n2 VOUT_t1 17.0005
R1346 VOUT_n3 VOUT_t2 17.0005
R1347 VOUT_n4 VOUT_t5 17.0005
R1348 VOUT_n5 VOUT_t3 17.0005
R1349 VOUT_n6 VOUT_t0 17.0005
R1350 VOUT_n7 VOUT_n6 10.7841
R1351 VOUT_n9 VOUT_n8 6.65677
R1352 VOUT_n8 VOUT_t9 3.07815
R1353 VOUT_n7 VOUT_t8 2.4849
R1354 VOUT VOUT_n9 1.22439
R1355 VOUT_n8 VOUT_n7 0.606387
R1356 VOUT_n1 VOUT_n0 0.351125
R1357 VOUT_n2 VOUT_n1 0.351125
R1358 VOUT_n3 VOUT_n2 0.351125
R1359 VOUT_n4 VOUT_n3 0.351125
R1360 VOUT_n5 VOUT_n4 0.351125
R1361 VOUT_n6 VOUT_n5 0.351125
R1362 pn228_n6 pn228_t0 17.0005
R1363 pn228_n5 pn228_t3 17.0005
R1364 pn228_n4 pn228_t1 17.0005
R1365 pn228_n3 pn228_t2 17.0005
R1366 pn228 pn228_n7 7.13857
R1367 pn228_n0 pn228_t6 7.13591
R1368 pn228_n1 pn228_n0 4.648
R1369 pn228_n2 pn228_t8 2.48792
R1370 pn228_n7 pn228_t7 2.48764
R1371 pn228_n0 pn228_t5 2.48732
R1372 pn228_n1 pn228_t4 2.48654
R1373 pn228_n2 pn228_n1 2.31737
R1374 pn228_n7 pn228_n6 2.29383
R1375 pn228_n3 pn228_n2 1.14571
R1376 pn228_n6 pn228_n5 0.043
R1377 pn228_n5 pn228_n4 0.043
R1378 pn228_n4 pn228_n3 0.043
R1379 pn83_n1 pn83_n0 93.5958
R1380 pn83 pn83_n10 18.4566
R1381 pn83_n0 pn83_t11 17.2776
R1382 pn83_n1 pn83_t9 16.2305
R1383 pn83_n2 pn83_t8 16.2305
R1384 pn83_n3 pn83_t7 16.2305
R1385 pn83_n7 pn83_t6 16.2305
R1386 pn83_n8 pn83_t5 16.2305
R1387 pn83_n4 pn83_t4 15.8176
R1388 pn83_n5 pn83_t3 15.8176
R1389 pn83_n6 pn83_t2 15.8176
R1390 pn83_n9 pn83_t1 15.8176
R1391 pn83_n10 pn83_t0 15.8176
R1392 pn83_n0 pn83_t10 5.3439
R1393 pn83_n9 pn83_n8 3.0805
R1394 pn83_n7 pn83_n6 3.0805
R1395 pn83_n4 pn83_n3 3.0805
R1396 pn83_n10 pn83_n9 2.6405
R1397 pn83_n6 pn83_n5 2.6405
R1398 pn83_n3 pn83_n2 2.6405
R1399 pn83_n2 pn83_n1 2.6405
R1400 pn83_n8 pn83_n7 1.7605
R1401 pn83_n5 pn83_n4 1.7605
R1402 pn168_n1 pn168_n0 48.5128
R1403 pn168 pn168_n1 25.106
R1404 pn168_n1 pn168_t2 24.8013
R1405 pn168_n0 pn168_t0 8.54633
R1406 pn168_n0 pn168_t1 6.14002
R1407 pn93 pn93_n0 17.5197
R1408 pn93_n0 pn93_t1 15.4519
R1409 pn93_n0 pn93_t0 8.76789
R1410 pn91_n0 pn91_t1 34.0955
R1411 pn91 pn91_n0 9.41086
R1412 pn91_n0 pn91_t0 5.73312
R1413 pn92_n0 pn92_t2 27.7009
R1414 pn92_n1 pn92_t0 9.08096
R1415 pn92 pn92_n1 8.55847
R1416 pn92_n0 pn92_t1 5.66871
R1417 pn92_n1 pn92_n0 1.19643
R1418 pn55_n3 pn55_n2 125.035
R1419 pn55_n2 pn55_n1 65.8798
R1420 pn55_n0 pn55_t1 34.6215
R1421 pn55_n2 pn55_t4 33.4862
R1422 pn55_n0 pn55_t2 15.0005
R1423 pn55 pn55_n3 9.25233
R1424 pn55_n3 pn55_t0 5.6237
R1425 pn55_n1 pn55_t3 4.49428
R1426 pn55_n1 pn55_n0 0.618163
R1427 pn15_n2 pn15_n1 125.121
R1428 pn15_n1 pn15_n0 47.7155
R1429 pn15_n0 pn15_t1 33.638
R1430 pn15_n1 pn15_t3 33.6062
R1431 pn15_n0 pn15_t2 15.9878
R1432 pn15 pn15_n2 9.25233
R1433 pn15_n2 pn15_t0 5.6237
R1434 pn54_n2 pn54_n1 124.469
R1435 pn54_n1 pn54_n0 63.3186
R1436 pn54_n0 pn54_t1 34.6239
R1437 pn54_n1 pn54_t3 33.7314
R1438 pn54_n0 pn54_t2 15.0019
R1439 pn54 pn54_n2 9.25233
R1440 pn54_n2 pn54_t0 5.6237
R1441 pn53_n2 pn53_n1 125.106
R1442 pn53_n1 pn53_n0 40.9424
R1443 pn53_n0 pn53_t1 34.7523
R1444 pn53_n1 pn53_t3 33.8528
R1445 pn53_n0 pn53_t2 15.0005
R1446 pn53 pn53_n2 9.18011
R1447 pn53_n2 pn53_t0 5.69515
R1448 pn200_n3 pn200_n2 122.291
R1449 pn200_n2 pn200_t3 35.2795
R1450 pn200_n1 pn200_t1 33.748
R1451 pn200_n2 pn200_n1 20.1299
R1452 pn200 pn200_n0 17.0005
R1453 pn200_n1 pn200_t2 16.0111
R1454 pn200_n0 pn200_t0 9.1383
R1455 pn200 pn200_n3 8.59489
R1456 pn200_n3 pn200_n0 0.0628333
R1457 VPWR_n8 VPWR_t68 17.394
R1458 VPWR_n76 VPWR_t93 17.3734
R1459 VPWR_n228 VPWR_t49 17.2581
R1460 VPWR_n162 VPWR_t62 17.2403
R1461 VPWR_n9 VPWR_t75 17.2247
R1462 VPWR_n75 VPWR_t38 17.2247
R1463 VPWR_n73 VPWR_t74 17.2247
R1464 VPWR_n71 VPWR_t124 17.2247
R1465 VPWR_n69 VPWR_t32 17.2247
R1466 VPWR_n67 VPWR_t134 17.2247
R1467 VPWR_n65 VPWR_t45 17.2247
R1468 VPWR_n63 VPWR_t72 17.2247
R1469 VPWR_n97 VPWR_t51 17.2247
R1470 VPWR_n92 VPWR_t86 17.2247
R1471 VPWR_n167 VPWR_t37 17.2247
R1472 VPWR_n179 VPWR_t43 17.2247
R1473 VPWR_n187 VPWR_t39 17.2247
R1474 VPWR_n193 VPWR_t59 17.2247
R1475 VPWR_n207 VPWR_t91 17.2247
R1476 VPWR_n211 VPWR_t50 17.2247
R1477 VPWR_n215 VPWR_t31 17.2247
R1478 VPWR_n197 VPWR_t30 17.2247
R1479 VPWR_n183 VPWR_t36 17.2247
R1480 VPWR_n183 VPWR_t64 17.2247
R1481 VPWR_n181 VPWR_t133 17.2247
R1482 VPWR_n181 VPWR_t67 17.2247
R1483 VPWR_n163 VPWR_t55 17.2247
R1484 VPWR_n78 VPWR_n17 17.0005
R1485 VPWR_n232 VPWR_n130 17.0005
R1486 VPWR_n232 VPWR_n83 17.0005
R1487 VPWR_n233 VPWR_n232 17.0005
R1488 VPWR_n232 VPWR_n84 17.0005
R1489 VPWR_n166 VPWR_n161 17.0005
R1490 VPWR_n170 VPWR_n161 17.0005
R1491 VPWR_n172 VPWR_n161 17.0005
R1492 VPWR_n174 VPWR_n161 17.0005
R1493 VPWR_n178 VPWR_n161 17.0005
R1494 VPWR_n186 VPWR_n161 17.0005
R1495 VPWR_n188 VPWR_n161 17.0005
R1496 VPWR_n192 VPWR_n161 17.0005
R1497 VPWR_n194 VPWR_n161 17.0005
R1498 VPWR_n198 VPWR_n161 17.0005
R1499 VPWR_n200 VPWR_n161 17.0005
R1500 VPWR_n202 VPWR_n161 17.0005
R1501 VPWR_n206 VPWR_n161 17.0005
R1502 VPWR_n210 VPWR_n161 17.0005
R1503 VPWR_n218 VPWR_n161 17.0005
R1504 VPWR_n224 VPWR_n161 17.0005
R1505 VPWR_n226 VPWR_n161 17.0005
R1506 VPWR_n230 VPWR_n131 17.0005
R1507 VPWR_n230 VPWR_n156 17.0005
R1508 VPWR_n230 VPWR_n135 17.0005
R1509 VPWR_n230 VPWR_n154 17.0005
R1510 VPWR_n230 VPWR_n136 17.0005
R1511 VPWR_n230 VPWR_n151 17.0005
R1512 VPWR_n230 VPWR_n139 17.0005
R1513 VPWR_n230 VPWR_n145 17.0005
R1514 VPWR_n232 VPWR_n120 17.0005
R1515 VPWR_n232 VPWR_n124 17.0005
R1516 VPWR_n232 VPWR_n116 17.0005
R1517 VPWR_n232 VPWR_n87 17.0005
R1518 VPWR_n232 VPWR_n111 17.0005
R1519 VPWR_n232 VPWR_n88 17.0005
R1520 VPWR_n232 VPWR_n108 17.0005
R1521 VPWR_n232 VPWR_n89 17.0005
R1522 VPWR_n232 VPWR_n100 17.0005
R1523 VPWR_n232 VPWR_n98 17.0005
R1524 VPWR_n48 VPWR_t160 15.2621
R1525 VPWR_n140 VPWR_t153 15.2621
R1526 VPWR_n227 VPWR_t151 15.2621
R1527 VPWR_n235 VPWR_n80 14.065
R1528 VPWR_n235 VPWR_n234 13.5005
R1529 VPWR_n158 VPWR_t65 8.76264
R1530 VPWR_n201 VPWR_t70 8.76264
R1531 VPWR_n165 VPWR_t111 8.76264
R1532 VPWR_n147 VPWR_t60 8.76107
R1533 VPWR_n223 VPWR_t104 8.76107
R1534 VPWR_n217 VPWR_t66 8.76107
R1535 VPWR_n177 VPWR_t110 8.76107
R1536 VPWR_n173 VPWR_t122 8.76054
R1537 VPWR_n169 VPWR_t112 8.76054
R1538 VPWR_n142 VPWR_t53 8.73093
R1539 VPWR_n219 VPWR_t85 8.71923
R1540 VPWR_n49 VPWR_n16 8.501
R1541 VPWR_n229 VPWR_n228 8.501
R1542 VPWR_n141 VPWR_n119 8.501
R1543 VPWR_n230 VPWR_n132 8.50069
R1544 VPWR_n232 VPWR_n126 8.50069
R1545 VPWR_n232 VPWR_n94 8.48045
R1546 VPWR_n78 VPWR_n41 8.47111
R1547 VPWR_n78 VPWR_n15 8.47111
R1548 VPWR_n77 VPWR_n60 8.47111
R1549 VPWR_n77 VPWR_n58 8.47111
R1550 VPWR_n77 VPWR_n45 8.47111
R1551 VPWR_n77 VPWR_n51 8.47111
R1552 VPWR_n78 VPWR_n19 8.47111
R1553 VPWR_n78 VPWR_n24 8.47111
R1554 VPWR_n78 VPWR_n26 8.47111
R1555 VPWR_n78 VPWR_n30 8.47111
R1556 VPWR_n78 VPWR_n35 8.47111
R1557 VPWR_n78 VPWR_n3 8.47111
R1558 VPWR_n78 VPWR_n5 8.47111
R1559 VPWR_n78 VPWR_n14 8.47111
R1560 VPWR_n232 VPWR_n118 8.47111
R1561 VPWR_n164 VPWR_n161 8.47111
R1562 VPWR_n176 VPWR_n161 8.47111
R1563 VPWR_n190 VPWR_n161 8.47111
R1564 VPWR_n196 VPWR_n161 8.47111
R1565 VPWR_n204 VPWR_n161 8.47111
R1566 VPWR_n212 VPWR_n161 8.47111
R1567 VPWR_n214 VPWR_n161 8.47111
R1568 VPWR_n216 VPWR_n161 8.47111
R1569 VPWR_n222 VPWR_n161 8.47111
R1570 VPWR_n230 VPWR_n160 8.47111
R1571 VPWR_n230 VPWR_n137 8.47111
R1572 VPWR_n230 VPWR_n148 8.47111
R1573 VPWR_n230 VPWR_n143 8.47111
R1574 VPWR_n232 VPWR_n122 8.47111
R1575 VPWR_n232 VPWR_n85 8.47111
R1576 VPWR_n232 VPWR_n104 8.47111
R1577 VPWR_n232 VPWR_n90 8.47111
R1578 VPWR_n39 VPWR_t163 7.62628
R1579 VPWR_n12 VPWR_t165 7.62628
R1580 VPWR_n1 VPWR_t164 7.62628
R1581 VPWR_n31 VPWR_t162 7.62628
R1582 VPWR_n22 VPWR_t161 7.62628
R1583 VPWR_n127 VPWR_t154 7.62628
R1584 VPWR_n106 VPWR_t156 7.62628
R1585 VPWR_n112 VPWR_t155 7.62628
R1586 VPWR_n133 VPWR_t152 7.62628
R1587 VPWR_n95 VPWR_t159 7.62594
R1588 VPWR_n102 VPWR_t158 7.62594
R1589 VPWR_n114 VPWR_t157 7.62594
R1590 VPWR_n94 VPWR_t41 6.02057
R1591 VPWR_n61 VPWR_t115 5.98829
R1592 VPWR_n59 VPWR_t76 5.98829
R1593 VPWR_n44 VPWR_t69 5.98829
R1594 VPWR_n46 VPWR_t33 5.98829
R1595 VPWR_n150 VPWR_t82 5.98829
R1596 VPWR_n138 VPWR_t54 5.98829
R1597 VPWR_n171 VPWR_t121 5.98829
R1598 VPWR_n175 VPWR_t109 5.98829
R1599 VPWR_n199 VPWR_t34 5.98829
R1600 VPWR_n203 VPWR_t141 5.98829
R1601 VPWR_n149 VPWR_t147 5.98786
R1602 VPWR_n152 VPWR_t77 5.98786
R1603 VPWR_n195 VPWR_t35 5.98786
R1604 VPWR_n191 VPWR_t78 5.98786
R1605 VPWR_n189 VPWR_t114 5.98786
R1606 VPWR_n185 VPWR_t140 5.98786
R1607 VPWR_n27 VPWR_t84 5.97212
R1608 VPWR_n146 VPWR_t123 5.97212
R1609 VPWR_n125 VPWR_t83 5.97169
R1610 VPWR_n38 VPWR_t46 5.97001
R1611 VPWR_n0 VPWR_t19 5.97001
R1612 VPWR_n11 VPWR_t17 5.97001
R1613 VPWR_n4 VPWR_t9 5.97001
R1614 VPWR_n6 VPWR_t21 5.97001
R1615 VPWR_n34 VPWR_t56 5.97001
R1616 VPWR_n36 VPWR_t12 5.97001
R1617 VPWR_n25 VPWR_t6 5.97001
R1618 VPWR_n29 VPWR_t28 5.97001
R1619 VPWR_n20 VPWR_t103 5.97001
R1620 VPWR_n117 VPWR_t113 5.97001
R1621 VPWR_n81 VPWR_t90 5.97001
R1622 VPWR_n101 VPWR_t26 5.97001
R1623 VPWR_n86 VPWR_t22 5.97001
R1624 VPWR_n110 VPWR_t14 5.97001
R1625 VPWR_n123 VPWR_t95 5.97001
R1626 VPWR_n153 VPWR_t8 5.97001
R1627 VPWR_n157 VPWR_t4 5.97001
R1628 VPWR_n82 VPWR_t130 5.96957
R1629 VPWR_n91 VPWR_t16 5.96957
R1630 VPWR_n99 VPWR_t98 5.96957
R1631 VPWR_n105 VPWR_t101 5.96957
R1632 VPWR_n109 VPWR_t1 5.96957
R1633 VPWR_n57 VPWR_t61 5.96578
R1634 VPWR_n55 VPWR_t128 5.96578
R1635 VPWR_n53 VPWR_t58 5.96578
R1636 VPWR_n52 VPWR_t148 5.96578
R1637 VPWR_n50 VPWR_t132 5.96578
R1638 VPWR_n225 VPWR_t63 5.96578
R1639 VPWR_n129 VPWR_t52 5.96534
R1640 VPWR_n155 VPWR_t42 5.96534
R1641 VPWR_n213 VPWR_t142 5.96534
R1642 VPWR_n18 VPWR_t24 5.96091
R1643 VPWR_n121 VPWR_t87 5.96091
R1644 VPWR_n159 VPWR_t137 5.96091
R1645 VPWR_n144 VPWR_t146 5.94207
R1646 VPWR_n221 VPWR_t143 5.92982
R1647 VPWR_n205 VPWR_t117 5.92275
R1648 VPWR_n209 VPWR_t92 5.91335
R1649 VPWR_n162 VPWR_n161 5.70407
R1650 VPWR_n39 VPWR_t11 5.65005
R1651 VPWR_n12 VPWR_t18 5.65005
R1652 VPWR_n1 VPWR_t10 5.65005
R1653 VPWR_n31 VPWR_t27 5.65005
R1654 VPWR_n22 VPWR_t7 5.65005
R1655 VPWR_n127 VPWR_t94 5.65005
R1656 VPWR_n95 VPWR_t15 5.65005
R1657 VPWR_n106 VPWR_t13 5.65005
R1658 VPWR_n102 VPWR_t99 5.65005
R1659 VPWR_n112 VPWR_t23 5.65005
R1660 VPWR_n114 VPWR_t2 5.65005
R1661 VPWR_n133 VPWR_t3 5.65005
R1662 VPWR_n48 VPWR_t25 5.64493
R1663 VPWR_n140 VPWR_t88 5.64493
R1664 VPWR_n227 VPWR_t138 5.64493
R1665 VPWR_n79 VPWR_n78 5.64096
R1666 VPWR_n78 VPWR_n21 5.64096
R1667 VPWR_n78 VPWR_n37 5.64096
R1668 VPWR_n78 VPWR_n7 5.64096
R1669 VPWR_n232 VPWR_n93 5.64096
R1670 VPWR_n78 VPWR_n33 5.64013
R1671 VPWR_n77 VPWR_n56 5.61485
R1672 VPWR_n77 VPWR_n42 5.61485
R1673 VPWR_n77 VPWR_n54 5.61485
R1674 VPWR_n77 VPWR_n47 5.61485
R1675 VPWR_n78 VPWR_n10 5.61485
R1676 VPWR_n168 VPWR_n161 5.61485
R1677 VPWR_n184 VPWR_n161 5.61485
R1678 VPWR_n208 VPWR_n161 5.61485
R1679 VPWR_n220 VPWR_n161 5.61485
R1680 VPWR_n77 VPWR_n74 4.17719
R1681 VPWR_n77 VPWR_n72 4.17719
R1682 VPWR_n77 VPWR_n70 4.17719
R1683 VPWR_n77 VPWR_n68 4.17719
R1684 VPWR_n77 VPWR_n66 4.17719
R1685 VPWR_n77 VPWR_n64 4.17719
R1686 VPWR_n77 VPWR_n62 4.17719
R1687 VPWR_n77 VPWR_n43 4.17719
R1688 VPWR_n180 VPWR_n161 4.17719
R1689 VPWR_n182 VPWR_n161 4.17719
R1690 VPWR_n77 VPWR_n76 2.76442
R1691 VPWR_n78 VPWR_n8 2.75511
R1692 VPWR_n78 VPWR_n28 2.72093
R1693 VPWR VPWR_n235 1.15292
R1694 VPWR_n231 VPWR_n230 0.851
R1695 VPWR_n232 VPWR_t0 0.53175
R1696 VPWR_n28 VPWR_n27 0.34303
R1697 VPWR_n76 VPWR_n75 0.32772
R1698 VPWR_n78 VPWR_t5 0.327423
R1699 VPWR_n29 VPWR_n28 0.307138
R1700 VPWR_n9 VPWR_n8 0.306065
R1701 VPWR_t5 VPWR_n77 0.289636
R1702 VPWR_n161 VPWR_t29 0.288636
R1703 VPWR_n64 VPWR_n63 0.25528
R1704 VPWR_n66 VPWR_n65 0.25528
R1705 VPWR_n68 VPWR_n67 0.25528
R1706 VPWR_n70 VPWR_n69 0.25528
R1707 VPWR_n72 VPWR_n71 0.25528
R1708 VPWR_n74 VPWR_n73 0.25528
R1709 VPWR_n183 VPWR_n182 0.25528
R1710 VPWR_n181 VPWR_n180 0.25528
R1711 VPWR_n52 VPWR_n43 0.244511
R1712 VPWR_n221 VPWR_n220 0.235825
R1713 VPWR_n44 VPWR_n43 0.23278
R1714 VPWR_n62 VPWR_n61 0.23278
R1715 VPWR_n63 VPWR_n62 0.224511
R1716 VPWR_n65 VPWR_n64 0.224511
R1717 VPWR_n67 VPWR_n66 0.224511
R1718 VPWR_n69 VPWR_n68 0.224511
R1719 VPWR_n71 VPWR_n70 0.224511
R1720 VPWR_n73 VPWR_n72 0.224511
R1721 VPWR_n75 VPWR_n74 0.224511
R1722 VPWR_n182 VPWR_n181 0.224511
R1723 VPWR_n180 VPWR_n179 0.224511
R1724 VPWR_n209 VPWR_n208 0.222075
R1725 VPWR_n10 VPWR_n9 0.195825
R1726 VPWR_n169 VPWR_n168 0.192075
R1727 VPWR_n7 VPWR_n6 0.190118
R1728 VPWR_n37 VPWR_n36 0.190118
R1729 VPWR_n21 VPWR_n20 0.190118
R1730 VPWR_n50 VPWR_n47 0.185825
R1731 VPWR_n54 VPWR_n53 0.185486
R1732 VPWR_n55 VPWR_n42 0.185486
R1733 VPWR_n57 VPWR_n56 0.185486
R1734 VPWR_n34 VPWR_n33 0.183859
R1735 VPWR_n54 VPWR_n52 0.175825
R1736 VPWR_n53 VPWR_n42 0.175825
R1737 VPWR_n56 VPWR_n55 0.175825
R1738 VPWR_n185 VPWR_n184 0.173325
R1739 VPWR_n47 VPWR_n46 0.172986
R1740 VPWR_n30 VPWR_n29 0.169539
R1741 VPWR_n49 VPWR_n48 0.166554
R1742 VPWR_n141 VPWR_n140 0.166554
R1743 VPWR_n228 VPWR_n227 0.166554
R1744 VPWR_n208 VPWR_n207 0.165486
R1745 VPWR_n184 VPWR_n183 0.165486
R1746 VPWR_n168 VPWR_n167 0.165486
R1747 VPWR_n220 VPWR_n219 0.162986
R1748 VPWR_n41 VPWR_n38 0.162039
R1749 VPWR_n14 VPWR_n11 0.162039
R1750 VPWR_n4 VPWR_n3 0.162039
R1751 VPWR_n25 VPWR_n24 0.162039
R1752 VPWR_n104 VPWR_n101 0.162039
R1753 VPWR_n86 VPWR_n85 0.162039
R1754 VPWR_n165 VPWR_n164 0.154539
R1755 VPWR_n51 VPWR_n49 0.153289
R1756 VPWR_n197 VPWR_n196 0.139539
R1757 VPWR_n11 VPWR_n10 0.139236
R1758 VPWR_n144 VPWR_n143 0.138289
R1759 VPWR_n148 VPWR_n147 0.135789
R1760 VPWR_n215 VPWR_n214 0.135789
R1761 VPWR_n177 VPWR_n176 0.135789
R1762 VPWR_n27 VPWR_n26 0.133289
R1763 VPWR_n148 VPWR_n146 0.133289
R1764 VPWR_n96 VPWR_n95 0.12922
R1765 VPWR_n40 VPWR_n39 0.128884
R1766 VPWR_n13 VPWR_n12 0.128884
R1767 VPWR_n2 VPWR_n1 0.128884
R1768 VPWR_n32 VPWR_n31 0.128884
R1769 VPWR_n23 VPWR_n22 0.128884
R1770 VPWR_n128 VPWR_n127 0.128884
R1771 VPWR_n134 VPWR_n133 0.128884
R1772 VPWR_n46 VPWR_n45 0.128289
R1773 VPWR_n45 VPWR_n44 0.128289
R1774 VPWR_n60 VPWR_n59 0.128289
R1775 VPWR_n61 VPWR_n60 0.128289
R1776 VPWR_n138 VPWR_n137 0.128289
R1777 VPWR_n150 VPWR_n137 0.128289
R1778 VPWR_n93 VPWR_n92 0.126368
R1779 VPWR_n213 VPWR_n212 0.125789
R1780 VPWR_n80 VPWR_n79 0.121368
R1781 VPWR_n103 VPWR_n89 0.11925
R1782 VPWR_n108 VPWR_n107 0.11925
R1783 VPWR_n116 VPWR_n115 0.11925
R1784 VPWR_n113 VPWR_n84 0.11925
R1785 VPWR_n143 VPWR_n142 0.118289
R1786 VPWR_n51 VPWR_n50 0.115789
R1787 VPWR_n58 VPWR_n57 0.115789
R1788 VPWR_n214 VPWR_n213 0.115789
R1789 VPWR_n18 VPWR_n17 0.11425
R1790 VPWR_n121 VPWR_n120 0.11425
R1791 VPWR_n59 VPWR_n58 0.113289
R1792 VPWR_n204 VPWR_n203 0.113289
R1793 VPWR_n196 VPWR_n195 0.113289
R1794 VPWR_n191 VPWR_n190 0.113289
R1795 VPWR_n190 VPWR_n189 0.113289
R1796 VPWR_n176 VPWR_n175 0.113289
R1797 VPWR_n163 VPWR_n162 0.109575
R1798 VPWR_n84 VPWR_n82 0.10925
R1799 VPWR_n108 VPWR_n105 0.10925
R1800 VPWR_n110 VPWR_n88 0.10925
R1801 VPWR_n124 VPWR_n123 0.10925
R1802 VPWR_n157 VPWR_n156 0.10925
R1803 VPWR_n223 VPWR_n222 0.105789
R1804 VPWR_n217 VPWR_n216 0.105789
R1805 VPWR_n216 VPWR_n215 0.105789
R1806 VPWR_n212 VPWR_n211 0.105789
R1807 VPWR_n103 VPWR_n102 0.103337
R1808 VPWR_n115 VPWR_n114 0.103337
R1809 VPWR_n107 VPWR_n106 0.103002
R1810 VPWR_n113 VPWR_n112 0.103002
R1811 VPWR_n206 VPWR_n205 0.103
R1812 VPWR_n164 VPWR_n163 0.102039
R1813 VPWR_n117 VPWR_n83 0.10175
R1814 VPWR_n100 VPWR_n99 0.10175
R1815 VPWR_n109 VPWR_n87 0.10175
R1816 VPWR_n154 VPWR_n153 0.10175
R1817 VPWR_n97 VPWR_n94 0.096447
R1818 VPWR_n158 VPWR_n131 0.09425
R1819 VPWR_n201 VPWR_n200 0.09425
R1820 VPWR_n228 VPWR_n226 0.093
R1821 VPWR_n49 VPWR_n17 0.08675
R1822 VPWR_n141 VPWR_n120 0.08675
R1823 VPWR_n228 VPWR_n131 0.08675
R1824 VPWR_n173 VPWR_n172 0.08675
R1825 VPWR_n38 VPWR_n15 0.079539
R1826 VPWR_n5 VPWR_n4 0.079539
R1827 VPWR_n35 VPWR_n34 0.079539
R1828 VPWR_n26 VPWR_n25 0.079539
R1829 VPWR_n118 VPWR_n117 0.079539
R1830 VPWR_n99 VPWR_n90 0.079539
R1831 VPWR_n205 VPWR_n204 0.078289
R1832 VPWR_n219 VPWR_n218 0.078
R1833 VPWR_n98 VPWR_n97 0.0755
R1834 VPWR_n224 VPWR_n223 0.0755
R1835 VPWR_n218 VPWR_n217 0.0755
R1836 VPWR_n211 VPWR_n210 0.0755
R1837 VPWR_n207 VPWR_n206 0.0755
R1838 VPWR_n193 VPWR_n192 0.0755
R1839 VPWR_n187 VPWR_n186 0.0755
R1840 VPWR_n179 VPWR_n178 0.0755
R1841 VPWR_n167 VPWR_n166 0.0755
R1842 VPWR_n15 VPWR_n0 0.072039
R1843 VPWR_n6 VPWR_n5 0.072039
R1844 VPWR_n36 VPWR_n35 0.072039
R1845 VPWR_n20 VPWR_n19 0.072039
R1846 VPWR_n118 VPWR_n81 0.072039
R1847 VPWR_n91 VPWR_n90 0.072039
R1848 VPWR_n123 VPWR_n122 0.072039
R1849 VPWR_n160 VPWR_n157 0.072039
R1850 VPWR_n80 VPWR_n0 0.06925
R1851 VPWR_n234 VPWR_n81 0.06925
R1852 VPWR_n149 VPWR_n136 0.068
R1853 VPWR_n154 VPWR_n152 0.068
R1854 VPWR_n203 VPWR_n202 0.068
R1855 VPWR_n200 VPWR_n199 0.068
R1856 VPWR_n195 VPWR_n194 0.068
R1857 VPWR_n192 VPWR_n191 0.068
R1858 VPWR_n189 VPWR_n188 0.068
R1859 VPWR_n186 VPWR_n185 0.068
R1860 VPWR_n175 VPWR_n174 0.068
R1861 VPWR_n172 VPWR_n171 0.068
R1862 VPWR_n126 VPWR_n125 0.067875
R1863 VPWR_n19 VPWR_n18 0.067039
R1864 VPWR_n122 VPWR_n121 0.067039
R1865 VPWR_n160 VPWR_n159 0.067039
R1866 VPWR_n155 VPWR_n132 0.066625
R1867 VPWR_n41 VPWR_n40 0.065789
R1868 VPWR_n14 VPWR_n13 0.065789
R1869 VPWR_n3 VPWR_n2 0.065789
R1870 VPWR_n24 VPWR_n23 0.065789
R1871 VPWR_n222 VPWR_n221 0.065789
R1872 VPWR_n130 VPWR_n129 0.0655
R1873 VPWR_n225 VPWR_n224 0.0655
R1874 VPWR_n92 VPWR_n91 0.06425
R1875 VPWR_n32 VPWR_n30 0.062039
R1876 VPWR_n104 VPWR_n103 0.062039
R1877 VPWR_n115 VPWR_n85 0.062039
R1878 VPWR_n129 VPWR_n83 0.0555
R1879 VPWR_n156 VPWR_n155 0.0555
R1880 VPWR_n226 VPWR_n225 0.0555
R1881 VPWR_n125 VPWR_n124 0.05425
R1882 VPWR_n139 VPWR_n138 0.053
R1883 VPWR_n151 VPWR_n150 0.053
R1884 VPWR_n151 VPWR_n149 0.053
R1885 VPWR_n152 VPWR_n135 0.053
R1886 VPWR_n199 VPWR_n198 0.053
R1887 VPWR_n171 VPWR_n170 0.053
R1888 VPWR_n170 VPWR_n169 0.04925
R1889 VPWR_n146 VPWR_n145 0.048
R1890 VPWR_n147 VPWR_n139 0.0455
R1891 VPWR_n194 VPWR_n193 0.0455
R1892 VPWR_n188 VPWR_n187 0.0455
R1893 VPWR_n178 VPWR_n177 0.0455
R1894 VPWR_n33 VPWR_n32 0.0448003
R1895 VPWR_n145 VPWR_n144 0.043
R1896 VPWR_n40 VPWR_n37 0.0423097
R1897 VPWR_n23 VPWR_n21 0.0423097
R1898 VPWR_n79 VPWR_n2 0.0423097
R1899 VPWR_n13 VPWR_n7 0.0423097
R1900 VPWR_n96 VPWR_n93 0.0423097
R1901 VPWR_n198 VPWR_n197 0.04175
R1902 VPWR_n234 VPWR_n233 0.0405
R1903 VPWR_n142 VPWR_n141 0.0355
R1904 VPWR_n174 VPWR_n173 0.03425
R1905 VPWR_n202 VPWR_n201 0.02675
R1906 VPWR_n166 VPWR_n165 0.02675
R1907 VPWR_n159 VPWR_n158 0.0205
R1908 VPWR_n101 VPWR_n100 0.01925
R1909 VPWR_n111 VPWR_n109 0.01925
R1910 VPWR_n87 VPWR_n86 0.01925
R1911 VPWR_n153 VPWR_n136 0.01925
R1912 VPWR_n210 VPWR_n209 0.01925
R1913 VPWR_n233 VPWR_n82 0.01175
R1914 VPWR_n105 VPWR_n88 0.01175
R1915 VPWR_n111 VPWR_n110 0.01175
R1916 VPWR_n130 VPWR_n128 0.0055
R1917 VPWR_n98 VPWR_n96 0.0055
R1918 VPWR_n135 VPWR_n134 0.0055
R1919 VPWR_n107 VPWR_n89 0.00175
R1920 VPWR_n116 VPWR_n113 0.00175
R1921 VPWR_n128 VPWR_n126 0.00162498
R1922 VPWR_n134 VPWR_n132 0.00162498
R1923 VPWR_n78 VPWR_n16 0.001
R1924 VPWR_n77 VPWR_n16 0.001
R1925 VPWR_n230 VPWR_n229 0.001
R1926 VPWR_t0 VPWR_n231 0.001
R1927 VPWR_n232 VPWR_n119 0.001
R1928 VPWR_n230 VPWR_n119 0.001
R1929 VPWR_n229 VPWR_n161 0.001
R1930 VPWR_n231 VPWR_t29 0.001
R1931 AVDD_n832 AVDD_n824 32.5927
R1932 AVDD_n375 AVDD_n367 32.5927
R1933 AVDD_n829 AVDD_n828 28.679
R1934 AVDD_n372 AVDD_n371 28.6789
R1935 AVDD_n374 AVDD_n368 28.052
R1936 AVDD_n831 AVDD_n825 28.052
R1937 AVDD_n829 AVDD_n827 27.9975
R1938 AVDD_n830 AVDD_n826 27.9975
R1939 AVDD_n373 AVDD_n369 27.9973
R1940 AVDD_n372 AVDD_n370 27.9973
R1941 AVDD_n834 AVDD_n807 27.9416
R1942 AVDD_n377 AVDD_n350 27.9416
R1943 AVDD_n833 AVDD_n812 27.9229
R1944 AVDD_n376 AVDD_n355 27.9229
R1945 AVDD_n836 AVDD_n489 27.464
R1946 AVDD_n811 AVDD_n810 17.0555
R1947 AVDD_n354 AVDD_n352 17.0555
R1948 AVDD_n346 AVDD_n0 17.0199
R1949 AVDD_t155 AVDD_t61 17.0005
R1950 AVDD_t161 AVDD_t61 17.0005
R1951 AVDD_t162 AVDD_t61 17.0005
R1952 AVDD_t163 AVDD_t61 17.0005
R1953 AVDD_t164 AVDD_t61 17.0005
R1954 AVDD_t165 AVDD_t61 17.0005
R1955 AVDD_t166 AVDD_t61 17.0005
R1956 AVDD_t167 AVDD_t61 17.0005
R1957 AVDD_t168 AVDD_t61 17.0005
R1958 AVDD_t169 AVDD_t61 17.0005
R1959 AVDD_t170 AVDD_t61 17.0005
R1960 AVDD_t171 AVDD_t61 17.0005
R1961 AVDD_t172 AVDD_t61 17.0005
R1962 AVDD_t146 AVDD_t62 17.0005
R1963 AVDD_t173 AVDD_t62 17.0005
R1964 AVDD_t174 AVDD_t62 17.0005
R1965 AVDD_t175 AVDD_t62 17.0005
R1966 AVDD_t176 AVDD_t62 17.0005
R1967 AVDD_t177 AVDD_t62 17.0005
R1968 AVDD_t178 AVDD_t62 17.0005
R1969 AVDD_t179 AVDD_t62 17.0005
R1970 AVDD_t180 AVDD_t62 17.0005
R1971 AVDD_t181 AVDD_t62 17.0005
R1972 AVDD_t182 AVDD_t62 17.0005
R1973 AVDD_t183 AVDD_t62 17.0005
R1974 AVDD_t184 AVDD_t62 17.0005
R1975 AVDD_t147 AVDD_t71 17.0005
R1976 AVDD_t148 AVDD_t71 17.0005
R1977 AVDD_t149 AVDD_t71 17.0005
R1978 AVDD_t150 AVDD_t71 17.0005
R1979 AVDD_t151 AVDD_t71 17.0005
R1980 AVDD_t152 AVDD_t71 17.0005
R1981 AVDD_t153 AVDD_t71 17.0005
R1982 AVDD_t154 AVDD_t71 17.0005
R1983 AVDD_t156 AVDD_t71 17.0005
R1984 AVDD_t157 AVDD_t71 17.0005
R1985 AVDD_t158 AVDD_t71 17.0005
R1986 AVDD_t159 AVDD_t71 17.0005
R1987 AVDD_t160 AVDD_t71 17.0005
R1988 AVDD_n543 AVDD_n490 17.0005
R1989 AVDD_n762 AVDD_n490 17.0005
R1990 AVDD_n761 AVDD_n490 17.0005
R1991 AVDD_n758 AVDD_n490 17.0005
R1992 AVDD_n759 AVDD_n490 17.0005
R1993 AVDD_n537 AVDD_n490 17.0005
R1994 AVDD_n539 AVDD_n490 17.0005
R1995 AVDD_n540 AVDD_n490 17.0005
R1996 AVDD_n752 AVDD_n490 17.0005
R1997 AVDD_t133 AVDD_n490 17.0005
R1998 AVDD_n525 AVDD_n490 17.0005
R1999 AVDD_n748 AVDD_n490 17.0005
R2000 AVDD_n733 AVDD_n490 17.0005
R2001 AVDD_n734 AVDD_n490 17.0005
R2002 AVDD_n735 AVDD_n490 17.0005
R2003 AVDD_t120 AVDD_n490 17.0005
R2004 AVDD_t207 AVDD_n490 17.0005
R2005 AVDD_n737 AVDD_n490 17.0005
R2006 AVDD_n556 AVDD_n490 17.0005
R2007 AVDD_n560 AVDD_n490 17.0005
R2008 AVDD_n563 AVDD_n490 17.0005
R2009 AVDD_n565 AVDD_n490 17.0005
R2010 AVDD_n568 AVDD_n490 17.0005
R2011 AVDD_n570 AVDD_n490 17.0005
R2012 AVDD_n573 AVDD_n490 17.0005
R2013 AVDD_n575 AVDD_n490 17.0005
R2014 AVDD_n580 AVDD_n490 17.0005
R2015 AVDD_n582 AVDD_n490 17.0005
R2016 AVDD_n579 AVDD_n490 17.0005
R2017 AVDD_n577 AVDD_n490 17.0005
R2018 AVDD_n794 AVDD_n793 17.0005
R2019 AVDD_n698 AVDD_n697 17.0005
R2020 AVDD_n698 AVDD_n632 17.0005
R2021 AVDD_n698 AVDD_n695 17.0005
R2022 AVDD_n698 AVDD_t198 17.0005
R2023 AVDD_n698 AVDD_n655 17.0005
R2024 AVDD_n698 AVDD_n635 17.0005
R2025 AVDD_n698 AVDD_n653 17.0005
R2026 AVDD_n698 AVDD_n636 17.0005
R2027 AVDD_n698 AVDD_n643 17.0005
R2028 AVDD_n698 AVDD_n637 17.0005
R2029 AVDD_n698 AVDD_n641 17.0005
R2030 AVDD_n698 AVDD_t196 17.0005
R2031 AVDD_n698 AVDD_t40 17.0005
R2032 AVDD_n698 AVDD_n638 17.0005
R2033 AVDD_n820 AVDD_n813 17.0005
R2034 AVDD_n817 AVDD_n814 17.0005
R2035 AVDD_n812 AVDD_n811 17.0005
R2036 AVDD_n807 AVDD_n806 17.0005
R2037 AVDD_t79 AVDD_t80 17.0005
R2038 AVDD_t79 AVDD_t81 17.0005
R2039 AVDD_t79 AVDD_t82 17.0005
R2040 AVDD_t79 AVDD_t83 17.0005
R2041 AVDD_t84 AVDD_t79 17.0005
R2042 AVDD_t63 AVDD_t85 17.0005
R2043 AVDD_t63 AVDD_t86 17.0005
R2044 AVDD_t63 AVDD_t87 17.0005
R2045 AVDD_t63 AVDD_t88 17.0005
R2046 AVDD_t63 AVDD_t89 17.0005
R2047 AVDD_t63 AVDD_t90 17.0005
R2048 AVDD_t63 AVDD_t91 17.0005
R2049 AVDD_t63 AVDD_t92 17.0005
R2050 AVDD_n330 AVDD_n43 17.0005
R2051 AVDD_n330 AVDD_n78 17.0005
R2052 AVDD_n330 AVDD_n44 17.0005
R2053 AVDD_n330 AVDD_n76 17.0005
R2054 AVDD_n330 AVDD_n45 17.0005
R2055 AVDD_n330 AVDD_n74 17.0005
R2056 AVDD_n330 AVDD_t107 17.0005
R2057 AVDD_n330 AVDD_n72 17.0005
R2058 AVDD_n330 AVDD_n46 17.0005
R2059 AVDD_n330 AVDD_n70 17.0005
R2060 AVDD_n330 AVDD_n47 17.0005
R2061 AVDD_n330 AVDD_n48 17.0005
R2062 AVDD_n330 AVDD_n66 17.0005
R2063 AVDD_n330 AVDD_n49 17.0005
R2064 AVDD_n330 AVDD_n64 17.0005
R2065 AVDD_n330 AVDD_n50 17.0005
R2066 AVDD_n330 AVDD_n62 17.0005
R2067 AVDD_n330 AVDD_n51 17.0005
R2068 AVDD_n330 AVDD_t54 17.0005
R2069 AVDD_n330 AVDD_n52 17.0005
R2070 AVDD_n330 AVDD_n61 17.0005
R2071 AVDD_n330 AVDD_n53 17.0005
R2072 AVDD_n330 AVDD_n60 17.0005
R2073 AVDD_n330 AVDD_t220 17.0005
R2074 AVDD_n330 AVDD_n59 17.0005
R2075 AVDD_n330 AVDD_n54 17.0005
R2076 AVDD_n330 AVDD_t218 17.0005
R2077 AVDD_n330 AVDD_n32 17.0005
R2078 AVDD_n330 AVDD_n29 17.0005
R2079 AVDD_n330 AVDD_n55 17.0005
R2080 AVDD_n330 AVDD_n56 17.0005
R2081 AVDD_n330 AVDD_n58 17.0005
R2082 AVDD_n330 AVDD_n57 17.0005
R2083 AVDD_t230 AVDD_n164 17.0005
R2084 AVDD_n229 AVDD_n164 17.0005
R2085 AVDD_n228 AVDD_n164 17.0005
R2086 AVDD_t112 AVDD_n164 17.0005
R2087 AVDD_n279 AVDD_n164 17.0005
R2088 AVDD_n181 AVDD_n164 17.0005
R2089 AVDD_n196 AVDD_n164 17.0005
R2090 AVDD_n225 AVDD_n164 17.0005
R2091 AVDD_n223 AVDD_n164 17.0005
R2092 AVDD_n201 AVDD_n164 17.0005
R2093 AVDD_n202 AVDD_n164 17.0005
R2094 AVDD_t110 AVDD_n164 17.0005
R2095 AVDD_t46 AVDD_n164 17.0005
R2096 AVDD_n190 AVDD_n164 17.0005
R2097 AVDD_t69 AVDD_n164 17.0005
R2098 AVDD_n210 AVDD_n164 17.0005
R2099 AVDD_t68 AVDD_n164 17.0005
R2100 AVDD_n214 AVDD_n164 17.0005
R2101 AVDD_n212 AVDD_n164 17.0005
R2102 AVDD_t66 AVDD_n164 17.0005
R2103 AVDD_n215 AVDD_n164 17.0005
R2104 AVDD_t64 AVDD_n164 17.0005
R2105 AVDD_n217 AVDD_n164 17.0005
R2106 AVDD_n219 AVDD_n164 17.0005
R2107 AVDD_n183 AVDD_n164 17.0005
R2108 AVDD_n350 AVDD_n349 17.0005
R2109 AVDD_n355 AVDD_n354 17.0005
R2110 AVDD_n364 AVDD_n361 17.0005
R2111 AVDD_n366 AVDD_n357 17.0005
R2112 AVDD_n835 AVDD_n803 14.9459
R2113 AVDD_n378 AVDD_n346 13.6618
R2114 AVDD_n416 AVDD_t172 8.79188
R2115 AVDD_n401 AVDD_t184 8.79188
R2116 AVDD_n435 AVDD_t160 8.79188
R2117 AVDD_n392 AVDD_t80 8.79188
R2118 AVDD_n821 AVDD_t189 8.76154
R2119 AVDD_n823 AVDD_t137 8.76154
R2120 AVDD_n356 AVDD_t39 8.76154
R2121 AVDD_n358 AVDD_t42 8.76154
R2122 AVDD_n283 AVDD_n282 8.61936
R2123 AVDD_n87 AVDD_n79 8.61464
R2124 AVDD_n421 AVDD_t155 8.56018
R2125 AVDD_n406 AVDD_t146 8.56018
R2126 AVDD_n440 AVDD_t147 8.56018
R2127 AVDD_n382 AVDD_t92 8.56018
R2128 AVDD_n800 AVDD_n799 8.501
R2129 AVDD_n799 AVDD_n492 8.501
R2130 AVDD_n799 AVDD_n496 8.501
R2131 AVDD_n799 AVDD_n494 8.501
R2132 AVDD_n799 AVDD_n499 8.501
R2133 AVDD_n799 AVDD_n493 8.501
R2134 AVDD_n718 AVDD_n504 8.501
R2135 AVDD_n718 AVDD_n604 8.501
R2136 AVDD_n718 AVDD_n605 8.501
R2137 AVDD_n718 AVDD_n606 8.501
R2138 AVDD_n718 AVDD_n607 8.501
R2139 AVDD_n718 AVDD_n608 8.501
R2140 AVDD_n718 AVDD_n609 8.501
R2141 AVDD_n718 AVDD_n610 8.501
R2142 AVDD_n718 AVDD_n611 8.501
R2143 AVDD_n718 AVDD_n613 8.501
R2144 AVDD_n718 AVDD_n614 8.501
R2145 AVDD_n718 AVDD_n615 8.501
R2146 AVDD_n718 AVDD_n717 8.501
R2147 AVDD_t93 AVDD_n0 8.501
R2148 AVDD_t93 AVDD_n22 8.501
R2149 AVDD_t93 AVDD_n18 8.501
R2150 AVDD_t93 AVDD_n17 8.501
R2151 AVDD_t93 AVDD_n15 8.501
R2152 AVDD_t93 AVDD_n14 8.501
R2153 AVDD_n295 AVDD_n158 8.501
R2154 AVDD_n295 AVDD_n154 8.501
R2155 AVDD_n136 AVDD_n108 8.501
R2156 AVDD_n134 AVDD_n110 8.501
R2157 AVDD_n132 AVDD_n112 8.501
R2158 AVDD_n130 AVDD_n114 8.501
R2159 AVDD_n128 AVDD_t3 8.501
R2160 AVDD_n149 AVDD_n147 8.501
R2161 AVDD_n123 AVDD_n118 8.501
R2162 AVDD_n297 AVDD_n103 8.501
R2163 AVDD_n421 AVDD_t161 8.5005
R2164 AVDD_n422 AVDD_t162 8.5005
R2165 AVDD_n423 AVDD_t163 8.5005
R2166 AVDD_n424 AVDD_t164 8.5005
R2167 AVDD_n425 AVDD_t165 8.5005
R2168 AVDD_n426 AVDD_t166 8.5005
R2169 AVDD_n427 AVDD_t167 8.5005
R2170 AVDD_n419 AVDD_t168 8.5005
R2171 AVDD_n418 AVDD_t169 8.5005
R2172 AVDD_n417 AVDD_t170 8.5005
R2173 AVDD_n416 AVDD_t171 8.5005
R2174 AVDD_n406 AVDD_t173 8.5005
R2175 AVDD_n407 AVDD_t174 8.5005
R2176 AVDD_n408 AVDD_t175 8.5005
R2177 AVDD_n409 AVDD_t176 8.5005
R2178 AVDD_n410 AVDD_t177 8.5005
R2179 AVDD_n411 AVDD_t178 8.5005
R2180 AVDD_n412 AVDD_t179 8.5005
R2181 AVDD_n404 AVDD_t180 8.5005
R2182 AVDD_n403 AVDD_t181 8.5005
R2183 AVDD_n402 AVDD_t182 8.5005
R2184 AVDD_n401 AVDD_t183 8.5005
R2185 AVDD_n440 AVDD_t148 8.5005
R2186 AVDD_n441 AVDD_t149 8.5005
R2187 AVDD_n442 AVDD_t150 8.5005
R2188 AVDD_n443 AVDD_t151 8.5005
R2189 AVDD_n444 AVDD_t152 8.5005
R2190 AVDD_n445 AVDD_t153 8.5005
R2191 AVDD_n446 AVDD_t154 8.5005
R2192 AVDD_n438 AVDD_t156 8.5005
R2193 AVDD_n437 AVDD_t157 8.5005
R2194 AVDD_n436 AVDD_t158 8.5005
R2195 AVDD_n435 AVDD_t159 8.5005
R2196 AVDD_n545 AVDD_n490 8.5005
R2197 AVDD_n542 AVDD_n490 8.5005
R2198 AVDD_t209 AVDD_n490 8.5005
R2199 AVDD_n547 AVDD_n490 8.5005
R2200 AVDD_n554 AVDD_n490 8.5005
R2201 AVDD_n558 AVDD_n490 8.5005
R2202 AVDD_t203 AVDD_n490 8.5005
R2203 AVDD_t201 AVDD_n490 8.5005
R2204 AVDD_n698 AVDD_n633 8.5005
R2205 AVDD_n698 AVDD_n640 8.5005
R2206 AVDD_n698 AVDD_n639 8.5005
R2207 AVDD_n768 AVDD_t129 8.5005
R2208 AVDD_n768 AVDD_t120 8.5005
R2209 AVDD_n768 AVDD_t207 8.5005
R2210 AVDD_n765 AVDD_n748 8.5005
R2211 AVDD_n692 AVDD_n633 8.5005
R2212 AVDD_n692 AVDD_n637 8.5005
R2213 AVDD_n697 AVDD_n601 8.5005
R2214 AVDD_n632 AVDD_n601 8.5005
R2215 AVDD_n695 AVDD_n601 8.5005
R2216 AVDD_n633 AVDD_n601 8.5005
R2217 AVDD_n655 AVDD_n601 8.5005
R2218 AVDD_n641 AVDD_n601 8.5005
R2219 AVDD_t196 AVDD_n601 8.5005
R2220 AVDD_t40 AVDD_n601 8.5005
R2221 AVDD_n767 AVDD_n539 8.5005
R2222 AVDD_n767 AVDD_n540 8.5005
R2223 AVDD_n746 AVDD_n733 8.5005
R2224 AVDD_n746 AVDD_n734 8.5005
R2225 AVDD_n746 AVDD_n735 8.5005
R2226 AVDD_n746 AVDD_n737 8.5005
R2227 AVDD_n762 AVDD_n531 8.5005
R2228 AVDD_n761 AVDD_n531 8.5005
R2229 AVDD_n758 AVDD_n531 8.5005
R2230 AVDD_n759 AVDD_n531 8.5005
R2231 AVDD_n537 AVDD_n531 8.5005
R2232 AVDD_n539 AVDD_n531 8.5005
R2233 AVDD_n540 AVDD_n531 8.5005
R2234 AVDD_n752 AVDD_n531 8.5005
R2235 AVDD_t133 AVDD_n531 8.5005
R2236 AVDD_t81 AVDD_n392 8.5005
R2237 AVDD_n391 AVDD_t82 8.5005
R2238 AVDD_t83 AVDD_n389 8.5005
R2239 AVDD_n393 AVDD_t84 8.5005
R2240 AVDD_t85 AVDD_n397 8.5005
R2241 AVDD_n387 AVDD_t86 8.5005
R2242 AVDD_n386 AVDD_t87 8.5005
R2243 AVDD_n385 AVDD_t88 8.5005
R2244 AVDD_n384 AVDD_t89 8.5005
R2245 AVDD_n383 AVDD_t90 8.5005
R2246 AVDD_n382 AVDD_t91 8.5005
R2247 AVDD_n330 AVDD_t222 8.5005
R2248 AVDD_n330 AVDD_t101 8.5005
R2249 AVDD_n330 AVDD_t99 8.5005
R2250 AVDD_n334 AVDD_t95 8.5005
R2251 AVDD_n334 AVDD_n333 8.5005
R2252 AVDD_n173 AVDD_n164 8.5005
R2253 AVDD_n220 AVDD_n164 8.5005
R2254 AVDD_n296 AVDD_n108 8.5005
R2255 AVDD_n296 AVDD_n110 8.5005
R2256 AVDD_n296 AVDD_n112 8.5005
R2257 AVDD_n296 AVDD_n114 8.5005
R2258 AVDD_n296 AVDD_t3 8.5005
R2259 AVDD_n296 AVDD_n149 8.5005
R2260 AVDD_n296 AVDD_n118 8.5005
R2261 AVDD_n297 AVDD_n296 8.5005
R2262 AVDD_n222 AVDD_t110 8.5005
R2263 AVDD_n222 AVDD_t69 8.5005
R2264 AVDD_n222 AVDD_n214 8.5005
R2265 AVDD_n331 AVDD_t54 8.5005
R2266 AVDD_n331 AVDD_n32 8.5005
R2267 AVDD_n331 AVDD_n29 8.5005
R2268 AVDD_n245 AVDD_n54 8.5005
R2269 AVDD_n62 AVDD_n40 8.5005
R2270 AVDD_n51 AVDD_n40 8.5005
R2271 AVDD_n52 AVDD_n40 8.5005
R2272 AVDD_n61 AVDD_n40 8.5005
R2273 AVDD_n53 AVDD_n40 8.5005
R2274 AVDD_n60 AVDD_n40 8.5005
R2275 AVDD_n237 AVDD_n54 8.5005
R2276 AVDD_n237 AVDD_t218 8.5005
R2277 AVDD_n237 AVDD_n32 8.5005
R2278 AVDD_n237 AVDD_n29 8.5005
R2279 AVDD_n237 AVDD_n55 8.5005
R2280 AVDD_n237 AVDD_n56 8.5005
R2281 AVDD_n237 AVDD_n58 8.5005
R2282 AVDD_n237 AVDD_n57 8.5005
R2283 AVDD_n277 AVDD_n228 8.5005
R2284 AVDD_n277 AVDD_t46 8.5005
R2285 AVDD_n277 AVDD_n190 8.5005
R2286 AVDD_t230 AVDD_n180 8.5005
R2287 AVDD_n229 AVDD_n180 8.5005
R2288 AVDD_n201 AVDD_n180 8.5005
R2289 AVDD_n202 AVDD_n180 8.5005
R2290 AVDD_n210 AVDD_n180 8.5005
R2291 AVDD_t68 AVDD_n180 8.5005
R2292 AVDD_t66 AVDD_n180 8.5005
R2293 AVDD_n215 AVDD_n180 8.5005
R2294 AVDD_t64 AVDD_n180 8.5005
R2295 AVDD_n217 AVDD_n180 8.5005
R2296 AVDD_n219 AVDD_n180 8.5005
R2297 AVDD_n806 AVDD_n805 8.49851
R2298 AVDD_n349 AVDD_n348 8.49851
R2299 AVDD_n345 AVDD_n1 8.48401
R2300 AVDD_n471 AVDD_n470 8.48209
R2301 AVDD_n461 AVDD_n460 8.48209
R2302 AVDD_n455 AVDD_n454 8.48209
R2303 AVDD_n487 AVDD_t22 8.48159
R2304 AVDD_n482 AVDD_t17 8.48159
R2305 AVDD_n477 AVDD_t11 8.48159
R2306 AVDD_n472 AVDD_t6 8.48159
R2307 AVDD_t6 AVDD_n453 8.48159
R2308 AVDD_n822 AVDD_n813 8.47111
R2309 AVDD_n824 AVDD_n813 8.47111
R2310 AVDD_n367 AVDD_n366 8.47111
R2311 AVDD_n366 AVDD_n359 8.47111
R2312 AVDD_n802 AVDD_n801 8.46995
R2313 AVDD_n495 AVDD_n491 8.46995
R2314 AVDD_n789 AVDD_n788 8.46995
R2315 AVDD_n790 AVDD_n787 8.46995
R2316 AVDD_n791 AVDD_n786 8.46995
R2317 AVDD_n792 AVDD_n785 8.46995
R2318 AVDD_n703 AVDD_n629 8.46995
R2319 AVDD_n704 AVDD_n628 8.46995
R2320 AVDD_n705 AVDD_n627 8.46995
R2321 AVDD_n706 AVDD_n626 8.46995
R2322 AVDD_n707 AVDD_n625 8.46995
R2323 AVDD_n708 AVDD_n624 8.46995
R2324 AVDD_n709 AVDD_n623 8.46995
R2325 AVDD_n710 AVDD_n622 8.46995
R2326 AVDD_n712 AVDD_n620 8.46995
R2327 AVDD_n713 AVDD_n619 8.46995
R2328 AVDD_n714 AVDD_n618 8.46995
R2329 AVDD_n716 AVDD_n715 8.46995
R2330 AVDD_n617 AVDD_n616 8.46995
R2331 AVDD_n765 AVDD_n757 8.46995
R2332 AVDD_n336 AVDD_n10 8.46995
R2333 AVDD_n340 AVDD_n6 8.46995
R2334 AVDD_n341 AVDD_n5 8.46995
R2335 AVDD_n343 AVDD_n3 8.46995
R2336 AVDD_n344 AVDD_n2 8.46995
R2337 AVDD_n289 AVDD_n161 8.46995
R2338 AVDD_n290 AVDD_n160 8.46995
R2339 AVDD_n291 AVDD_n159 8.46995
R2340 AVDD_n138 AVDD_n137 8.46995
R2341 AVDD_n139 AVDD_n135 8.46995
R2342 AVDD_n140 AVDD_n133 8.46995
R2343 AVDD_n141 AVDD_n131 8.46995
R2344 AVDD_n142 AVDD_n129 8.46995
R2345 AVDD_n146 AVDD_n127 8.46995
R2346 AVDD_n126 AVDD_n120 8.46995
R2347 AVDD_n125 AVDD_n124 8.46995
R2348 AVDD_n90 AVDD_n89 8.46995
R2349 AVDD_n89 AVDD_n88 8.46995
R2350 AVDD_n331 AVDD_n31 8.46995
R2351 AVDD_n489 AVDD_n488 7.83279
R2352 AVDD_n816 AVDD_t72 6.72112
R2353 AVDD_n360 AVDD_t0 6.72012
R2354 AVDD_n816 AVDD_t145 6.15759
R2355 AVDD_n360 AVDD_t76 6.15759
R2356 AVDD_n369 AVDD_t216 6.11392
R2357 AVDD_n370 AVDD_t45 6.11392
R2358 AVDD_n371 AVDD_t124 6.11392
R2359 AVDD_n828 AVDD_t59 6.11376
R2360 AVDD_n827 AVDD_t122 6.11376
R2361 AVDD_n826 AVDD_t74 6.11376
R2362 AVDD_n825 AVDD_t139 6.00228
R2363 AVDD_n368 AVDD_t2 6.00228
R2364 AVDD_n805 AVDD_t143 5.99877
R2365 AVDD_n348 AVDD_t5 5.99877
R2366 AVDD_n818 AVDD_t123 5.97212
R2367 AVDD_n362 AVDD_t43 5.97212
R2368 AVDD_n810 AVDD_t144 5.96578
R2369 AVDD_n352 AVDD_t78 5.96578
R2370 AVDD_t142 AVDD_n804 5.9613
R2371 AVDD_t4 AVDD_n347 5.9589
R2372 AVDD_n319 AVDD_t224 5.85645
R2373 AVDD_n518 AVDD_t128 5.85066
R2374 AVDD_n718 AVDD_n603 5.66778
R2375 AVDD_n718 AVDD_n612 5.66778
R2376 AVDD_t93 AVDD_n21 5.66778
R2377 AVDD_t93 AVDD_n20 5.66778
R2378 AVDD_t93 AVDD_n19 5.66778
R2379 AVDD_t93 AVDD_n16 5.66778
R2380 AVDD_n295 AVDD_n157 5.66778
R2381 AVDD_n295 AVDD_n156 5.66778
R2382 AVDD_n295 AVDD_n155 5.66778
R2383 AVDD_n145 AVDD_n117 5.66778
R2384 AVDD_n299 AVDD_n101 5.66778
R2385 AVDD_n244 AVDD_n13 5.66767
R2386 AVDD_n299 AVDD_n102 5.66767
R2387 AVDD_t212 AVDD_n490 5.66717
R2388 AVDD_t41 AVDD_n490 5.66717
R2389 AVDD_t125 AVDD_n490 5.66717
R2390 AVDD_n698 AVDD_t187 5.66717
R2391 AVDD_n806 AVDD_t142 5.66717
R2392 AVDD_n330 AVDD_t105 5.66717
R2393 AVDD_n330 AVDD_t97 5.66717
R2394 AVDD_n276 AVDD_n164 5.66717
R2395 AVDD_n296 AVDD_n117 5.66717
R2396 AVDD_n349 AVDD_t4 5.66717
R2397 AVDD_n819 AVDD_n814 5.61485
R2398 AVDD_n364 AVDD_n363 5.61485
R2399 AVDD_n702 AVDD_n630 5.61281
R2400 AVDD_n711 AVDD_n621 5.61281
R2401 AVDD_n337 AVDD_n9 5.61281
R2402 AVDD_n338 AVDD_n8 5.61281
R2403 AVDD_n339 AVDD_n7 5.61281
R2404 AVDD_n342 AVDD_n4 5.61281
R2405 AVDD_n287 AVDD_n163 5.61281
R2406 AVDD_n288 AVDD_n162 5.61281
R2407 AVDD_n144 AVDD_n143 5.61281
R2408 AVDD_n122 AVDD_n121 5.61281
R2409 AVDD_n767 AVDD_n534 5.61281
R2410 AVDD_n254 AVDD_n40 5.61281
R2411 AVDD_n256 AVDD_t225 5.44361
R2412 AVDD_n723 AVDD_t126 5.43734
R2413 AVDD_n828 AVDD_t58 4.89247
R2414 AVDD_n827 AVDD_t49 4.89247
R2415 AVDD_n826 AVDD_t73 4.89247
R2416 AVDD_n369 AVDD_t60 4.89166
R2417 AVDD_n370 AVDD_t44 4.89166
R2418 AVDD_n371 AVDD_t50 4.89166
R2419 AVDD_n825 AVDD_t138 4.88458
R2420 AVDD_n368 AVDD_t1 4.88395
R2421 AVDD_n836 AVDD_n835 4.72951
R2422 AVDD_n256 AVDD_n234 4.58808
R2423 AVDD_n723 AVDD_n585 4.58638
R2424 AVDD_n488 AVDD_t24 4.34779
R2425 AVDD_n485 AVDD_t21 4.34779
R2426 AVDD_n484 AVDD_t20 4.34779
R2427 AVDD_n483 AVDD_t19 4.34779
R2428 AVDD_n480 AVDD_t15 4.34779
R2429 AVDD_n479 AVDD_t14 4.34779
R2430 AVDD_n478 AVDD_t13 4.34779
R2431 AVDD_n475 AVDD_t10 4.34779
R2432 AVDD_n474 AVDD_t9 4.34779
R2433 AVDD_n473 AVDD_t8 4.34779
R2434 AVDD_n452 AVDD_t37 4.34688
R2435 AVDD_n459 AVDD_t33 4.34688
R2436 AVDD_n458 AVDD_t34 4.34688
R2437 AVDD_n457 AVDD_t35 4.34688
R2438 AVDD_n465 AVDD_t29 4.34688
R2439 AVDD_n464 AVDD_t30 4.34688
R2440 AVDD_n463 AVDD_t31 4.34688
R2441 AVDD_n466 AVDD_t25 4.34688
R2442 AVDD_n467 AVDD_t27 4.34688
R2443 AVDD_n468 AVDD_t26 4.34688
R2444 AVDD_n472 AVDD_t7 4.33459
R2445 AVDD_n453 AVDD_t16 4.33368
R2446 AVDD_n486 AVDD_t23 4.26185
R2447 AVDD_n481 AVDD_t18 4.26185
R2448 AVDD_n476 AVDD_t12 4.26185
R2449 AVDD_n456 AVDD_t36 4.26094
R2450 AVDD_n462 AVDD_t32 4.26094
R2451 AVDD_n469 AVDD_t28 4.26094
R2452 AVDD_n718 AVDD_n506 4.251
R2453 AVDD_n696 AVDD_n600 4.251
R2454 AVDD_n694 AVDD_n600 4.251
R2455 AVDD_n634 AVDD_n600 4.251
R2456 AVDD_n687 AVDD_n682 4.251
R2457 AVDD_n687 AVDD_n683 4.251
R2458 AVDD_n687 AVDD_n684 4.251
R2459 AVDD_n564 AVDD_n498 4.251
R2460 AVDD_n574 AVDD_n498 4.251
R2461 AVDD_n581 AVDD_n498 4.251
R2462 AVDD_n578 AVDD_n498 4.251
R2463 AVDD_n768 AVDD_n527 4.251
R2464 AVDD_n768 AVDD_n524 4.251
R2465 AVDD_n768 AVDD_n523 4.251
R2466 AVDD_n768 AVDD_n522 4.251
R2467 AVDD_n766 AVDD_n765 4.251
R2468 AVDD_n765 AVDD_n763 4.251
R2469 AVDD_n765 AVDD_n760 4.251
R2470 AVDD_n765 AVDD_n530 4.251
R2471 AVDD_n765 AVDD_n529 4.251
R2472 AVDD_n765 AVDD_n753 4.251
R2473 AVDD_n765 AVDD_n750 4.251
R2474 AVDD_n765 AVDD_n749 4.251
R2475 AVDD_n765 AVDD_n550 4.251
R2476 AVDD_n765 AVDD_n549 4.251
R2477 AVDD_n765 AVDD_n548 4.251
R2478 AVDD_n720 AVDD_n588 4.251
R2479 AVDD_n720 AVDD_n589 4.251
R2480 AVDD_n720 AVDD_n590 4.251
R2481 AVDD_n720 AVDD_n592 4.251
R2482 AVDD_n720 AVDD_n593 4.251
R2483 AVDD_n720 AVDD_n594 4.251
R2484 AVDD_n720 AVDD_n595 4.251
R2485 AVDD_n720 AVDD_n596 4.251
R2486 AVDD_n720 AVDD_n597 4.251
R2487 AVDD_n720 AVDD_n598 4.251
R2488 AVDD_n693 AVDD_n692 4.251
R2489 AVDD_n692 AVDD_n671 4.251
R2490 AVDD_n692 AVDD_n669 4.251
R2491 AVDD_n692 AVDD_n660 4.251
R2492 AVDD_n652 AVDD_n601 4.251
R2493 AVDD_n642 AVDD_n601 4.251
R2494 AVDD_n584 AVDD_n569 4.251
R2495 AVDD_n584 AVDD_n576 4.251
R2496 AVDD_n584 AVDD_n583 4.251
R2497 AVDD_n767 AVDD_n535 4.251
R2498 AVDD_n767 AVDD_n536 4.251
R2499 AVDD_n767 AVDD_n538 4.251
R2500 AVDD_n767 AVDD_n541 4.251
R2501 AVDD_n746 AVDD_n736 4.251
R2502 AVDD_n815 AVDD_n814 4.251
R2503 AVDD_n312 AVDD_n310 4.251
R2504 AVDD_n312 AVDD_n309 4.251
R2505 AVDD_n312 AVDD_n306 4.251
R2506 AVDD_n312 AVDD_n305 4.251
R2507 AVDD_n303 AVDD_n92 4.251
R2508 AVDD_n303 AVDD_n93 4.251
R2509 AVDD_n303 AVDD_n94 4.251
R2510 AVDD_n303 AVDD_n95 4.251
R2511 AVDD_n303 AVDD_n96 4.251
R2512 AVDD_n303 AVDD_n98 4.251
R2513 AVDD_n303 AVDD_n99 4.251
R2514 AVDD_n222 AVDD_n203 4.251
R2515 AVDD_n222 AVDD_n208 4.251
R2516 AVDD_n222 AVDD_n211 4.251
R2517 AVDD_n222 AVDD_n216 4.251
R2518 AVDD_n222 AVDD_n218 4.251
R2519 AVDD_n331 AVDD_n37 4.251
R2520 AVDD_n331 AVDD_n36 4.251
R2521 AVDD_n331 AVDD_n35 4.251
R2522 AVDD_n331 AVDD_n33 4.251
R2523 AVDD_n331 AVDD_n27 4.251
R2524 AVDD_n331 AVDD_n26 4.251
R2525 AVDD_n332 AVDD_n331 4.251
R2526 AVDD_n280 AVDD_n176 4.251
R2527 AVDD_n280 AVDD_n177 4.251
R2528 AVDD_n77 AVDD_n42 4.251
R2529 AVDD_n75 AVDD_n42 4.251
R2530 AVDD_n73 AVDD_n42 4.251
R2531 AVDD_n71 AVDD_n42 4.251
R2532 AVDD_n68 AVDD_n42 4.251
R2533 AVDD_n65 AVDD_n42 4.251
R2534 AVDD_n63 AVDD_n42 4.251
R2535 AVDD_n245 AVDD_n240 4.251
R2536 AVDD_n245 AVDD_n241 4.251
R2537 AVDD_n245 AVDD_n243 4.251
R2538 AVDD_n109 AVDD_n100 4.251
R2539 AVDD_n111 AVDD_n100 4.251
R2540 AVDD_n113 AVDD_n100 4.251
R2541 AVDD_n115 AVDD_n100 4.251
R2542 AVDD_n116 AVDD_n100 4.251
R2543 AVDD_n119 AVDD_n100 4.251
R2544 AVDD_n104 AVDD_n100 4.251
R2545 AVDD_n298 AVDD_n100 4.251
R2546 AVDD_n277 AVDD_n230 4.251
R2547 AVDD_n277 AVDD_n179 4.251
R2548 AVDD_n278 AVDD_n277 4.251
R2549 AVDD_n277 AVDD_n226 4.251
R2550 AVDD_n277 AVDD_n192 4.251
R2551 AVDD_n277 AVDD_n191 4.251
R2552 AVDD_n277 AVDD_n189 4.251
R2553 AVDD_n277 AVDD_n188 4.251
R2554 AVDD_n277 AVDD_n187 4.251
R2555 AVDD_n277 AVDD_n186 4.251
R2556 AVDD_n227 AVDD_n180 4.251
R2557 AVDD_n195 AVDD_n180 4.251
R2558 AVDD_n224 AVDD_n180 4.251
R2559 AVDD_n207 AVDD_n180 4.251
R2560 AVDD_n209 AVDD_n180 4.251
R2561 AVDD_n213 AVDD_n180 4.251
R2562 AVDD_n365 AVDD_n364 4.251
R2563 AVDD_n798 AVDD_n502 4.2505
R2564 AVDD_n798 AVDD_n516 4.2505
R2565 AVDD_n798 AVDD_n515 4.2505
R2566 AVDD_n798 AVDD_n513 4.2505
R2567 AVDD_n798 AVDD_t56 4.2505
R2568 AVDD_n798 AVDD_n512 4.2505
R2569 AVDD_n798 AVDD_n511 4.2505
R2570 AVDD_n798 AVDD_n510 4.2505
R2571 AVDD_n798 AVDD_n509 4.2505
R2572 AVDD_n798 AVDD_n508 4.2505
R2573 AVDD_n798 AVDD_n507 4.2505
R2574 AVDD_n768 AVDD_t209 4.2505
R2575 AVDD_n768 AVDD_n525 4.2505
R2576 AVDD_n765 AVDD_n547 4.2505
R2577 AVDD_n692 AVDD_n640 4.2505
R2578 AVDD_n635 AVDD_n601 4.2505
R2579 AVDD_n640 AVDD_n601 4.2505
R2580 AVDD_t41 AVDD_n767 4.2505
R2581 AVDD_n746 AVDD_n547 4.2505
R2582 AVDD_t41 AVDD_n531 4.2505
R2583 AVDD_n331 AVDD_t101 4.2505
R2584 AVDD_n237 AVDD_t97 4.2505
R2585 AVDD_n279 AVDD_n180 4.2505
R2586 AVDD_n220 AVDD_n180 4.2505
R2587 AVDD_n245 AVDD_n238 4.18423
R2588 AVDD_n746 AVDD_n551 4.17416
R2589 AVDD_n166 AVDD_t109 4.13346
R2590 AVDD_n80 AVDD_t94 4.13268
R2591 AVDD_n777 AVDD_t215 4.13257
R2592 AVDD_n644 AVDD_t200 4.13242
R2593 AVDD_n809 AVDD_n808 3.99818
R2594 AVDD_n353 AVDD_n351 3.99818
R2595 AVDD_n533 AVDD_t132 3.99681
R2596 AVDD_n239 AVDD_t227 3.99681
R2597 AVDD_n840 AVDD_n400 3.62053
R2598 AVDD_n844 AVDD_n843 3.5505
R2599 AVDD_n839 AVDD_n451 3.5505
R2600 AVDD_n675 AVDD_t188 3.52652
R2601 AVDD_n675 AVDD_t185 3.52631
R2602 AVDD_n204 AVDD_t65 3.52621
R2603 AVDD_n204 AVDD_t70 3.52561
R2604 AVDD_n366 AVDD_t38 3.4015
R2605 AVDD_t57 AVDD_n813 3.4005
R2606 AVDD_n354 AVDD_n353 3.25209
R2607 AVDD_n811 AVDD_n809 3.25209
R2608 AVDD_t79 AVDD_n390 3.02195
R2609 AVDD_n557 AVDD_n498 2.83444
R2610 AVDD_n561 AVDD_n498 2.83444
R2611 AVDD_n567 AVDD_n498 2.83444
R2612 AVDD_n571 AVDD_n498 2.83444
R2613 AVDD_n765 AVDD_n751 2.83444
R2614 AVDD_n720 AVDD_n591 2.83444
R2615 AVDD_n692 AVDD_n670 2.83444
R2616 AVDD_n584 AVDD_n555 2.83444
R2617 AVDD_n584 AVDD_n559 2.83444
R2618 AVDD_n584 AVDD_n562 2.83444
R2619 AVDD_n584 AVDD_n566 2.83444
R2620 AVDD_n584 AVDD_n572 2.83444
R2621 AVDD_n312 AVDD_n307 2.83444
R2622 AVDD_n303 AVDD_n97 2.83444
R2623 AVDD_n222 AVDD_n221 2.83444
R2624 AVDD_n331 AVDD_n28 2.83444
R2625 AVDD_n69 AVDD_n42 2.83444
R2626 AVDD_n245 AVDD_n242 2.83444
R2627 AVDD_n40 AVDD_n39 2.83444
R2628 AVDD_n150 AVDD_n100 2.83444
R2629 AVDD_n148 AVDD_n100 2.83444
R2630 AVDD_n277 AVDD_n185 2.83444
R2631 AVDD_n768 AVDD_n526 2.83433
R2632 AVDD_n765 AVDD_n544 2.83433
R2633 AVDD_n312 AVDD_n311 2.83433
R2634 AVDD_n280 AVDD_n178 2.83433
R2635 AVDD_n67 AVDD_n42 2.83433
R2636 AVDD_n151 AVDD_n106 2.83428
R2637 AVDD_t205 AVDD_n490 2.83383
R2638 AVDD_n798 AVDD_n514 2.83383
R2639 AVDD_n303 AVDD_t105 2.83383
R2640 AVDD_n245 AVDD_n244 2.83383
R2641 AVDD_n744 AVDD_t121 2.79906
R2642 AVDD_n253 AVDD_t55 2.79883
R2643 AVDD_n321 AVDD_n303 2.72834
R2644 AVDD_n772 AVDD_n498 2.72807
R2645 AVDD_n222 AVDD_n200 2.72406
R2646 AVDD_n431 AVDD_t62 2.68583
R2647 AVDD_n433 AVDD_t61 2.68579
R2648 AVDD_n433 AVDD_t62 2.68579
R2649 AVDD_n847 AVDD_t71 2.68579
R2650 AVDD_n431 AVDD_t61 2.68572
R2651 AVDD_n849 AVDD_t71 2.68552
R2652 AVDD_n398 AVDD_t63 2.61869
R2653 AVDD_n434 AVDD_t75 2.57324
R2654 AVDD_n831 AVDD_n830 2.56394
R2655 AVDD_n374 AVDD_n373 2.56394
R2656 AVDD_n850 AVDD_n434 2.55942
R2657 AVDD_n335 AVDD_n11 2.5527
R2658 AVDD_n313 AVDD_t221 2.53447
R2659 AVDD_n520 AVDD_t130 2.52969
R2660 AVDD AVDD_n852 2.51909
R2661 AVDD_n698 AVDD_t51 2.42907
R2662 AVDD_n675 AVDD_t186 2.31654
R2663 AVDD_n204 AVDD_t67 2.31603
R2664 AVDD_n679 AVDD_n600 2.30049
R2665 AVDD_n252 AVDD_n40 2.29499
R2666 AVDD_n746 AVDD_n745 2.29466
R2667 AVDD_n692 AVDD_n691 2.29256
R2668 AVDD_n256 AVDD_t226 2.28173
R2669 AVDD_n723 AVDD_t131 2.27484
R2670 AVDD_n399 AVDD_n398 2.22852
R2671 AVDD_n166 AVDD_t111 2.1465
R2672 AVDD_n646 AVDD_t195 2.14647
R2673 AVDD_n167 AVDD_t113 2.14647
R2674 AVDD_n650 AVDD_t191 2.14635
R2675 AVDD_n86 AVDD_t108 2.14634
R2676 AVDD_n82 AVDD_t100 2.14634
R2677 AVDD_n171 AVDD_t118 2.14633
R2678 AVDD_n777 AVDD_t213 2.1463
R2679 AVDD_n778 AVDD_t211 2.14618
R2680 AVDD_n84 AVDD_t104 2.14617
R2681 AVDD_n648 AVDD_t193 2.14614
R2682 AVDD_n780 AVDD_t208 2.14585
R2683 AVDD_n81 AVDD_t98 2.14584
R2684 AVDD_n781 AVDD_t206 2.14581
R2685 AVDD_n80 AVDD_t96 2.14573
R2686 AVDD_n647 AVDD_t194 2.14565
R2687 AVDD_n645 AVDD_t197 2.14556
R2688 AVDD_n83 AVDD_t102 2.14554
R2689 AVDD_n169 AVDD_t116 2.14551
R2690 AVDD_n170 AVDD_t117 2.1455
R2691 AVDD_n168 AVDD_t115 2.14547
R2692 AVDD_n782 AVDD_t204 2.14541
R2693 AVDD_n649 AVDD_t192 2.14538
R2694 AVDD_n644 AVDD_t199 2.14537
R2695 AVDD_n85 AVDD_t106 2.14535
R2696 AVDD_n779 AVDD_t210 2.14497
R2697 AVDD_n783 AVDD_t202 2.14492
R2698 AVDD_n172 AVDD_t119 2.14492
R2699 AVDD_n331 AVDD_n25 2.12619
R2700 AVDD_n312 AVDD_n308 2.126
R2701 AVDD_n692 AVDD_t187 2.1255
R2702 AVDD_t187 AVDD_n601 2.1255
R2703 AVDD_t103 AVDD_n330 2.1255
R2704 AVDD_n651 AVDD_n650 2.11548
R2705 AVDD_n650 AVDD_n649 1.98738
R2706 AVDD_n649 AVDD_n648 1.98738
R2707 AVDD_n648 AVDD_n647 1.98738
R2708 AVDD_n647 AVDD_n646 1.98738
R2709 AVDD_n646 AVDD_n645 1.98738
R2710 AVDD_n645 AVDD_n644 1.98738
R2711 AVDD_n783 AVDD_n782 1.98738
R2712 AVDD_n782 AVDD_n781 1.98738
R2713 AVDD_n781 AVDD_n780 1.98738
R2714 AVDD_n780 AVDD_n779 1.98738
R2715 AVDD_n779 AVDD_n778 1.98738
R2716 AVDD_n778 AVDD_n777 1.98738
R2717 AVDD_n167 AVDD_n166 1.98738
R2718 AVDD_n168 AVDD_n167 1.98738
R2719 AVDD_n169 AVDD_n168 1.98738
R2720 AVDD_n170 AVDD_n169 1.98738
R2721 AVDD_n171 AVDD_n170 1.98738
R2722 AVDD_n172 AVDD_n171 1.98738
R2723 AVDD_n81 AVDD_n80 1.98738
R2724 AVDD_n82 AVDD_n81 1.98738
R2725 AVDD_n83 AVDD_n82 1.98738
R2726 AVDD_n84 AVDD_n83 1.98738
R2727 AVDD_n85 AVDD_n84 1.98738
R2728 AVDD_n86 AVDD_n85 1.98738
R2729 AVDD_n277 AVDD_n194 1.97072
R2730 AVDD_n738 AVDD_n531 1.97003
R2731 AVDD_n237 AVDD_n236 1.9699
R2732 AVDD_n319 AVDD_t223 1.96529
R2733 AVDD_n518 AVDD_t127 1.95944
R2734 AVDD_n672 AVDD_t52 1.94112
R2735 AVDD_n664 AVDD_t53 1.94059
R2736 AVDD_n193 AVDD_t47 1.9405
R2737 AVDD_n269 AVDD_t48 1.94032
R2738 AVDD_n690 AVDD_n689 1.93283
R2739 AVDD_n274 AVDD_n273 1.93283
R2740 AVDD_n754 AVDD_t134 1.83605
R2741 AVDD_n30 AVDD_t219 1.83529
R2742 AVDD_n846 AVDD_n845 1.71867
R2743 AVDD_n677 AVDD_n600 1.71723
R2744 AVDD_n222 AVDD_n206 1.71685
R2745 AVDD_n331 AVDD_n34 1.70124
R2746 AVDD_n379 AVDD_n378 1.67394
R2747 AVDD_n700 AVDD_n599 1.62461
R2748 AVDD_n803 AVDD_n802 1.61535
R2749 AVDD_n294 AVDD_n293 1.60845
R2750 AVDD_n543 AVDD_n531 1.54595
R2751 AVDD_n237 AVDD_n59 1.54595
R2752 AVDD_n754 AVDD_n546 1.5386
R2753 AVDD_n285 AVDD_n284 1.53209
R2754 AVDD_n30 AVDD_n24 1.52027
R2755 AVDD_n651 AVDD_n631 1.51973
R2756 AVDD_n205 AVDD_n197 1.51606
R2757 AVDD_n247 AVDD_n246 1.51383
R2758 AVDD_n676 AVDD_n674 1.50721
R2759 AVDD_n837 AVDD_n836 1.5064
R2760 AVDD_n257 AVDD_n233 1.50512
R2761 AVDD_n272 AVDD_n182 1.50486
R2762 AVDD_n725 AVDD_n724 1.50131
R2763 AVDD_n284 AVDD_n283 1.46989
R2764 AVDD_n324 AVDD_n323 1.45558
R2765 AVDD_n662 AVDD_n661 1.45165
R2766 AVDD_n732 AVDD_n731 1.45106
R2767 AVDD_n328 AVDD_n11 1.44368
R2768 AVDD_n138 AVDD_n105 1.43885
R2769 AVDD_n251 AVDD_n235 1.43841
R2770 AVDD_n680 AVDD_n674 1.4383
R2771 AVDD_n743 AVDD_n732 1.43138
R2772 AVDD_n249 AVDD_n248 1.42888
R2773 AVDD_n741 AVDD_n740 1.42594
R2774 AVDD_n533 AVDD_n532 1.42549
R2775 AVDD_n246 AVDD_n239 1.42233
R2776 AVDD_n315 AVDD_n24 1.41878
R2777 AVDD_n489 AVDD_n452 1.41793
R2778 AVDD_n692 AVDD_t51 1.41717
R2779 AVDD_n271 AVDD_n231 1.41345
R2780 AVDD_n193 AVDD_n182 1.40923
R2781 AVDD_n700 AVDD_n699 1.40727
R2782 AVDD_n672 AVDD_n658 1.4022
R2783 AVDD_n756 AVDD_n546 1.3996
R2784 AVDD_n667 AVDD_n658 1.397
R2785 AVDD_n842 AVDD_n837 1.3934
R2786 AVDD_n775 AVDD_n774 1.39132
R2787 AVDD_n323 AVDD_n322 1.38007
R2788 AVDD_n292 AVDD_n105 1.37996
R2789 AVDD_n771 AVDD_n517 1.3755
R2790 AVDD_n428 AVDD_n420 1.37246
R2791 AVDD_n413 AVDD_n405 1.37246
R2792 AVDD_n447 AVDD_n439 1.37246
R2793 AVDD_n396 AVDD_n395 1.37246
R2794 AVDD_n414 AVDD_n413 1.3724
R2795 AVDD_n448 AVDD_n447 1.3724
R2796 AVDD_n395 AVDD_n394 1.3724
R2797 AVDD_n429 AVDD_n428 1.37235
R2798 AVDD_n689 AVDD_n688 1.37134
R2799 AVDD_n770 AVDD_n519 1.36952
R2800 AVDD_n587 AVDD_n586 1.36728
R2801 AVDD_n264 AVDD_n232 1.36727
R2802 AVDD_n784 AVDD_n783 1.36552
R2803 AVDD_n726 AVDD_n725 1.36471
R2804 AVDD_n273 AVDD_n174 1.36249
R2805 AVDD_n266 AVDD_n232 1.35935
R2806 AVDD_n722 AVDD_n586 1.35935
R2807 AVDD_n198 AVDD_n174 1.35905
R2808 AVDD_n263 AVDD_n233 1.35367
R2809 AVDD_n739 AVDD_n532 1.34499
R2810 AVDD_n729 AVDD_n584 1.34122
R2811 AVDD_n262 AVDD_n42 1.34122
R2812 AVDD_n727 AVDD_n584 1.34098
R2813 AVDD_n330 AVDD_n329 1.34081
R2814 AVDD_n267 AVDD_n231 1.33979
R2815 AVDD_n809 AVDD_t141 1.33349
R2816 AVDD_n353 AVDD_t77 1.33349
R2817 AVDD_n617 AVDD_n505 1.33336
R2818 AVDD_n255 AVDD_n235 1.3318
R2819 AVDD_n775 AVDD_n517 1.32245
R2820 AVDD_n199 AVDD_n197 1.31346
R2821 AVDD_n320 AVDD_n91 1.31055
R2822 AVDD_n542 AVDD_n531 1.30819
R2823 AVDD_n666 AVDD_n661 1.30552
R2824 AVDD_n324 AVDD_n91 1.30149
R2825 AVDD_n317 AVDD_n316 1.29653
R2826 AVDD_n774 AVDD_n773 1.29437
R2827 AVDD_n326 AVDD_n325 1.28613
R2828 AVDD_n107 AVDD_n88 1.27756
R2829 AVDD_n755 AVDD_n519 1.27205
R2830 AVDD_n742 AVDD_n741 1.26328
R2831 AVDD_n797 AVDD_n776 1.26123
R2832 AVDD_n250 AVDD_n249 1.25683
R2833 AVDD_n268 AVDD_n267 1.25679
R2834 AVDD_n688 AVDD_n681 1.24908
R2835 AVDD_n318 AVDD_n317 1.24686
R2836 AVDD_n796 AVDD_n503 1.2461
R2837 AVDD_n699 AVDD_n631 1.23626
R2838 AVDD_n721 AVDD_n587 1.23328
R2839 AVDD_n265 AVDD_n264 1.23239
R2840 AVDD_n776 AVDD_n775 1.23113
R2841 AVDD_n266 AVDD_n265 1.22679
R2842 AVDD_n722 AVDD_n721 1.2259
R2843 AVDD_n327 AVDD_n326 1.22253
R2844 AVDD_n797 AVDD_n796 1.22125
R2845 AVDD_n656 AVDD_n601 1.21522
R2846 AVDD_n776 AVDD_n505 1.2149
R2847 AVDD_n767 AVDD_t212 1.21479
R2848 AVDD_n245 AVDD_n59 1.21479
R2849 AVDD_n245 AVDD_t95 1.21479
R2850 AVDD_n728 AVDD_n585 1.20491
R2851 AVDD_n261 AVDD_n234 1.20311
R2852 AVDD_n664 AVDD_n663 1.20071
R2853 AVDD_n260 AVDD_n42 1.19727
R2854 AVDD_n432 AVDD_n430 1.1926
R2855 AVDD_n432 AVDD_n415 1.1926
R2856 AVDD_n848 AVDD_n449 1.1926
R2857 AVDD_n269 AVDD_n268 1.18054
R2858 AVDD_n287 AVDD_n286 1.16481
R2859 AVDD_n663 AVDD_n662 1.15451
R2860 AVDD_n295 AVDD_n294 1.13751
R2861 AVDD_n701 AVDD_n503 1.13665
R2862 AVDD_n336 AVDD_n335 1.13494
R2863 AVDD_n768 AVDD_t41 1.13383
R2864 AVDD_n765 AVDD_t205 1.13383
R2865 AVDD_n718 AVDD_n601 1.13383
R2866 AVDD_n638 AVDD_n601 1.13383
R2867 AVDD_n312 AVDD_n55 1.13383
R2868 AVDD_n331 AVDD_t103 1.13383
R2869 AVDD_n244 AVDD_n237 1.13383
R2870 AVDD_n277 AVDD_n276 1.13383
R2871 AVDD_n276 AVDD_n180 1.13383
R2872 AVDD_n183 AVDD_n180 1.13383
R2873 AVDD_n388 AVDD_n380 1.1255
R2874 AVDD_n832 AVDD_n831 1.0873
R2875 AVDD_n375 AVDD_n374 1.0873
R2876 AVDD_n292 AVDD_n107 1.07475
R2877 AVDD_n665 AVDD_n601 1.07451
R2878 AVDD_n687 AVDD_n673 1.07087
R2879 AVDD_n275 AVDD_n274 1.07012
R2880 AVDD_n528 AVDD_n520 1.06688
R2881 AVDD_n314 AVDD_n313 1.06684
R2882 AVDD_n687 AVDD_n686 1.0635
R2883 AVDD_n281 AVDD_n280 1.0635
R2884 AVDD_n799 AVDD_n500 1.06345
R2885 AVDD_t93 AVDD_n12 1.06345
R2886 AVDD_n767 AVDD_n542 1.063
R2887 AVDD_n280 AVDD_n279 1.063
R2888 AVDD_n668 AVDD_n667 1.05475
R2889 AVDD_n325 AVDD_n324 1.02487
R2890 AVDD_n768 AVDD_n521 1.001
R2891 AVDD_n765 AVDD_n764 1.001
R2892 AVDD_n692 AVDD_n602 1.001
R2893 AVDD_n692 AVDD_n659 1.001
R2894 AVDD_n312 AVDD_n41 1.001
R2895 AVDD_n331 AVDD_n23 1.001
R2896 AVDD_n277 AVDD_n184 1.001
R2897 AVDD_n724 AVDD_n552 0.990316
R2898 AVDD_n793 AVDD_n784 0.988758
R2899 AVDD_n755 AVDD_n528 0.986059
R2900 AVDD_n316 AVDD_n314 0.985829
R2901 AVDD_n270 AVDD_n180 0.967806
R2902 AVDD_n280 AVDD_n175 0.966768
R2903 AVDD_n286 AVDD_n285 0.958261
R2904 AVDD_n258 AVDD_n257 0.954733
R2905 AVDD_n690 AVDD_n668 0.948168
R2906 AVDD_n657 AVDD_n600 0.945654
R2907 AVDD_n687 AVDD_n685 0.945383
R2908 AVDD_n484 AVDD_n483 0.943357
R2909 AVDD_n485 AVDD_n484 0.943357
R2910 AVDD_n479 AVDD_n478 0.943357
R2911 AVDD_n480 AVDD_n479 0.943357
R2912 AVDD_n474 AVDD_n473 0.943357
R2913 AVDD_n475 AVDD_n474 0.943357
R2914 AVDD_n459 AVDD_n458 0.943357
R2915 AVDD_n458 AVDD_n457 0.943357
R2916 AVDD_n465 AVDD_n464 0.943357
R2917 AVDD_n464 AVDD_n463 0.943357
R2918 AVDD_n467 AVDD_n466 0.943357
R2919 AVDD_n468 AVDD_n467 0.943357
R2920 AVDD_n771 AVDD_n770 0.942375
R2921 AVDD_n322 AVDD_n318 0.942375
R2922 AVDD_n318 AVDD_n304 0.938447
R2923 AVDD_n486 AVDD_n485 0.936741
R2924 AVDD_n481 AVDD_n480 0.936741
R2925 AVDD_n476 AVDD_n475 0.936741
R2926 AVDD_n457 AVDD_n456 0.936741
R2927 AVDD_n463 AVDD_n462 0.936741
R2928 AVDD_n469 AVDD_n468 0.936741
R2929 AVDD_n275 AVDD_n272 0.934976
R2930 AVDD_n259 AVDD_n258 0.922086
R2931 AVDD_n769 AVDD_n520 0.911198
R2932 AVDD_n434 AVDD_n433 0.910917
R2933 AVDD_n846 AVDD_n450 0.88534
R2934 AVDD_n851 AVDD_n850 0.88534
R2935 AVDD_n313 AVDD_n304 0.877989
R2936 AVDD_n270 AVDD_n269 0.875268
R2937 AVDD_n770 AVDD_n769 0.858536
R2938 AVDD_n585 AVDD_t136 0.853627
R2939 AVDD_n234 AVDD_t229 0.853449
R2940 AVDD_n730 AVDD_n552 0.842287
R2941 AVDD_n665 AVDD_n664 0.826889
R2942 AVDD_n455 AVDD_n452 0.826195
R2943 AVDD_n488 AVDD_n487 0.825943
R2944 AVDD_n483 AVDD_n482 0.825943
R2945 AVDD_n478 AVDD_n477 0.825943
R2946 AVDD_n473 AVDD_n472 0.825943
R2947 AVDD_n461 AVDD_n459 0.825943
R2948 AVDD_n470 AVDD_n465 0.825943
R2949 AVDD_n466 AVDD_n453 0.825943
R2950 AVDD_n666 AVDD_n665 0.805771
R2951 AVDD_n743 AVDD_n742 0.804875
R2952 AVDD_n251 AVDD_n250 0.804875
R2953 AVDD_n283 AVDD_n172 0.798
R2954 AVDD_n87 AVDD_n86 0.798
R2955 AVDD_n756 AVDD_n755 0.791125
R2956 AVDD_n316 AVDD_n315 0.791125
R2957 AVDD_n799 AVDD_n498 0.773227
R2958 AVDD_n303 AVDD_n302 0.773227
R2959 AVDD_n681 AVDD_n673 0.759454
R2960 AVDD_n662 AVDD_n587 0.752167
R2961 AVDD_n267 AVDD_n266 0.752167
R2962 AVDD_n701 AVDD_n700 0.744833
R2963 AVDD_n293 AVDD_n292 0.744833
R2964 AVDD_n678 AVDD_n631 0.743
R2965 AVDD_n773 AVDD_n518 0.743
R2966 AVDD_n285 AVDD_n165 0.743
R2967 AVDD_n320 AVDD_n319 0.743
R2968 AVDD_n261 AVDD_n260 0.739166
R2969 AVDD_n271 AVDD_n270 0.724239
R2970 AVDD_n258 AVDD_n42 0.720216
R2971 AVDD_n830 AVDD_n829 0.71902
R2972 AVDD_n373 AVDD_n372 0.71902
R2973 AVDD_n312 AVDD_n304 0.718841
R2974 AVDD_n834 AVDD_n833 0.71022
R2975 AVDD_n377 AVDD_n376 0.71022
R2976 AVDD_n395 AVDD_n381 0.709333
R2977 AVDD_n428 AVDD_t61 0.708833
R2978 AVDD_n413 AVDD_t62 0.708833
R2979 AVDD_n447 AVDD_t71 0.708833
R2980 AVDD_n718 AVDD_n600 0.708833
R2981 AVDD_n746 AVDD_t205 0.708833
R2982 AVDD_n223 AVDD_n222 0.708833
R2983 AVDD_t103 AVDD_n40 0.708833
R2984 AVDD_t220 AVDD_n40 0.708833
R2985 AVDD_n727 AVDD_n726 0.707629
R2986 AVDD_n730 AVDD_n729 0.705804
R2987 AVDD_n263 AVDD_n262 0.705804
R2988 AVDD_n729 AVDD_n728 0.691425
R2989 AVDD_n262 AVDD_n261 0.691425
R2990 AVDD_n728 AVDD_n727 0.689575
R2991 AVDD_n273 AVDD_n175 0.688891
R2992 AVDD_n198 AVDD_n175 0.687
R2993 AVDD_n852 AVDD_n399 0.682169
R2994 AVDD_n584 AVDD_n552 0.657038
R2995 AVDD_n796 AVDD_n795 0.656833
R2996 AVDD_n726 AVDD_n722 0.656833
R2997 AVDD_n264 AVDD_n263 0.656833
R2998 AVDD_n328 AVDD_n327 0.656833
R2999 AVDD_n553 AVDD_n498 0.655237
R3000 AVDD_n769 AVDD_n768 0.655074
R3001 AVDD_n747 AVDD_n746 0.654846
R3002 AVDD_n222 AVDD_n153 0.654846
R3003 AVDD_n303 AVDD_n38 0.654793
R3004 AVDD_n689 AVDD_n673 0.646068
R3005 AVDD_n329 AVDD_n87 0.643883
R3006 AVDD_n260 AVDD_n259 0.632917
R3007 AVDD_n795 AVDD_n784 0.620937
R3008 AVDD_n731 AVDD_n730 0.6165
R3009 AVDD_n259 AVDD_n255 0.6165
R3010 AVDD_n302 AVDD_n79 0.61023
R3011 AVDD_n817 AVDD_n816 0.608548
R3012 AVDD_n361 AVDD_n360 0.608548
R3013 AVDD_n654 AVDD_n600 0.608143
R3014 AVDD_n718 AVDD_n599 0.607584
R3015 AVDD_n329 AVDD_n328 0.606638
R3016 AVDD_n678 AVDD_n677 0.602483
R3017 AVDD_n206 AVDD_n165 0.601312
R3018 AVDD_n820 AVDD_n819 0.598325
R3019 AVDD_n363 AVDD_n357 0.597986
R3020 AVDD_n390 AVDD_n379 0.5889
R3021 AVDD_n740 AVDD_n739 0.584875
R3022 AVDD_n194 AVDD_n193 0.570737
R3023 AVDD_n742 AVDD_n738 0.566085
R3024 AVDD_n250 AVDD_n236 0.56562
R3025 AVDD_n681 AVDD_n680 0.554167
R3026 AVDD_n199 AVDD_n198 0.554167
R3027 AVDD_n286 AVDD_n164 0.548275
R3028 AVDD_n277 AVDD_n275 0.541445
R3029 AVDD_n768 AVDD_n528 0.540998
R3030 AVDD_n314 AVDD_n312 0.540795
R3031 AVDD_n692 AVDD_n668 0.540644
R3032 AVDD_n248 AVDD_n247 0.529875
R3033 AVDD_n691 AVDD_n672 0.513374
R3034 AVDD_n335 AVDD_n334 0.500491
R3035 AVDD_n691 AVDD_n690 0.489845
R3036 AVDD_n724 AVDD_n723 0.48175
R3037 AVDD_n257 AVDD_n256 0.48175
R3038 AVDD_n206 AVDD_n205 0.481055
R3039 AVDD_n677 AVDD_n676 0.479916
R3040 AVDD_n799 AVDD_n798 0.472722
R3041 AVDD_n584 AVDD_t205 0.472722
R3042 AVDD_n296 AVDD_n295 0.472722
R3043 AVDD_n302 AVDD_n89 0.472722
R3044 AVDD_n720 AVDD_n719 0.448368
R3045 AVDD_n720 AVDD_n501 0.448368
R3046 AVDD_n584 AVDD_n497 0.448368
R3047 AVDD_n301 AVDD_n42 0.448368
R3048 AVDD_n152 AVDD_n100 0.448368
R3049 AVDD_t103 AVDD_n42 0.447868
R3050 AVDD_t214 AVDD_n490 0.436397
R3051 AVDD_n300 AVDD_n100 0.426427
R3052 AVDD_n274 AVDD_n194 0.421413
R3053 AVDD_n398 AVDD_n380 0.414782
R3054 AVDD_n200 AVDD_n199 0.409568
R3055 AVDD_n745 AVDD_n744 0.406478
R3056 AVDD_n253 AVDD_n252 0.405803
R3057 AVDD_n667 AVDD_n666 0.403833
R3058 AVDD_n272 AVDD_n271 0.403833
R3059 AVDD_n322 AVDD_n321 0.396912
R3060 AVDD_n772 AVDD_n771 0.396555
R3061 AVDD_n773 AVDD_n772 0.395931
R3062 AVDD_n321 AVDD_n320 0.395585
R3063 AVDD_n252 AVDD_n251 0.394531
R3064 AVDD_n745 AVDD_n743 0.39384
R3065 AVDD_n340 AVDD_n339 0.389698
R3066 AVDD_n248 AVDD_n236 0.383806
R3067 AVDD_n740 AVDD_n738 0.383351
R3068 AVDD_n296 AVDD_n107 0.378894
R3069 AVDD_n676 AVDD_n675 0.378625
R3070 AVDD_n205 AVDD_n204 0.378625
R3071 AVDD_n338 AVDD_n337 0.374678
R3072 AVDD_n339 AVDD_n338 0.374678
R3073 AVDD_n288 AVDD_n287 0.374678
R3074 AVDD_n143 AVDD_n142 0.356358
R3075 AVDD_n847 AVDD_n846 0.3495
R3076 AVDD_n680 AVDD_n679 0.346776
R3077 AVDD_n721 AVDD_n720 0.344982
R3078 AVDD_n265 AVDD_n100 0.344981
R3079 AVDD_n710 AVDD_n709 0.338378
R3080 AVDD_n798 AVDD_n503 0.318401
R3081 AVDD_n679 AVDD_n678 0.318181
R3082 AVDD_n712 AVDD_n711 0.312698
R3083 AVDD_n703 AVDD_n702 0.312698
R3084 AVDD_n343 AVDD_n342 0.312698
R3085 AVDD_n122 AVDD_n90 0.312698
R3086 AVDD_n143 AVDD_n127 0.312698
R3087 AVDD_n289 AVDD_n288 0.312698
R3088 AVDD_n711 AVDD_n710 0.312358
R3089 AVDD_n337 AVDD_n336 0.312358
R3090 AVDD_n342 AVDD_n341 0.312358
R3091 AVDD_n125 AVDD_n122 0.312358
R3092 AVDD_n744 AVDD_n551 0.293062
R3093 AVDD_n239 AVDD_n238 0.279676
R3094 AVDD_n268 AVDD_n180 0.267068
R3095 AVDD_n394 AVDD_n393 0.266246
R3096 AVDD_n420 AVDD_n419 0.263661
R3097 AVDD_n405 AVDD_n404 0.263661
R3098 AVDD_n439 AVDD_n438 0.263661
R3099 AVDD_n200 AVDD_n165 0.262721
R3100 AVDD_n293 AVDD_n291 0.255606
R3101 AVDD_n802 AVDD_n491 0.250378
R3102 AVDD_n789 AVDD_n491 0.250378
R3103 AVDD_n790 AVDD_n789 0.250378
R3104 AVDD_n791 AVDD_n790 0.250378
R3105 AVDD_n792 AVDD_n791 0.250378
R3106 AVDD_n715 AVDD_n617 0.250378
R3107 AVDD_n715 AVDD_n714 0.250378
R3108 AVDD_n714 AVDD_n713 0.250378
R3109 AVDD_n713 AVDD_n712 0.250378
R3110 AVDD_n709 AVDD_n708 0.250378
R3111 AVDD_n708 AVDD_n707 0.250378
R3112 AVDD_n707 AVDD_n706 0.250378
R3113 AVDD_n706 AVDD_n705 0.250378
R3114 AVDD_n705 AVDD_n704 0.250378
R3115 AVDD_n704 AVDD_n703 0.250378
R3116 AVDD_n341 AVDD_n340 0.250378
R3117 AVDD_n344 AVDD_n343 0.250378
R3118 AVDD_n126 AVDD_n125 0.250378
R3119 AVDD_n127 AVDD_n126 0.250378
R3120 AVDD_n142 AVDD_n141 0.250378
R3121 AVDD_n141 AVDD_n140 0.250378
R3122 AVDD_n140 AVDD_n139 0.250378
R3123 AVDD_n139 AVDD_n138 0.250378
R3124 AVDD_n290 AVDD_n289 0.250378
R3125 AVDD_n291 AVDD_n290 0.250378
R3126 AVDD_n739 AVDD_n534 0.250092
R3127 AVDD_n255 AVDD_n254 0.250092
R3128 AVDD_n282 AVDD_t114 0.249701
R3129 AVDD_n414 AVDD_n412 0.246353
R3130 AVDD_n448 AVDD_n446 0.246353
R3131 AVDD_n429 AVDD_n427 0.246262
R3132 AVDD_n798 AVDD_n505 0.245376
R3133 AVDD_n663 AVDD_n601 0.245118
R3134 AVDD_n397 AVDD_n396 0.243768
R3135 AVDD_n698 AVDD_t190 0.243357
R3136 AVDD_n534 AVDD_n533 0.231419
R3137 AVDD_n254 AVDD_n253 0.231419
R3138 AVDD_n840 AVDD_n839 0.226119
R3139 AVDD_n768 AVDD_n519 0.224647
R3140 AVDD_n843 AVDD_n838 0.222818
R3141 AVDD_n345 AVDD_n344 0.222252
R3142 AVDD_n399 AVDD_n379 0.206515
R3143 AVDD_n317 AVDD_n312 0.205691
R3144 AVDD_n849 AVDD_n848 0.197667
R3145 AVDD_n433 AVDD_n432 0.197667
R3146 AVDD_n702 AVDD_n701 0.194752
R3147 AVDD_n848 AVDD_n847 0.194
R3148 AVDD_n432 AVDD_n431 0.194
R3149 AVDD_n699 AVDD_n698 0.193947
R3150 AVDD_n795 AVDD_n794 0.193
R3151 AVDD_n280 AVDD_n174 0.191084
R3152 AVDD_n794 AVDD_n792 0.187772
R3153 AVDD_n757 AVDD_n756 0.187772
R3154 AVDD_n315 AVDD_n31 0.187772
R3155 AVDD_n327 AVDD_n88 0.187772
R3156 AVDD_n731 AVDD_n551 0.186728
R3157 AVDD_n757 AVDD_n754 0.182272
R3158 AVDD_n31 AVDD_n30 0.182272
R3159 AVDD_n688 AVDD_n687 0.175952
R3160 AVDD_n844 AVDD_n837 0.1715
R3161 AVDD_n363 AVDD_n362 0.168325
R3162 AVDD_n819 AVDD_n818 0.167986
R3163 AVDD_n774 AVDD_n498 0.15651
R3164 AVDD_n835 AVDD_n834 0.15626
R3165 AVDD_n378 AVDD_n377 0.15626
R3166 AVDD_n805 AVDD_n804 0.148386
R3167 AVDD_n348 AVDD_n347 0.148386
R3168 AVDD_n833 AVDD_n832 0.14834
R3169 AVDD_n376 AVDD_n375 0.14834
R3170 AVDD_n822 AVDD_n821 0.147039
R3171 AVDD_n359 AVDD_n358 0.147039
R3172 AVDD_n247 AVDD_n238 0.146176
R3173 AVDD_n396 AVDD_n388 0.146019
R3174 AVDD_n798 AVDD_n797 0.145216
R3175 AVDD_n430 AVDD_n420 0.144849
R3176 AVDD_n415 AVDD_n405 0.144849
R3177 AVDD_n449 AVDD_n439 0.144849
R3178 AVDD_n430 AVDD_n429 0.144496
R3179 AVDD_n415 AVDD_n414 0.144416
R3180 AVDD_n449 AVDD_n448 0.144416
R3181 AVDD_n326 AVDD_n89 0.144223
R3182 AVDD_n303 AVDD_n91 0.143444
R3183 AVDD_n394 AVDD_n388 0.143246
R3184 AVDD_n845 AVDD_n844 0.1355
R3185 AVDD_n451 AVDD_n450 0.1355
R3186 AVDD_n851 AVDD_n400 0.1355
R3187 AVDD_n824 AVDD_n823 0.132039
R3188 AVDD_n367 AVDD_n356 0.132039
R3189 AVDD_n325 AVDD_n90 0.125439
R3190 AVDD_n296 AVDD_n105 0.125147
R3191 AVDD_n812 AVDD_n808 0.1205
R3192 AVDD_n355 AVDD_n351 0.1205
R3193 AVDD_n249 AVDD_n237 0.115622
R3194 AVDD_n741 AVDD_n531 0.11484
R3195 AVDD_n843 AVDD_n842 0.110882
R3196 AVDD_n823 AVDD_n822 0.109539
R3197 AVDD_n359 AVDD_n356 0.109539
R3198 AVDD_n852 AVDD_n851 0.107375
R3199 AVDD_n839 AVDD_n838 0.104104
R3200 AVDD_n850 AVDD_n849 0.0941667
R3201 AVDD_n845 AVDD_n451 0.0905
R3202 AVDD_n450 AVDD_n400 0.0905
R3203 AVDD_n661 AVDD_n601 0.08135
R3204 AVDD_n231 AVDD_n180 0.0810905
R3205 AVDD_n487 AVDD_n486 0.073233
R3206 AVDD_n482 AVDD_n481 0.073233
R3207 AVDD_n477 AVDD_n476 0.073233
R3208 AVDD_n470 AVDD_n469 0.073233
R3209 AVDD_n462 AVDD_n461 0.073233
R3210 AVDD_n818 AVDD_n817 0.073
R3211 AVDD_n362 AVDD_n361 0.073
R3212 AVDD_n456 AVDD_n455 0.0729806
R3213 AVDD_n346 AVDD_n345 0.069551
R3214 AVDD_n810 AVDD_n808 0.0655
R3215 AVDD_n352 AVDD_n351 0.0655
R3216 AVDD_n422 AVDD_n421 0.0601808
R3217 AVDD_n423 AVDD_n422 0.0601808
R3218 AVDD_n424 AVDD_n423 0.0601808
R3219 AVDD_n425 AVDD_n424 0.0601808
R3220 AVDD_n426 AVDD_n425 0.0601808
R3221 AVDD_n427 AVDD_n426 0.0601808
R3222 AVDD_n419 AVDD_n418 0.0601808
R3223 AVDD_n418 AVDD_n417 0.0601808
R3224 AVDD_n417 AVDD_n416 0.0601808
R3225 AVDD_n407 AVDD_n406 0.0601808
R3226 AVDD_n408 AVDD_n407 0.0601808
R3227 AVDD_n409 AVDD_n408 0.0601808
R3228 AVDD_n410 AVDD_n409 0.0601808
R3229 AVDD_n411 AVDD_n410 0.0601808
R3230 AVDD_n412 AVDD_n411 0.0601808
R3231 AVDD_n404 AVDD_n403 0.0601808
R3232 AVDD_n403 AVDD_n402 0.0601808
R3233 AVDD_n402 AVDD_n401 0.0601808
R3234 AVDD_n441 AVDD_n440 0.0601808
R3235 AVDD_n442 AVDD_n441 0.0601808
R3236 AVDD_n443 AVDD_n442 0.0601808
R3237 AVDD_n444 AVDD_n443 0.0601808
R3238 AVDD_n445 AVDD_n444 0.0601808
R3239 AVDD_n446 AVDD_n445 0.0601808
R3240 AVDD_n438 AVDD_n437 0.0601808
R3241 AVDD_n437 AVDD_n436 0.0601808
R3242 AVDD_n436 AVDD_n435 0.0601808
R3243 AVDD_n392 AVDD_n391 0.0601808
R3244 AVDD_n391 AVDD_n389 0.0601808
R3245 AVDD_n393 AVDD_n389 0.0601808
R3246 AVDD_n397 AVDD_n387 0.0601808
R3247 AVDD_n387 AVDD_n386 0.0601808
R3248 AVDD_n386 AVDD_n385 0.0601808
R3249 AVDD_n385 AVDD_n384 0.0601808
R3250 AVDD_n384 AVDD_n383 0.0601808
R3251 AVDD_n383 AVDD_n382 0.0601808
R3252 AVDD_n323 AVDD_n303 0.0534423
R3253 AVDD_n517 AVDD_n498 0.0479278
R3254 AVDD_n246 AVDD_n245 0.0416869
R3255 AVDD_n767 AVDD_n532 0.0373055
R3256 AVDD_n821 AVDD_n820 0.03425
R3257 AVDD_n358 AVDD_n357 0.03425
R3258 AVDD_n746 AVDD_n732 0.0281409
R3259 AVDD_n277 AVDD_n182 0.0270412
R3260 AVDD_n235 AVDD_n40 0.0260595
R3261 AVDD_n692 AVDD_n658 0.0234919
R3262 AVDD_n390 AVDD_n380 0.0212511
R3263 AVDD_n674 AVDD_n600 0.01277
R3264 AVDD_n222 AVDD_n197 0.0111532
R3265 AVDD_n330 AVDD_n11 0.0106049
R3266 AVDD_n698 AVDD_n651 0.00890027
R3267 AVDD_n330 AVDD_n79 0.00772326
R3268 AVDD_n803 AVDD_n490 0.00705521
R3269 AVDD_n841 AVDD_n838 0.00681125
R3270 AVDD_n233 AVDD_n42 0.00674758
R3271 AVDD_n294 AVDD_n159 0.00632401
R3272 AVDD_n725 AVDD_n584 0.00552064
R3273 AVDD_n807 AVDD_n804 0.0055
R3274 AVDD_n350 AVDD_n347 0.0055
R3275 AVDD_n841 AVDD_n840 0.00527201
R3276 AVDD_n284 AVDD_n164 0.00402211
R3277 AVDD_n282 AVDD_n164 0.00394628
R3278 AVDD_n698 AVDD_n599 0.00313584
R3279 AVDD_n765 AVDD_n546 0.00286821
R3280 AVDD_n331 AVDD_n24 0.0027407
R3281 AVDD_n657 AVDD_t187 0.00222197
R3282 AVDD_n232 AVDD_n100 0.00205444
R3283 AVDD_n720 AVDD_n586 0.00205439
R3284 AVDD_n785 AVDD_n500 0.00193748
R3285 AVDD_n12 AVDD_n10 0.00193748
R3286 AVDD_n50 AVDD_n38 0.00192304
R3287 AVDD_n685 AVDD_n639 0.00188886
R3288 AVDD_n656 AVDD_t198 0.00185712
R3289 AVDD_n137 AVDD_n106 0.00183333
R3290 AVDD_n842 AVDD_n841 0.00179569
R3291 AVDD_t51 AVDD_n657 0.00177779
R3292 AVDD_n616 AVDD_n506 0.00175
R3293 AVDD_n568 AVDD_n567 0.00166667
R3294 AVDD_n751 AVDD_t209 0.00166667
R3295 AVDD_n670 AVDD_n653 0.00166667
R3296 AVDD_n591 AVDD_n513 0.00166667
R3297 AVDD_n573 AVDD_n572 0.00166667
R3298 AVDD_n571 AVDD_n570 0.00166667
R3299 AVDD_n566 AVDD_n565 0.00166667
R3300 AVDD_n563 AVDD_n562 0.00166667
R3301 AVDD_n561 AVDD_n560 0.00166667
R3302 AVDD_n560 AVDD_n559 0.00166667
R3303 AVDD_n557 AVDD_n556 0.00166667
R3304 AVDD_n556 AVDD_n555 0.00166667
R3305 AVDD_n307 AVDD_n59 0.00166667
R3306 AVDD_n97 AVDD_n47 0.00166667
R3307 AVDD_n242 AVDD_n56 0.00166667
R3308 AVDD_n55 AVDD_n28 0.00166667
R3309 AVDD_n39 AVDD_t54 0.00166667
R3310 AVDD_n70 AVDD_n69 0.00166667
R3311 AVDD_n149 AVDD_n148 0.00166667
R3312 AVDD_n150 AVDD_n108 0.00166667
R3313 AVDD_n221 AVDD_n219 0.00166667
R3314 AVDD_n217 AVDD_n185 0.00166667
R3315 AVDD_n620 AVDD_n612 0.00166667
R3316 AVDD_n629 AVDD_n603 0.00166667
R3317 AVDD_n21 AVDD_n8 0.00166667
R3318 AVDD_n20 AVDD_n7 0.00166667
R3319 AVDD_n19 AVDD_n6 0.00166667
R3320 AVDD_n16 AVDD_n3 0.00166667
R3321 AVDD_n101 AVDD_n89 0.00166667
R3322 AVDD_n146 AVDD_n145 0.00166667
R3323 AVDD_n163 AVDD_n157 0.00166667
R3324 AVDD_n162 AVDD_n156 0.00166667
R3325 AVDD_n161 AVDD_n155 0.00166667
R3326 AVDD_n25 AVDD_t95 0.00162501
R3327 AVDD_t220 AVDD_n34 0.00160001
R3328 AVDD_n553 AVDD_t205 0.00153848
R3329 AVDD_n302 AVDD_n300 0.00152503
R3330 AVDD_n300 AVDD_n299 0.00147495
R3331 AVDD_n554 AVDD_n553 0.00146149
R3332 AVDD_t99 AVDD_n34 0.00139996
R3333 AVDD_n244 AVDD_n25 0.00137497
R3334 AVDD_n630 AVDD_n603 0.00133332
R3335 AVDD_n621 AVDD_n612 0.00133332
R3336 AVDD_n21 AVDD_n9 0.00133332
R3337 AVDD_n20 AVDD_n8 0.00133332
R3338 AVDD_n19 AVDD_n7 0.00133332
R3339 AVDD_n16 AVDD_n4 0.00133332
R3340 AVDD_n164 AVDD_n157 0.00133332
R3341 AVDD_n163 AVDD_n156 0.00133332
R3342 AVDD_n162 AVDD_n155 0.00133332
R3343 AVDD_n145 AVDD_n144 0.00133332
R3344 AVDD_n121 AVDD_n101 0.00133332
R3345 AVDD_n558 AVDD_n557 0.00133331
R3346 AVDD_t203 AVDD_n561 0.00133331
R3347 AVDD_t201 AVDD_n571 0.00133331
R3348 AVDD_n591 AVDD_n514 0.00133331
R3349 AVDD_n555 AVDD_n554 0.00133331
R3350 AVDD_n559 AVDD_n558 0.00133331
R3351 AVDD_n562 AVDD_t203 0.00133331
R3352 AVDD_t125 AVDD_n566 0.00133331
R3353 AVDD_n572 AVDD_t201 0.00133331
R3354 AVDD_n670 AVDD_n635 0.00133331
R3355 AVDD_n567 AVDD_t125 0.00133331
R3356 AVDD_n751 AVDD_n542 0.00133331
R3357 AVDD_n221 AVDD_n220 0.00133331
R3358 AVDD_t97 AVDD_n28 0.00133331
R3359 AVDD_n69 AVDD_t222 0.00133331
R3360 AVDD_n242 AVDD_t97 0.00133331
R3361 AVDD_n39 AVDD_t101 0.00133331
R3362 AVDD_n151 AVDD_n150 0.00133331
R3363 AVDD_n148 AVDD_n117 0.00133331
R3364 AVDD_n220 AVDD_n185 0.00133331
R3365 AVDD_n307 AVDD_t99 0.00133331
R3366 AVDD_n97 AVDD_t222 0.00133331
R3367 AVDD_n798 AVDD_n506 0.00124998
R3368 AVDD_n296 AVDD_n106 0.00116665
R3369 AVDD_t51 AVDD_n656 0.00114283
R3370 AVDD_n685 AVDD_t190 0.00111109
R3371 AVDD_t103 AVDD_n38 0.00107691
R3372 AVDD_n793 AVDD_n500 0.00106249
R3373 AVDD_n334 AVDD_n12 0.00106249
R3374 AVDD_n801 AVDD_n800 0.001
R3375 AVDD_n801 AVDD_n492 0.001
R3376 AVDD_n496 AVDD_n495 0.001
R3377 AVDD_n788 AVDD_n494 0.001
R3378 AVDD_n786 AVDD_n499 0.001
R3379 AVDD_n786 AVDD_n493 0.001
R3380 AVDD_n630 AVDD_n504 0.001
R3381 AVDD_n629 AVDD_n604 0.001
R3382 AVDD_n628 AVDD_n605 0.001
R3383 AVDD_n627 AVDD_n606 0.001
R3384 AVDD_n626 AVDD_n607 0.001
R3385 AVDD_n625 AVDD_n608 0.001
R3386 AVDD_n624 AVDD_n609 0.001
R3387 AVDD_n623 AVDD_n610 0.001
R3388 AVDD_n622 AVDD_n611 0.001
R3389 AVDD_n619 AVDD_n613 0.001
R3390 AVDD_n619 AVDD_n614 0.001
R3391 AVDD_n716 AVDD_n615 0.001
R3392 AVDD_n717 AVDD_n716 0.001
R3393 AVDD_n717 AVDD_n616 0.001
R3394 AVDD_n618 AVDD_n615 0.001
R3395 AVDD_n618 AVDD_n614 0.001
R3396 AVDD_n620 AVDD_n613 0.001
R3397 AVDD_n621 AVDD_n611 0.001
R3398 AVDD_n622 AVDD_n610 0.001
R3399 AVDD_n623 AVDD_n609 0.001
R3400 AVDD_n624 AVDD_n608 0.001
R3401 AVDD_n625 AVDD_n607 0.001
R3402 AVDD_n626 AVDD_n606 0.001
R3403 AVDD_n627 AVDD_n605 0.001
R3404 AVDD_n628 AVDD_n604 0.001
R3405 AVDD_n798 AVDD_n504 0.001
R3406 AVDD_n654 AVDD_n635 0.001
R3407 AVDD_n697 AVDD_n696 0.001
R3408 AVDD_n694 AVDD_n633 0.001
R3409 AVDD_t187 AVDD_n634 0.001
R3410 AVDD_n686 AVDD_n641 0.001
R3411 AVDD_n682 AVDD_n640 0.001
R3412 AVDD_n683 AVDD_t40 0.001
R3413 AVDD_n684 AVDD_n639 0.001
R3414 AVDD_n565 AVDD_n564 0.001
R3415 AVDD_n575 AVDD_n574 0.001
R3416 AVDD_n582 AVDD_n581 0.001
R3417 AVDD_n578 AVDD_n577 0.001
R3418 AVDD_n540 AVDD_n527 0.001
R3419 AVDD_t133 AVDD_n526 0.001
R3420 AVDD_n733 AVDD_n524 0.001
R3421 AVDD_n735 AVDD_n523 0.001
R3422 AVDD_n547 AVDD_n522 0.001
R3423 AVDD_n547 AVDD_n521 0.001
R3424 AVDD_n764 AVDD_n545 0.001
R3425 AVDD_n766 AVDD_n545 0.001
R3426 AVDD_t212 AVDD_n544 0.001
R3427 AVDD_n763 AVDD_n762 0.001
R3428 AVDD_n760 AVDD_n759 0.001
R3429 AVDD_t41 AVDD_n530 0.001
R3430 AVDD_t41 AVDD_n529 0.001
R3431 AVDD_n753 AVDD_n540 0.001
R3432 AVDD_n750 AVDD_n525 0.001
R3433 AVDD_n749 AVDD_n525 0.001
R3434 AVDD_n733 AVDD_n550 0.001
R3435 AVDD_n549 AVDD_t120 0.001
R3436 AVDD_n548 AVDD_t207 0.001
R3437 AVDD_n799 AVDD_n501 0.001
R3438 AVDD_n588 AVDD_n502 0.001
R3439 AVDD_n589 AVDD_n516 0.001
R3440 AVDD_n590 AVDD_n515 0.001
R3441 AVDD_n592 AVDD_n513 0.001
R3442 AVDD_n593 AVDD_t56 0.001
R3443 AVDD_n594 AVDD_n512 0.001
R3444 AVDD_n595 AVDD_n511 0.001
R3445 AVDD_n596 AVDD_n510 0.001
R3446 AVDD_n597 AVDD_n509 0.001
R3447 AVDD_n598 AVDD_n508 0.001
R3448 AVDD_n719 AVDD_n507 0.001
R3449 AVDD_n718 AVDD_n602 0.001
R3450 AVDD_n695 AVDD_n693 0.001
R3451 AVDD_n671 AVDD_n655 0.001
R3452 AVDD_n669 AVDD_n643 0.001
R3453 AVDD_n660 AVDD_t196 0.001
R3454 AVDD_n659 AVDD_t40 0.001
R3455 AVDD_n652 AVDD_n636 0.001
R3456 AVDD_n643 AVDD_n642 0.001
R3457 AVDD_n799 AVDD_n497 0.001
R3458 AVDD_n569 AVDD_n568 0.001
R3459 AVDD_n580 AVDD_n576 0.001
R3460 AVDD_n583 AVDD_n582 0.001
R3461 AVDD_n762 AVDD_n535 0.001
R3462 AVDD_n761 AVDD_n536 0.001
R3463 AVDD_n538 AVDD_n537 0.001
R3464 AVDD_n541 AVDD_t133 0.001
R3465 AVDD_n748 AVDD_n747 0.001
R3466 AVDD_n736 AVDD_t207 0.001
R3467 AVDD_n684 AVDD_n638 0.001
R3468 AVDD_n659 AVDD_n638 0.001
R3469 AVDD_n683 AVDD_n640 0.001
R3470 AVDD_n682 AVDD_t196 0.001
R3471 AVDD_n660 AVDD_n641 0.001
R3472 AVDD_n686 AVDD_n637 0.001
R3473 AVDD_n642 AVDD_n637 0.001
R3474 AVDD_n669 AVDD_n636 0.001
R3475 AVDD_n653 AVDD_n652 0.001
R3476 AVDD_n655 AVDD_n654 0.001
R3477 AVDD_n671 AVDD_t198 0.001
R3478 AVDD_n634 AVDD_n633 0.001
R3479 AVDD_n695 AVDD_n694 0.001
R3480 AVDD_n693 AVDD_n632 0.001
R3481 AVDD_n696 AVDD_n632 0.001
R3482 AVDD_n697 AVDD_n602 0.001
R3483 AVDD_n719 AVDD_n718 0.001
R3484 AVDD_n598 AVDD_n507 0.001
R3485 AVDD_n597 AVDD_n508 0.001
R3486 AVDD_n596 AVDD_n509 0.001
R3487 AVDD_n595 AVDD_n510 0.001
R3488 AVDD_n594 AVDD_n511 0.001
R3489 AVDD_n593 AVDD_n512 0.001
R3490 AVDD_n592 AVDD_t56 0.001
R3491 AVDD_n590 AVDD_n514 0.001
R3492 AVDD_n589 AVDD_n515 0.001
R3493 AVDD_n588 AVDD_n516 0.001
R3494 AVDD_n502 AVDD_n501 0.001
R3495 AVDD_n577 AVDD_n497 0.001
R3496 AVDD_n579 AVDD_n578 0.001
R3497 AVDD_n583 AVDD_n579 0.001
R3498 AVDD_n581 AVDD_n580 0.001
R3499 AVDD_n576 AVDD_n575 0.001
R3500 AVDD_n574 AVDD_n573 0.001
R3501 AVDD_n570 AVDD_n569 0.001
R3502 AVDD_n564 AVDD_n563 0.001
R3503 AVDD_t205 AVDD_n521 0.001
R3504 AVDD_n737 AVDD_n522 0.001
R3505 AVDD_n737 AVDD_n548 0.001
R3506 AVDD_n736 AVDD_t120 0.001
R3507 AVDD_n735 AVDD_n549 0.001
R3508 AVDD_n734 AVDD_n523 0.001
R3509 AVDD_n734 AVDD_n550 0.001
R3510 AVDD_n748 AVDD_n524 0.001
R3511 AVDD_n747 AVDD_t129 0.001
R3512 AVDD_n749 AVDD_t129 0.001
R3513 AVDD_n750 AVDD_t209 0.001
R3514 AVDD_n542 AVDD_n526 0.001
R3515 AVDD_n752 AVDD_n541 0.001
R3516 AVDD_n753 AVDD_n752 0.001
R3517 AVDD_n539 AVDD_n527 0.001
R3518 AVDD_n539 AVDD_n529 0.001
R3519 AVDD_n537 AVDD_n530 0.001
R3520 AVDD_n759 AVDD_n538 0.001
R3521 AVDD_n760 AVDD_n758 0.001
R3522 AVDD_n758 AVDD_n536 0.001
R3523 AVDD_n763 AVDD_n761 0.001
R3524 AVDD_n543 AVDD_n535 0.001
R3525 AVDD_n544 AVDD_n543 0.001
R3526 AVDD_t212 AVDD_n766 0.001
R3527 AVDD_n764 AVDD_t214 0.001
R3528 AVDD_n800 AVDD_n490 0.001
R3529 AVDD_n495 AVDD_n492 0.001
R3530 AVDD_n788 AVDD_n496 0.001
R3531 AVDD_n787 AVDD_n494 0.001
R3532 AVDD_n787 AVDD_n499 0.001
R3533 AVDD_n785 AVDD_n493 0.001
R3534 AVDD_t72 AVDD_n815 0.001
R3535 AVDD_n815 AVDD_t57 0.001
R3536 AVDD_n471 AVDD_t11 0.001
R3537 AVDD_n460 AVDD_t17 0.001
R3538 AVDD_n454 AVDD_t22 0.001
R3539 AVDD_t6 AVDD_n471 0.001
R3540 AVDD_n460 AVDD_t11 0.001
R3541 AVDD_n454 AVDD_t17 0.001
R3542 AVDD_t63 AVDD_n381 0.001
R3543 AVDD_t79 AVDD_n381 0.001
R3544 AVDD_n1 AVDD_n0 0.001
R3545 AVDD_n22 AVDD_n9 0.001
R3546 AVDD_n18 AVDD_n5 0.001
R3547 AVDD_n17 AVDD_n4 0.001
R3548 AVDD_n15 AVDD_n2 0.001
R3549 AVDD_n14 AVDD_n2 0.001
R3550 AVDD_n330 AVDD_n13 0.001
R3551 AVDD_n334 AVDD_n13 0.001
R3552 AVDD_n22 AVDD_n10 0.001
R3553 AVDD_n18 AVDD_n6 0.001
R3554 AVDD_n17 AVDD_n5 0.001
R3555 AVDD_n15 AVDD_n3 0.001
R3556 AVDD_n14 AVDD_n1 0.001
R3557 AVDD_n160 AVDD_n158 0.001
R3558 AVDD_n160 AVDD_n154 0.001
R3559 AVDD_n137 AVDD_n136 0.001
R3560 AVDD_n135 AVDD_n134 0.001
R3561 AVDD_n133 AVDD_n132 0.001
R3562 AVDD_n131 AVDD_n130 0.001
R3563 AVDD_n129 AVDD_n128 0.001
R3564 AVDD_n147 AVDD_n146 0.001
R3565 AVDD_n123 AVDD_n120 0.001
R3566 AVDD_n124 AVDD_n103 0.001
R3567 AVDD_n296 AVDD_n102 0.001
R3568 AVDD_t103 AVDD_n41 0.001
R3569 AVDD_n311 AVDD_n51 0.001
R3570 AVDD_n310 AVDD_n52 0.001
R3571 AVDD_n309 AVDD_n61 0.001
R3572 AVDD_n308 AVDD_n60 0.001
R3573 AVDD_n306 AVDD_t218 0.001
R3574 AVDD_n305 AVDD_n29 0.001
R3575 AVDD_n92 AVDD_n78 0.001
R3576 AVDD_n93 AVDD_n76 0.001
R3577 AVDD_n94 AVDD_n74 0.001
R3578 AVDD_n95 AVDD_t107 0.001
R3579 AVDD_n96 AVDD_n70 0.001
R3580 AVDD_n98 AVDD_n48 0.001
R3581 AVDD_n99 AVDD_n64 0.001
R3582 AVDD_n203 AVDD_n202 0.001
R3583 AVDD_n208 AVDD_n190 0.001
R3584 AVDD_n211 AVDD_t68 0.001
R3585 AVDD_n216 AVDD_t66 0.001
R3586 AVDD_n218 AVDD_n217 0.001
R3587 AVDD_n183 AVDD_n153 0.001
R3588 AVDD_n51 AVDD_n37 0.001
R3589 AVDD_n52 AVDD_n36 0.001
R3590 AVDD_n60 AVDD_n35 0.001
R3591 AVDD_n59 AVDD_n33 0.001
R3592 AVDD_n56 AVDD_n27 0.001
R3593 AVDD_n57 AVDD_n26 0.001
R3594 AVDD_n332 AVDD_t95 0.001
R3595 AVDD_n23 AVDD_t93 0.001
R3596 AVDD_n281 AVDD_n173 0.001
R3597 AVDD_n276 AVDD_n176 0.001
R3598 AVDD_n276 AVDD_n177 0.001
R3599 AVDD_n228 AVDD_n178 0.001
R3600 AVDD_n302 AVDD_n301 0.001
R3601 AVDD_n78 AVDD_n77 0.001
R3602 AVDD_n75 AVDD_n45 0.001
R3603 AVDD_n73 AVDD_t107 0.001
R3604 AVDD_n72 AVDD_n71 0.001
R3605 AVDD_t105 AVDD_n68 0.001
R3606 AVDD_n67 AVDD_n48 0.001
R3607 AVDD_n66 AVDD_n65 0.001
R3608 AVDD_n64 AVDD_n63 0.001
R3609 AVDD_n240 AVDD_t218 0.001
R3610 AVDD_n241 AVDD_n29 0.001
R3611 AVDD_n243 AVDD_n57 0.001
R3612 AVDD_n152 AVDD_n151 0.001
R3613 AVDD_n109 AVDD_n108 0.001
R3614 AVDD_n111 AVDD_n110 0.001
R3615 AVDD_n114 AVDD_n113 0.001
R3616 AVDD_n115 AVDD_n114 0.001
R3617 AVDD_n116 AVDD_t3 0.001
R3618 AVDD_n149 AVDD_n119 0.001
R3619 AVDD_n118 AVDD_n104 0.001
R3620 AVDD_n298 AVDD_n297 0.001
R3621 AVDD_n230 AVDD_n229 0.001
R3622 AVDD_t112 AVDD_n179 0.001
R3623 AVDD_n278 AVDD_n181 0.001
R3624 AVDD_n226 AVDD_n225 0.001
R3625 AVDD_n223 AVDD_n192 0.001
R3626 AVDD_t110 AVDD_n191 0.001
R3627 AVDD_t69 AVDD_n189 0.001
R3628 AVDD_t68 AVDD_n188 0.001
R3629 AVDD_t66 AVDD_n187 0.001
R3630 AVDD_t64 AVDD_n186 0.001
R3631 AVDD_n184 AVDD_n183 0.001
R3632 AVDD_n227 AVDD_t112 0.001
R3633 AVDD_n195 AVDD_n181 0.001
R3634 AVDD_n225 AVDD_n224 0.001
R3635 AVDD_t110 AVDD_n207 0.001
R3636 AVDD_t69 AVDD_n209 0.001
R3637 AVDD_n214 AVDD_n213 0.001
R3638 AVDD_n333 AVDD_n23 0.001
R3639 AVDD_n333 AVDD_n332 0.001
R3640 AVDD_n244 AVDD_n26 0.001
R3641 AVDD_n243 AVDD_n58 0.001
R3642 AVDD_n58 AVDD_n27 0.001
R3643 AVDD_n241 AVDD_n55 0.001
R3644 AVDD_n305 AVDD_n32 0.001
R3645 AVDD_n240 AVDD_n32 0.001
R3646 AVDD_n306 AVDD_n54 0.001
R3647 AVDD_n54 AVDD_n33 0.001
R3648 AVDD_n308 AVDD_t220 0.001
R3649 AVDD_n53 AVDD_n35 0.001
R3650 AVDD_n309 AVDD_n53 0.001
R3651 AVDD_n61 AVDD_n36 0.001
R3652 AVDD_n310 AVDD_t54 0.001
R3653 AVDD_n311 AVDD_t101 0.001
R3654 AVDD_n62 AVDD_n37 0.001
R3655 AVDD_n62 AVDD_n41 0.001
R3656 AVDD_n63 AVDD_n50 0.001
R3657 AVDD_n99 AVDD_n49 0.001
R3658 AVDD_n65 AVDD_n49 0.001
R3659 AVDD_n98 AVDD_n66 0.001
R3660 AVDD_t105 AVDD_n67 0.001
R3661 AVDD_n68 AVDD_n47 0.001
R3662 AVDD_n96 AVDD_n46 0.001
R3663 AVDD_n71 AVDD_n46 0.001
R3664 AVDD_n95 AVDD_n72 0.001
R3665 AVDD_n74 AVDD_n73 0.001
R3666 AVDD_n94 AVDD_n45 0.001
R3667 AVDD_n76 AVDD_n75 0.001
R3668 AVDD_n93 AVDD_n44 0.001
R3669 AVDD_n77 AVDD_n44 0.001
R3670 AVDD_n92 AVDD_n43 0.001
R3671 AVDD_n301 AVDD_n43 0.001
R3672 AVDD_n299 AVDD_n298 0.001
R3673 AVDD_n297 AVDD_n104 0.001
R3674 AVDD_n119 AVDD_n118 0.001
R3675 AVDD_n117 AVDD_n116 0.001
R3676 AVDD_t3 AVDD_n115 0.001
R3677 AVDD_n113 AVDD_n112 0.001
R3678 AVDD_n112 AVDD_n111 0.001
R3679 AVDD_n110 AVDD_n109 0.001
R3680 AVDD_n295 AVDD_n152 0.001
R3681 AVDD_n295 AVDD_n153 0.001
R3682 AVDD_n219 AVDD_n184 0.001
R3683 AVDD_n218 AVDD_t64 0.001
R3684 AVDD_n215 AVDD_n186 0.001
R3685 AVDD_n216 AVDD_n215 0.001
R3686 AVDD_n212 AVDD_n187 0.001
R3687 AVDD_n213 AVDD_n212 0.001
R3688 AVDD_n214 AVDD_n188 0.001
R3689 AVDD_n211 AVDD_n210 0.001
R3690 AVDD_n210 AVDD_n189 0.001
R3691 AVDD_n209 AVDD_n190 0.001
R3692 AVDD_n208 AVDD_t46 0.001
R3693 AVDD_n207 AVDD_t46 0.001
R3694 AVDD_n202 AVDD_n191 0.001
R3695 AVDD_n203 AVDD_n201 0.001
R3696 AVDD_n201 AVDD_n192 0.001
R3697 AVDD_n224 AVDD_n223 0.001
R3698 AVDD_n226 AVDD_n196 0.001
R3699 AVDD_n196 AVDD_n195 0.001
R3700 AVDD_n279 AVDD_n278 0.001
R3701 AVDD_n279 AVDD_n179 0.001
R3702 AVDD_n228 AVDD_n227 0.001
R3703 AVDD_n229 AVDD_n178 0.001
R3704 AVDD_n230 AVDD_t230 0.001
R3705 AVDD_t230 AVDD_n177 0.001
R3706 AVDD_n176 AVDD_n173 0.001
R3707 AVDD_t114 AVDD_n281 0.001
R3708 AVDD_n102 AVDD_n89 0.001
R3709 AVDD_n121 AVDD_n103 0.001
R3710 AVDD_n124 AVDD_n123 0.001
R3711 AVDD_n147 AVDD_n120 0.001
R3712 AVDD_n144 AVDD_n128 0.001
R3713 AVDD_n130 AVDD_n129 0.001
R3714 AVDD_n132 AVDD_n131 0.001
R3715 AVDD_n134 AVDD_n133 0.001
R3716 AVDD_n136 AVDD_n135 0.001
R3717 AVDD_n161 AVDD_n158 0.001
R3718 AVDD_n159 AVDD_n154 0.001
R3719 AVDD_t38 AVDD_n365 0.001
R3720 AVDD_n365 AVDD_t0 0.001
R3721 VGND_n10 VGND_n9 427.132
R3722 VGND_t524 VGND_n152 414.274
R3723 VGND_n188 VGND_t399 414.274
R3724 VGND_n188 VGND_t23 414.274
R3725 VGND_n26 VGND_t403 414.274
R3726 VGND_n227 VGND_n226 411.43
R3727 VGND_t280 VGND_n71 407.144
R3728 VGND_t494 VGND_n49 407.144
R3729 VGND_t528 VGND_n41 407.144
R3730 VGND_t512 VGND_n41 407.144
R3731 VGND_n178 VGND_t82 407.144
R3732 VGND_t454 VGND_n38 407.144
R3733 VGND_n186 VGND_t88 407.144
R3734 VGND_n166 VGND_t21 398.572
R3735 VGND_t432 VGND_n14 385.714
R3736 VGND_t526 VGND_n67 379.99
R3737 VGND_n138 VGND_t276 377.144
R3738 VGND_t274 VGND_n88 372.858
R3739 VGND_n201 VGND_t506 372.858
R3740 VGND_n204 VGND_t41 372.858
R3741 VGND_n209 VGND_t429 372.858
R3742 VGND_n224 VGND_t315 372.858
R3743 VGND_t273 VGND_t304 360
R3744 VGND_t514 VGND_t56 360
R3745 VGND_n215 VGND_t318 360
R3746 VGND_n53 VGND_t421 354.897
R3747 VGND_n67 VGND_t275 354.274
R3748 VGND_n210 VGND_t322 354.274
R3749 VGND_t302 VGND_n47 347.144
R3750 VGND_t313 VGND_n44 347.144
R3751 VGND_n18 VGND_t418 337.132
R3752 VGND_n187 VGND_t4 334.286
R3753 VGND_n221 VGND_t75 334.286
R3754 VGND_n24 VGND_t112 328.56
R3755 VGND_n21 VGND_t127 328.56
R3756 VGND_t530 VGND_n210 328.56
R3757 VGND_t81 VGND_n216 328.56
R3758 VGND_t119 VGND_t255 325.714
R3759 VGND_n166 VGND_t114 321.43
R3760 VGND_n174 VGND_t422 321.43
R3761 VGND_n226 VGND_t521 312.858
R3762 VGND_t264 VGND_n27 312.858
R3763 VGND_t49 VGND_n25 312.858
R3764 VGND_t520 VGND_n22 312.858
R3765 VGND_t9 VGND_n19 312.858
R3766 VGND_t456 VGND_n17 312.858
R3767 VGND_t298 VGND_n11 312.858
R3768 VGND_t116 VGND_n54 308.572
R3769 VGND_t405 VGND_n32 308.572
R3770 VGND_t324 VGND_n12 308.572
R3771 VGND_t256 VGND_n39 304.286
R3772 VGND_t53 VGND_n72 300
R3773 VGND_n178 VGND_t19 282.858
R3774 VGND_t401 VGND_n35 278.572
R3775 VGND_n139 VGND_t118 274.286
R3776 VGND_n57 VGND_t420 272.846
R3777 VGND_t86 VGND_t68 265.714
R3778 VGND_t278 VGND_t73 265.714
R3779 VGND_n186 VGND_t257 257.144
R3780 VGND_n220 VGND_t425 257.144
R3781 VGND_t336 VGND_n123 252.065
R3782 VGND_n103 VGND_t359 252.041
R3783 VGND_t364 VGND_n82 252.041
R3784 VGND_n123 VGND_t334 243.494
R3785 VGND_t329 VGND_n82 243.47
R3786 VGND_t349 VGND_n57 242.846
R3787 VGND_t354 VGND_n91 235.714
R3788 VGND_t326 VGND_n87 235.714
R3789 VGND_n119 VGND_t331 235.714
R3790 VGND_n139 VGND_t341 235.714
R3791 VGND_n113 VGND_t362 227.143
R3792 VGND_t367 VGND_n76 227.143
R3793 VGND_t339 VGND_n74 227.143
R3794 VGND_n145 VGND_t344 227.143
R3795 VGND_t346 VGND_t272 222.857
R3796 VGND_t297 VGND_n38 210
R3797 VGND_n162 VGND_t351 205.714
R3798 VGND_n185 VGND_t297 201.429
R3799 VGND_n99 VGND_t357 200.613
R3800 VGND_n132 VGND_t339 200.613
R3801 VGND_t362 VGND_n107 199.989
R3802 VGND_n78 VGND_t367 199.989
R3803 VGND_n156 VGND_t346 192.042
R3804 VGND_n107 VGND_t326 191.417
R3805 VGND_t331 VGND_n78 191.417
R3806 VGND_n113 VGND_t329 184.286
R3807 VGND_t334 VGND_n76 184.286
R3808 VGND_t42 VGND_t349 180
R3809 VGND_t359 VGND_n87 175.714
R3810 VGND_n119 VGND_t364 175.714
R3811 VGND_t341 VGND_n71 175.714
R3812 VGND_t66 VGND_t336 171.429
R3813 VGND_t344 VGND_t70 162.857
R3814 VGND_t420 VGND_n54 154.286
R3815 VGND_t257 VGND_n32 154.286
R3816 VGND_t253 VGND_t354 137.143
R3817 VGND_t118 VGND_n72 137.143
R3818 VGND_n185 VGND_t401 132.857
R3819 VGND_t357 VGND_t269 128.571
R3820 VGND_t351 VGND_t57 128.571
R3821 VGND_t19 VGND_n39 128.571
R3822 VGND_n355 VGND_n228 124.096
R3823 VGND_t425 VGND_t37 115.715
R3824 VGND_n138 VGND_t53 111.43
R3825 VGND_n181 VGND_t256 107.144
R3826 VGND_n162 VGND_t116 102.858
R3827 VGND_n221 VGND_t324 102.858
R3828 VGND_n91 VGND_t521 98.5719
R3829 VGND_t269 VGND_n88 98.5719
R3830 VGND_n191 VGND_t264 98.5719
R3831 VGND_n197 VGND_t49 98.5719
R3832 VGND_t112 VGND_n22 98.5719
R3833 VGND_t127 VGND_n19 98.5719
R3834 VGND_n220 VGND_t81 98.5719
R3835 VGND_n224 VGND_t298 98.5719
R3836 VGND_t57 VGND_n53 93.4703
R3837 VGND_t73 VGND_n63 90.0005
R3838 VGND_t114 VGND_n47 90.0005
R3839 VGND_t422 VGND_n44 90.0005
R3840 VGND_t271 VGND_t405 90.0005
R3841 VGND_t418 VGND_n17 90.0005
R3842 VGND_n626 VGND_n3 89.4633
R3843 VGND_t275 VGND_n65 88.5605
R3844 VGND_n170 VGND_t119 88.5605
R3845 VGND_t68 VGND_n63 81.4291
R3846 VGND_n65 VGND_t86 79.9891
R3847 VGND_n170 VGND_t313 79.9891
R3848 VGND_t4 VGND_n29 77.1434
R3849 VGND_n215 VGND_t424 77.1434
R3850 VGND_t75 VGND_n11 77.1434
R3851 VGND_n227 VGND_n4 73.3091
R3852 VGND_n228 VGND_n227 73.3091
R3853 VGND_t421 VGND_n49 72.8576
R3854 VGND_t322 VGND_n16 72.8576
R3855 VGND_n9 VGND_n3 71.7824
R3856 VGND_n9 VGND_n4 71.755
R3857 VGND_n152 VGND_t278 71.4177
R3858 VGND_n163 VGND_t302 64.2862
R3859 VGND_n209 VGND_t445 64.2862
R3860 VGND_t483 VGND_t520 60.0005
R3861 VGND_t531 VGND_t9 60.0005
R3862 VGND_n627 VGND_n625 59.4776
R3863 VGND_n103 VGND_t274 54.8988
R3864 VGND_n99 VGND_t253 54.8988
R3865 VGND_t304 VGND_n26 54.2748
R3866 VGND_t56 VGND_n24 54.2748
R3867 VGND_t506 VGND_n21 54.2748
R3868 VGND_t41 VGND_n18 54.2748
R3869 VGND_t315 VGND_n10 54.2748
R3870 VGND_n626 VGND_n265 54.1219
R3871 VGND_n709 VGND_n242 52.899
R3872 VGND_n356 VGND_n355 51.9883
R3873 VGND_n520 VGND_n358 51.9883
R3874 VGND_n515 VGND_n360 51.9883
R3875 VGND_n523 VGND_n362 51.9883
R3876 VGND_n528 VGND_n364 51.9883
R3877 VGND_n503 VGND_n366 51.9883
R3878 VGND_n498 VGND_n368 51.9883
R3879 VGND_n536 VGND_n370 51.9883
R3880 VGND_n486 VGND_n376 51.9883
R3881 VGND_n477 VGND_n378 51.9883
R3882 VGND_n555 VGND_n380 51.9883
R3883 VGND_n559 VGND_n382 51.9883
R3884 VGND_n473 VGND_n384 51.9883
R3885 VGND_n468 VGND_n386 51.9883
R3886 VGND_n567 VGND_n388 51.9883
R3887 VGND_n454 VGND_n391 51.9883
R3888 VGND_n450 VGND_n394 51.9883
R3889 VGND_n581 VGND_n396 51.9883
R3890 VGND_n447 VGND_n397 51.9883
R3891 VGND_n586 VGND_n398 51.9883
R3892 VGND_n444 VGND_n400 51.9883
R3893 VGND_n592 VGND_n402 51.9883
R3894 VGND_n440 VGND_n404 51.9883
R3895 VGND_n438 VGND_n406 51.9883
R3896 VGND_n600 VGND_n408 51.9883
R3897 VGND_n435 VGND_n410 51.9883
R3898 VGND_n605 VGND_n412 51.9883
R3899 VGND_n432 VGND_n414 51.9883
R3900 VGND_n613 VGND_n416 51.9883
R3901 VGND_n428 VGND_n417 51.9883
R3902 VGND_n616 VGND_n418 51.9883
R3903 VGND_n619 VGND_n420 51.9883
R3904 VGND_n423 VGND_n421 51.9883
R3905 VGND_n357 VGND_t60 51.2237
R3906 VGND_n399 VGND_t301 51.2237
R3907 VGND_n405 VGND_t509 51.2237
R3908 VGND_n413 VGND_t508 51.2237
R3909 VGND_n379 VGND_t426 48.1656
R3910 VGND_n145 VGND_t526 47.1434
R3911 VGND_n576 VGND_t511 43.5785
R3912 VGND_n393 VGND_t282 43.5785
R3913 VGND_n482 VGND_t379 42.0494
R3914 VGND_n216 VGND_t432 41.4177
R3915 VGND_n359 VGND_t287 40.5204
R3916 VGND_n395 VGND_t5 40.5204
R3917 VGND_n407 VGND_t39 40.5204
R3918 VGND_n415 VGND_t44 40.5204
R3919 VGND_n419 VGND_t35 40.5204
R3920 VGND_n521 VGND_n352 39.7559
R3921 VGND_n514 VGND_n350 39.7559
R3922 VGND_n529 VGND_n348 39.7559
R3923 VGND_n500 VGND_n347 39.7559
R3924 VGND_n497 VGND_n345 39.7559
R3925 VGND_n493 VGND_n343 39.7559
R3926 VGND_n481 VGND_n342 39.7559
R3927 VGND_n484 VGND_n341 39.7559
R3928 VGND_n556 VGND_n337 39.7559
R3929 VGND_n560 VGND_n336 39.7559
R3930 VGND_n470 VGND_n335 39.7559
R3931 VGND_n467 VGND_n333 39.7559
R3932 VGND_n461 VGND_n331 39.7559
R3933 VGND_n574 VGND_n329 39.7559
R3934 VGND_n453 VGND_n328 39.7559
R3935 VGND_n449 VGND_n324 39.7559
R3936 VGND_n582 VGND_n322 39.7559
R3937 VGND_n443 VGND_n316 39.7559
R3938 VGND_n593 VGND_n315 39.7559
R3939 VGND_n437 VGND_n312 39.7559
R3940 VGND_n601 VGND_n310 39.7559
R3941 VGND_n431 VGND_n306 39.7559
R3942 VGND_n614 VGND_n304 39.7559
R3943 VGND_n427 VGND_n302 39.7559
R3944 VGND_n425 VGND_n300 39.7559
R3945 VGND_n620 VGND_n298 39.7559
R3946 VGND_n201 VGND_t483 38.5719
R3947 VGND_n204 VGND_t531 38.5719
R3948 VGND_t429 VGND_n16 38.5719
R3949 VGND_t267 VGND_n14 38.5719
R3950 VGND_t37 VGND_n12 38.5719
R3951 VGND_t377 VGND_n344 37.4623
R3952 VGND_t390 VGND_n332 37.4623
R3953 VGND_t70 VGND_n144 37.1319
R3954 VGND_n549 VGND_t384 36.6977
R3955 VGND_n573 VGND_t392 36.6977
R3956 VGND_t276 VGND_n74 34.2862
R3957 VGND_t445 VGND_t456 34.2862
R3958 VGND_n519 VGND_n354 33.6396
R3959 VGND_n517 VGND_n352 33.6396
R3960 VGND_n522 VGND_n350 33.6396
R3961 VGND_n511 VGND_n349 33.6396
R3962 VGND_n504 VGND_n347 33.6396
R3963 VGND_n535 VGND_n345 33.6396
R3964 VGND_n492 VGND_n343 33.6396
R3965 VGND_n483 VGND_n342 33.6396
R3966 VGND_n485 VGND_n341 33.6396
R3967 VGND_n478 VGND_n340 33.6396
R3968 VGND_n552 VGND_n339 33.6396
R3969 VGND_n475 VGND_n337 33.6396
R3970 VGND_n474 VGND_n336 33.6396
R3971 VGND_n561 VGND_n335 33.6396
R3972 VGND_n566 VGND_n333 33.6396
R3973 VGND_n460 VGND_n331 33.6396
R3974 VGND_n457 VGND_n329 33.6396
R3975 VGND_n575 VGND_n328 33.6396
R3976 VGND_n451 VGND_n326 33.6396
R3977 VGND_n578 VGND_n324 33.6396
R3978 VGND_n448 VGND_n322 33.6396
R3979 VGND_n585 VGND_n320 33.6396
R3980 VGND_n445 VGND_n318 33.6396
R3981 VGND_n591 VGND_n316 33.6396
R3982 VGND_n439 VGND_n314 33.6396
R3983 VGND_n597 VGND_n312 33.6396
R3984 VGND_n436 VGND_n310 33.6396
R3985 VGND_n604 VGND_n309 33.6396
R3986 VGND_n433 VGND_n308 33.6396
R3987 VGND_n609 VGND_n306 33.6396
R3988 VGND_n430 VGND_n304 33.6396
R3989 VGND_n615 VGND_n302 33.6396
R3990 VGND_n426 VGND_n300 33.6396
R3991 VGND_n424 VGND_n298 33.6396
R3992 VGND_n623 VGND_n296 33.6396
R3993 VGND_n508 VGND_t372 32.8751
R3994 VGND_n487 VGND_t382 32.8751
R3995 VGND_t58 VGND_n320 32.8751
R3996 VGND_t27 VGND_n309 32.8751
R3997 VGND_t289 VGND_n296 32.8751
R3998 VGND_n509 VGND_t369 31.3461
R3999 VGND_t25 VGND_n315 31.3461
R4000 VGND_n153 VGND_t524 28.5605
R4001 VGND_t272 VGND_n153 28.5605
R4002 VGND_t21 VGND_n46 28.5605
R4003 VGND_t255 VGND_n46 28.5605
R4004 VGND_t374 VGND_n346 28.288
R4005 VGND_t387 VGND_n334 28.288
R4006 VGND_n367 VGND_t374 26.7589
R4007 VGND_n385 VGND_t387 26.7589
R4008 VGND_t121 VGND_n339 25.2299
R4009 VGND_n355 VGND_n8 22.5214
R4010 VGND_t300 VGND_n354 22.1718
R4011 VGND_n577 VGND_t51 22.1718
R4012 VGND_t295 VGND_n318 22.1718
R4013 VGND_t84 VGND_n314 22.1718
R4014 VGND_t496 VGND_n308 22.1718
R4015 VGND_n514 VGND_n361 21.7859
R4016 VGND_n509 VGND_n363 21.7859
R4017 VGND_n529 VGND_n365 21.7859
R4018 VGND_n493 VGND_n371 21.7859
R4019 VGND_n481 VGND_n373 21.7859
R4020 VGND_n484 VGND_n375 21.7859
R4021 VGND_n549 VGND_n377 21.7859
R4022 VGND_n556 VGND_n381 21.7859
R4023 VGND_n461 VGND_n330 21.7859
R4024 VGND_n574 VGND_n390 21.7859
R4025 VGND_n453 VGND_n327 21.7859
R4026 VGND_n582 VGND_n321 21.7859
R4027 VGND_n446 VGND_n319 21.7859
R4028 VGND_n443 VGND_n401 21.7859
R4029 VGND_n593 VGND_n403 21.7859
R4030 VGND_n601 VGND_n409 21.7859
R4031 VGND_n434 VGND_n411 21.7859
R4032 VGND_n614 VGND_n303 21.7859
R4033 VGND_n620 VGND_n297 21.7859
R4034 VGND_n422 VGND_n295 21.7859
R4035 VGND_t424 VGND_t530 21.4291
R4036 VGND_n519 VGND_n356 21.4072
R4037 VGND_n517 VGND_n358 21.4072
R4038 VGND_n511 VGND_n362 21.4072
R4039 VGND_n508 VGND_n364 21.4072
R4040 VGND_n504 VGND_n366 21.4072
R4041 VGND_n535 VGND_n368 21.4072
R4042 VGND_n492 VGND_n370 21.4072
R4043 VGND_n483 VGND_n372 21.4072
R4044 VGND_n485 VGND_n374 21.4072
R4045 VGND_n478 VGND_n376 21.4072
R4046 VGND_n552 VGND_n378 21.4072
R4047 VGND_n475 VGND_n380 21.4072
R4048 VGND_n561 VGND_n384 21.4072
R4049 VGND_n566 VGND_n386 21.4072
R4050 VGND_n460 VGND_n388 21.4072
R4051 VGND_n457 VGND_n389 21.4072
R4052 VGND_n451 VGND_n392 21.4072
R4053 VGND_n578 VGND_n394 21.4072
R4054 VGND_n445 VGND_n398 21.4072
R4055 VGND_n591 VGND_n400 21.4072
R4056 VGND_n441 VGND_n402 21.4072
R4057 VGND_n439 VGND_n404 21.4072
R4058 VGND_n597 VGND_n406 21.4072
R4059 VGND_n433 VGND_n412 21.4072
R4060 VGND_n609 VGND_n414 21.4072
R4061 VGND_n426 VGND_n418 21.4072
R4062 VGND_t110 VGND_n391 20.6427
R4063 VGND_n132 VGND_t66 20.6131
R4064 VGND_n156 VGND_t42 20.6121
R4065 VGND_n144 VGND_t280 19.9891
R4066 VGND_n175 VGND_t512 19.9891
R4067 VGND_t82 VGND_n175 19.9891
R4068 VGND_t281 VGND_n383 19.4923
R4069 VGND_t428 VGND_n301 19.4923
R4070 VGND_t382 VGND_n374 19.1136
R4071 VGND_t71 VGND_n382 19.1136
R4072 VGND_t320 VGND_n417 19.1136
R4073 VGND_n518 VGND_t300 17.5846
R4074 VGND_n369 VGND_t377 17.5846
R4075 VGND_n387 VGND_t390 17.5846
R4076 VGND_t51 VGND_n326 17.5846
R4077 VGND_n585 VGND_t263 17.5846
R4078 VGND_n590 VGND_t295 17.5846
R4079 VGND_n596 VGND_t84 17.5846
R4080 VGND_n604 VGND_t46 17.5846
R4081 VGND_n608 VGND_t496 17.5846
R4082 VGND_n623 VGND_t90 17.5846
R4083 VGND_n516 VGND_t61 17.4838
R4084 VGND_n622 VGND_t91 17.46
R4085 VGND_n223 VGND_t299 17.4106
R4086 VGND_n96 VGND_t270 17.3526
R4087 VGND_n217 VGND_t319 17.3263
R4088 VGND_n513 VGND_t288 17.3129
R4089 VGND_n93 VGND_t254 17.3129
R4090 VGND_n202 VGND_t128 17.3129
R4091 VGND_n199 VGND_t113 17.3129
R4092 VGND_n192 VGND_t265 17.3129
R4093 VGND_n195 VGND_t50 17.3129
R4094 VGND_n198 VGND_t507 17.3129
R4095 VGND_n205 VGND_t10 17.3129
R4096 VGND_n211 VGND_t430 17.3129
R4097 VGND_n213 VGND_t268 17.3129
R4098 VGND_n218 VGND_t38 17.3129
R4099 VGND_n583 VGND_t6 17.3129
R4100 VGND_n587 VGND_t59 17.3129
R4101 VGND_n588 VGND_t296 17.3129
R4102 VGND_n598 VGND_t85 17.3129
R4103 VGND_n602 VGND_t40 17.3129
R4104 VGND_n606 VGND_t28 17.3129
R4105 VGND_n610 VGND_t497 17.3129
R4106 VGND_n611 VGND_t45 17.3129
R4107 VGND_n621 VGND_t36 17.3129
R4108 VGND_n158 VGND_t117 17.2661
R4109 VGND_n222 VGND_t325 17.2327
R4110 VGND_n33 VGND_t258 17.2327
R4111 VGND_n97 VGND_t356 17.2313
R4112 VGND_n108 VGND_t361 17.2313
R4113 VGND_n109 VGND_t328 17.2313
R4114 VGND_n80 VGND_t366 17.2313
R4115 VGND_n79 VGND_t333 17.2313
R4116 VGND_n130 VGND_t338 17.2313
R4117 VGND_n142 VGND_t343 17.2313
R4118 VGND_n154 VGND_t348 17.2313
R4119 VGND_n507 VGND_t371 17.2313
R4120 VGND_n496 VGND_t376 17.2313
R4121 VGND_n466 VGND_t389 17.2313
R4122 VGND_n542 VGND_t381 17.2313
R4123 VGND_n55 VGND_t353 17.2284
R4124 VGND_n550 VGND_t386 17.2284
R4125 VGND_n458 VGND_t394 17.2284
R4126 VGND_n133 VGND_t54 17.2247
R4127 VGND_n147 VGND_t87 17.2205
R4128 VGND_n212 VGND_t323 17.2205
R4129 VGND_n168 VGND_t120 17.2205
R4130 VGND_n50 VGND_t303 17.2205
R4131 VGND_n579 VGND_t52 17.2036
R4132 VGND_n488 VGND_n487 17.0005
R4133 VGND_n543 VGND_n488 17.0005
R4134 VGND_n488 VGND_n481 17.0005
R4135 VGND_n488 VGND_n483 17.0005
R4136 VGND_n480 VGND_t383 17.0005
R4137 VGND_n488 VGND_n484 17.0005
R4138 VGND_n488 VGND_n485 17.0005
R4139 VGND_n625 VGND_n624 17.0005
R4140 VGND_n624 VGND_n422 17.0005
R4141 VGND_n624 VGND_n623 17.0005
R4142 VGND_n624 VGND_n423 17.0005
R4143 VGND_n624 VGND_n620 17.0005
R4144 VGND_n624 VGND_n424 17.0005
R4145 VGND_n624 VGND_n619 17.0005
R4146 VGND_n624 VGND_n425 17.0005
R4147 VGND_n624 VGND_n426 17.0005
R4148 VGND_n624 VGND_n616 17.0005
R4149 VGND_n624 VGND_n427 17.0005
R4150 VGND_n624 VGND_n615 17.0005
R4151 VGND_n624 VGND_n428 17.0005
R4152 VGND_n624 VGND_n614 17.0005
R4153 VGND_n624 VGND_n430 17.0005
R4154 VGND_n624 VGND_n613 17.0005
R4155 VGND_n624 VGND_n431 17.0005
R4156 VGND_n624 VGND_n609 17.0005
R4157 VGND_n624 VGND_n432 17.0005
R4158 VGND_n624 VGND_n608 17.0005
R4159 VGND_n624 VGND_n433 17.0005
R4160 VGND_n624 VGND_n605 17.0005
R4161 VGND_n624 VGND_n434 17.0005
R4162 VGND_n624 VGND_n604 17.0005
R4163 VGND_n624 VGND_n435 17.0005
R4164 VGND_n624 VGND_n601 17.0005
R4165 VGND_n624 VGND_n436 17.0005
R4166 VGND_n624 VGND_n600 17.0005
R4167 VGND_n624 VGND_n437 17.0005
R4168 VGND_n624 VGND_n597 17.0005
R4169 VGND_n624 VGND_n438 17.0005
R4170 VGND_n624 VGND_n596 17.0005
R4171 VGND_n624 VGND_n439 17.0005
R4172 VGND_n624 VGND_n440 17.0005
R4173 VGND_n624 VGND_n593 17.0005
R4174 VGND_n624 VGND_n441 17.0005
R4175 VGND_n624 VGND_n592 17.0005
R4176 VGND_n624 VGND_n443 17.0005
R4177 VGND_n624 VGND_n591 17.0005
R4178 VGND_n624 VGND_n444 17.0005
R4179 VGND_n624 VGND_n590 17.0005
R4180 VGND_n624 VGND_n445 17.0005
R4181 VGND_n624 VGND_n586 17.0005
R4182 VGND_n624 VGND_n446 17.0005
R4183 VGND_n624 VGND_n585 17.0005
R4184 VGND_n624 VGND_n447 17.0005
R4185 VGND_n624 VGND_n582 17.0005
R4186 VGND_n624 VGND_n448 17.0005
R4187 VGND_n624 VGND_n581 17.0005
R4188 VGND_n624 VGND_n449 17.0005
R4189 VGND_n624 VGND_n578 17.0005
R4190 VGND_n624 VGND_n450 17.0005
R4191 VGND_n624 VGND_n577 17.0005
R4192 VGND_n624 VGND_n451 17.0005
R4193 VGND_n624 VGND_n576 17.0005
R4194 VGND_n624 VGND_n453 17.0005
R4195 VGND_n624 VGND_n575 17.0005
R4196 VGND_n624 VGND_n454 17.0005
R4197 VGND_n624 VGND_n574 17.0005
R4198 VGND_n624 VGND_n457 17.0005
R4199 VGND_n624 VGND_n459 17.0005
R4200 VGND_n624 VGND_n573 17.0005
R4201 VGND_n462 VGND_n461 17.0005
R4202 VGND_n462 VGND_n460 17.0005
R4203 VGND_n568 VGND_n567 17.0005
R4204 VGND_n568 VGND_n467 17.0005
R4205 VGND_n569 VGND_n568 17.0005
R4206 VGND_n568 VGND_n566 17.0005
R4207 VGND_n568 VGND_n468 17.0005
R4208 VGND_n568 VGND_n470 17.0005
R4209 VGND_n562 VGND_n561 17.0005
R4210 VGND_n562 VGND_n473 17.0005
R4211 VGND_n562 VGND_n560 17.0005
R4212 VGND_n562 VGND_n474 17.0005
R4213 VGND_n562 VGND_n559 17.0005
R4214 VGND_n562 VGND_n556 17.0005
R4215 VGND_n562 VGND_n475 17.0005
R4216 VGND_n562 VGND_n555 17.0005
R4217 VGND_n562 VGND_n476 17.0005
R4218 VGND_n562 VGND_n552 17.0005
R4219 VGND_n562 VGND_n477 17.0005
R4220 VGND_n562 VGND_n549 17.0005
R4221 VGND_n562 VGND_n548 17.0005
R4222 VGND_n562 VGND_n478 17.0005
R4223 VGND_n488 VGND_n486 17.0005
R4224 VGND_n488 VGND_n482 17.0005
R4225 VGND_n494 VGND_n493 17.0005
R4226 VGND_n494 VGND_n492 17.0005
R4227 VGND_n537 VGND_n536 17.0005
R4228 VGND_n537 VGND_n497 17.0005
R4229 VGND_n538 VGND_n537 17.0005
R4230 VGND_n537 VGND_n535 17.0005
R4231 VGND_n537 VGND_n498 17.0005
R4232 VGND_n537 VGND_n500 17.0005
R4233 VGND_n505 VGND_n504 17.0005
R4234 VGND_n505 VGND_n503 17.0005
R4235 VGND_n530 VGND_n529 17.0005
R4236 VGND_n530 VGND_n508 17.0005
R4237 VGND_n531 VGND_n530 17.0005
R4238 VGND_n530 VGND_n528 17.0005
R4239 VGND_n530 VGND_n509 17.0005
R4240 VGND_n530 VGND_n511 17.0005
R4241 VGND_n524 VGND_n523 17.0005
R4242 VGND_n524 VGND_n514 17.0005
R4243 VGND_n524 VGND_n522 17.0005
R4244 VGND_n524 VGND_n515 17.0005
R4245 VGND_n524 VGND_n521 17.0005
R4246 VGND_n524 VGND_n517 17.0005
R4247 VGND_n524 VGND_n520 17.0005
R4248 VGND_n524 VGND_n518 17.0005
R4249 VGND_n524 VGND_n519 17.0005
R4250 VGND_n512 VGND_t370 17.0005
R4251 VGND_n502 VGND_t373 17.0005
R4252 VGND_n501 VGND_t375 17.0005
R4253 VGND_n491 VGND_t378 17.0005
R4254 VGND_n489 VGND_t380 17.0005
R4255 VGND_n718 VGND_n717 17.0005
R4256 VGND_n225 VGND_n224 17.0005
R4257 VGND_n225 VGND_n11 17.0005
R4258 VGND_n225 VGND_n221 17.0005
R4259 VGND_n225 VGND_n12 17.0005
R4260 VGND_n225 VGND_n13 17.0005
R4261 VGND_n225 VGND_n220 17.0005
R4262 VGND_n225 VGND_n14 17.0005
R4263 VGND_n225 VGND_n15 17.0005
R4264 VGND_n225 VGND_n215 17.0005
R4265 VGND_n225 VGND_n16 17.0005
R4266 VGND_n225 VGND_n209 17.0005
R4267 VGND_n225 VGND_n17 17.0005
R4268 VGND_n225 VGND_n204 17.0005
R4269 VGND_n225 VGND_n203 17.0005
R4270 VGND_n225 VGND_n19 17.0005
R4271 VGND_n225 VGND_n201 17.0005
R4272 VGND_n225 VGND_n200 17.0005
R4273 VGND_n225 VGND_n22 17.0005
R4274 VGND_n225 VGND_n197 17.0005
R4275 VGND_n225 VGND_n25 17.0005
R4276 VGND_n225 VGND_n191 17.0005
R4277 VGND_n225 VGND_n27 17.0005
R4278 VGND_n225 VGND_n29 17.0005
R4279 VGND_n225 VGND_n187 17.0005
R4280 VGND_n225 VGND_n32 17.0005
R4281 VGND_n225 VGND_n186 17.0005
R4282 VGND_n225 VGND_n35 17.0005
R4283 VGND_n225 VGND_n37 17.0005
R4284 VGND_n225 VGND_n185 17.0005
R4285 VGND_n225 VGND_n38 17.0005
R4286 VGND_n225 VGND_n181 17.0005
R4287 VGND_n225 VGND_n39 17.0005
R4288 VGND_n225 VGND_n178 17.0005
R4289 VGND_n225 VGND_n177 17.0005
R4290 VGND_n225 VGND_n41 17.0005
R4291 VGND_n225 VGND_n43 17.0005
R4292 VGND_n225 VGND_n174 17.0005
R4293 VGND_n225 VGND_n173 17.0005
R4294 VGND_n225 VGND_n44 17.0005
R4295 VGND_n225 VGND_n166 17.0005
R4296 VGND_n225 VGND_n165 17.0005
R4297 VGND_n225 VGND_n47 17.0005
R4298 VGND_n225 VGND_n163 17.0005
R4299 VGND_n225 VGND_n49 17.0005
R4300 VGND_n225 VGND_n162 17.0005
R4301 VGND_n225 VGND_n54 17.0005
R4302 VGND_n225 VGND_n155 17.0005
R4303 VGND_n225 VGND_n62 17.0005
R4304 VGND_n225 VGND_n151 17.0005
R4305 VGND_n225 VGND_n63 17.0005
R4306 VGND_n225 VGND_n64 17.0005
R4307 VGND_n225 VGND_n148 17.0005
R4308 VGND_n225 VGND_n145 17.0005
R4309 VGND_n225 VGND_n70 17.0005
R4310 VGND_n225 VGND_n71 17.0005
R4311 VGND_n225 VGND_n139 17.0005
R4312 VGND_n225 VGND_n72 17.0005
R4313 VGND_n225 VGND_n73 17.0005
R4314 VGND_n225 VGND_n138 17.0005
R4315 VGND_n225 VGND_n74 17.0005
R4316 VGND_n225 VGND_n131 17.0005
R4317 VGND_n225 VGND_n122 17.0005
R4318 VGND_n225 VGND_n76 17.0005
R4319 VGND_n225 VGND_n119 17.0005
R4320 VGND_n225 VGND_n85 17.0005
R4321 VGND_n225 VGND_n118 17.0005
R4322 VGND_n225 VGND_n86 17.0005
R4323 VGND_n225 VGND_n113 17.0005
R4324 VGND_n225 VGND_n87 17.0005
R4325 VGND_n225 VGND_n102 17.0005
R4326 VGND_n225 VGND_n88 17.0005
R4327 VGND_n225 VGND_n98 17.0005
R4328 VGND_n225 VGND_n91 17.0005
R4329 VGND_n226 VGND_n225 17.0005
R4330 VGND_n92 VGND_t355 17.0005
R4331 VGND_n95 VGND_t358 17.0005
R4332 VGND_n100 VGND_t360 17.0005
R4333 VGND_n104 VGND_t327 17.0005
R4334 VGND_n114 VGND_t365 17.0005
R4335 VGND_n110 VGND_t363 17.0005
R4336 VGND_n116 VGND_t330 17.0005
R4337 VGND_n83 VGND_t332 17.0005
R4338 VGND_n120 VGND_t368 17.0005
R4339 VGND_n127 VGND_t335 17.0005
R4340 VGND_n125 VGND_t337 17.0005
R4341 VGND_n134 VGND_t340 17.0005
R4342 VGND_n140 VGND_t342 17.0005
R4343 VGND_n68 VGND_t345 17.0005
R4344 VGND_n59 VGND_t347 17.0005
R4345 VGND_n159 VGND_t350 17.0005
R4346 VGND_n157 VGND_t352 17.0005
R4347 VGND_n546 VGND_t385 17.0005
R4348 VGND_n471 VGND_t388 17.0005
R4349 VGND_n464 VGND_t391 17.0005
R4350 VGND_n463 VGND_t393 17.0005
R4351 VGND_n627 VGND_n626 15.8946
R4352 VGND_n648 VGND_n8 15.5008
R4353 VGND_n480 VGND_t536 15.3099
R4354 VGND_n502 VGND_t540 15.3099
R4355 VGND_n491 VGND_t538 15.3099
R4356 VGND_n95 VGND_t546 15.3099
R4357 VGND_n110 VGND_t544 15.3099
R4358 VGND_n116 VGND_t557 15.3099
R4359 VGND_n120 VGND_t542 15.3099
R4360 VGND_n127 VGND_t555 15.3099
R4361 VGND_n134 VGND_t553 15.3099
R4362 VGND_n68 VGND_t551 15.3099
R4363 VGND_n159 VGND_t549 15.3099
R4364 VGND_n464 VGND_t533 15.3099
R4365 VGND_n518 VGND_n357 15.291
R4366 VGND_n521 VGND_n359 15.291
R4367 VGND_n500 VGND_n367 15.291
R4368 VGND_n497 VGND_n369 15.291
R4369 VGND_n476 VGND_n379 15.291
R4370 VGND_n470 VGND_n385 15.291
R4371 VGND_n467 VGND_n387 15.291
R4372 VGND_t392 VGND_n389 15.291
R4373 VGND_n577 VGND_n393 15.291
R4374 VGND_n449 VGND_n395 15.291
R4375 VGND_n590 VGND_n399 15.291
R4376 VGND_n596 VGND_n405 15.291
R4377 VGND_n437 VGND_n407 15.291
R4378 VGND_n608 VGND_n413 15.291
R4379 VGND_n431 VGND_n415 15.291
R4380 VGND_n425 VGND_n419 15.291
R4381 VGND_n512 VGND_t541 15.2696
R4382 VGND_n501 VGND_t539 15.2696
R4383 VGND_n489 VGND_t537 15.2696
R4384 VGND_n92 VGND_t547 15.2696
R4385 VGND_n100 VGND_t545 15.2696
R4386 VGND_n104 VGND_t558 15.2696
R4387 VGND_n114 VGND_t543 15.2696
R4388 VGND_n83 VGND_t556 15.2696
R4389 VGND_n125 VGND_t554 15.2696
R4390 VGND_n140 VGND_t552 15.2696
R4391 VGND_n59 VGND_t550 15.2696
R4392 VGND_n471 VGND_t534 15.2696
R4393 VGND_n157 VGND_t548 15.2596
R4394 VGND_n546 VGND_t535 15.2596
R4395 VGND_n463 VGND_t532 15.2596
R4396 VGND_t287 VGND_n351 14.5265
R4397 VGND_t431 VGND_n360 14.5265
R4398 VGND_n476 VGND_t121 14.5265
R4399 VGND_t5 VGND_n323 14.5265
R4400 VGND_t314 VGND_n396 14.5265
R4401 VGND_t39 VGND_n311 14.5265
R4402 VGND_t55 VGND_n408 14.5265
R4403 VGND_t44 VGND_n305 14.5265
R4404 VGND_t266 VGND_n416 14.5265
R4405 VGND_t35 VGND_n299 14.5265
R4406 VGND_t510 VGND_n420 14.5265
R4407 VGND_n544 VGND_n0 13.9211
R4408 VGND_n136 VGND_n0 13.6395
R4409 VGND_n187 VGND_t271 12.8576
R4410 VGND_t399 VGND_n29 12.8576
R4411 VGND_t23 VGND_n27 12.8576
R4412 VGND_n191 VGND_t273 12.8576
R4413 VGND_t403 VGND_n25 12.8576
R4414 VGND_n197 VGND_t514 12.8576
R4415 VGND_t318 VGND_t267 12.8576
R4416 VGND_t282 VGND_n325 11.4684
R4417 VGND_n722 VGND_n721 11.2018
R4418 VGND_n709 VGND_n265 10.5429
R4419 VGND_t379 VGND_n372 9.93934
R4420 VGND_n523 VGND_n361 9.55344
R4421 VGND_n528 VGND_n363 9.55344
R4422 VGND_n503 VGND_n365 9.55344
R4423 VGND_n482 VGND_n371 9.55344
R4424 VGND_n487 VGND_n373 9.55344
R4425 VGND_n486 VGND_n375 9.55344
R4426 VGND_n477 VGND_n377 9.55344
R4427 VGND_n559 VGND_n381 9.55344
R4428 VGND_n473 VGND_n383 9.55344
R4429 VGND_n573 VGND_n330 9.55344
R4430 VGND_n454 VGND_n390 9.55344
R4431 VGND_n576 VGND_n327 9.55344
R4432 VGND_n447 VGND_n321 9.55344
R4433 VGND_n586 VGND_n319 9.55344
R4434 VGND_n440 VGND_n403 9.55344
R4435 VGND_n435 VGND_n409 9.55344
R4436 VGND_n605 VGND_n411 9.55344
R4437 VGND_n428 VGND_n303 9.55344
R4438 VGND_n616 VGND_n301 9.55344
R4439 VGND_n423 VGND_n297 9.55344
R4440 VGND_n625 VGND_n295 9.55344
R4441 VGND_n721 VGND_n1 9.03934
R4442 VGND_n721 VGND_n720 9.03934
R4443 VGND_n69 VGND_t527 8.80544
R4444 VGND_n61 VGND_t525 8.7673
R4445 VGND_n194 VGND_t404 8.7673
R4446 VGND_n189 VGND_t24 8.7673
R4447 VGND_n150 VGND_t74 8.76678
R4448 VGND_n207 VGND_t419 8.76678
R4449 VGND_n172 VGND_t423 8.76678
R4450 VGND_n164 VGND_t115 8.76678
R4451 VGND_n167 VGND_t22 8.7663
R4452 VGND_n30 VGND_t400 8.7663
R4453 VGND_n472 VGND_t72 8.7663
R4454 VGND_n594 VGND_t26 8.7663
R4455 VGND_n617 VGND_t321 8.7663
R4456 VGND_n135 VGND_t277 8.76154
R4457 VGND_n124 VGND_t67 8.75731
R4458 VGND_n160 VGND_t43 8.75731
R4459 VGND_n42 VGND_t513 8.75731
R4460 VGND_n146 VGND_t69 8.75631
R4461 VGND_n149 VGND_t279 8.75631
R4462 VGND_n51 VGND_t495 8.75631
R4463 VGND_n171 VGND_t529 8.75631
R4464 VGND_n176 VGND_t83 8.75631
R4465 VGND_n182 VGND_t455 8.75631
R4466 VGND_n36 VGND_t89 8.75631
R4467 VGND_n553 VGND_t122 8.75631
R4468 VGND_n557 VGND_t427 8.75631
R4469 VGND_n455 VGND_t111 8.75631
R4470 VGND_n183 VGND_t402 8.71077
R4471 VGND_n179 VGND_t20 8.71077
R4472 VGND_n225 VGND_n94 8.50225
R4473 VGND_n572 VGND_n571 8.501
R4474 VGND_n570 VGND_n465 8.501
R4475 VGND_n564 VGND_n469 8.501
R4476 VGND_n547 VGND_n479 8.501
R4477 VGND_n540 VGND_n490 8.501
R4478 VGND_n539 VGND_n495 8.501
R4479 VGND_n533 VGND_n499 8.501
R4480 VGND_n532 VGND_n506 8.501
R4481 VGND_n526 VGND_n510 8.501
R4482 VGND_n709 VGND_n266 8.501
R4483 VGND_n717 VGND_n243 8.501
R4484 VGND_n709 VGND_n268 8.501
R4485 VGND_n717 VGND_n240 8.501
R4486 VGND_n709 VGND_n263 8.501
R4487 VGND_n717 VGND_n245 8.501
R4488 VGND_n709 VGND_n269 8.501
R4489 VGND_n717 VGND_n246 8.501
R4490 VGND_n709 VGND_n262 8.501
R4491 VGND_n717 VGND_n238 8.501
R4492 VGND_n709 VGND_n261 8.501
R4493 VGND_n717 VGND_n237 8.501
R4494 VGND_n709 VGND_n260 8.501
R4495 VGND_n709 VGND_n271 8.501
R4496 VGND_n717 VGND_n235 8.501
R4497 VGND_n709 VGND_n272 8.501
R4498 VGND_n717 VGND_n249 8.501
R4499 VGND_n709 VGND_n273 8.501
R4500 VGND_n717 VGND_n250 8.501
R4501 VGND_n709 VGND_n257 8.501
R4502 VGND_n717 VGND_n233 8.501
R4503 VGND_n709 VGND_n256 8.501
R4504 VGND_n717 VGND_n232 8.501
R4505 VGND_n709 VGND_n255 8.501
R4506 VGND_n717 VGND_n231 8.501
R4507 VGND_n709 VGND_n254 8.501
R4508 VGND_n717 VGND_n230 8.501
R4509 VGND_n710 VGND_n709 8.501
R4510 VGND_n717 VGND_n716 8.501
R4511 VGND_n709 VGND_n229 8.501
R4512 VGND_n649 VGND_n648 8.501
R4513 VGND_n648 VGND_n630 8.501
R4514 VGND_n648 VGND_n632 8.501
R4515 VGND_n648 VGND_n634 8.501
R4516 VGND_n648 VGND_n636 8.501
R4517 VGND_n545 VGND_n488 8.5005
R4518 VGND_n628 VGND_n296 8.5005
R4519 VGND_n628 VGND_n421 8.5005
R4520 VGND_n628 VGND_n298 8.5005
R4521 VGND_n628 VGND_n420 8.5005
R4522 VGND_n628 VGND_n299 8.5005
R4523 VGND_n628 VGND_n419 8.5005
R4524 VGND_n628 VGND_n300 8.5005
R4525 VGND_n628 VGND_n418 8.5005
R4526 VGND_n628 VGND_n302 8.5005
R4527 VGND_n628 VGND_n417 8.5005
R4528 VGND_n628 VGND_n304 8.5005
R4529 VGND_n628 VGND_n416 8.5005
R4530 VGND_n628 VGND_n305 8.5005
R4531 VGND_n628 VGND_n415 8.5005
R4532 VGND_n628 VGND_n306 8.5005
R4533 VGND_n628 VGND_n414 8.5005
R4534 VGND_n628 VGND_n307 8.5005
R4535 VGND_n628 VGND_n413 8.5005
R4536 VGND_n628 VGND_n308 8.5005
R4537 VGND_n628 VGND_n412 8.5005
R4538 VGND_n628 VGND_n309 8.5005
R4539 VGND_n628 VGND_n410 8.5005
R4540 VGND_n628 VGND_n310 8.5005
R4541 VGND_n628 VGND_n408 8.5005
R4542 VGND_n628 VGND_n311 8.5005
R4543 VGND_n628 VGND_n407 8.5005
R4544 VGND_n628 VGND_n312 8.5005
R4545 VGND_n628 VGND_n406 8.5005
R4546 VGND_n628 VGND_n313 8.5005
R4547 VGND_n628 VGND_n405 8.5005
R4548 VGND_n628 VGND_n314 8.5005
R4549 VGND_n628 VGND_n404 8.5005
R4550 VGND_n628 VGND_n315 8.5005
R4551 VGND_n628 VGND_n402 8.5005
R4552 VGND_n628 VGND_n316 8.5005
R4553 VGND_n628 VGND_n400 8.5005
R4554 VGND_n628 VGND_n317 8.5005
R4555 VGND_n628 VGND_n399 8.5005
R4556 VGND_n628 VGND_n318 8.5005
R4557 VGND_n628 VGND_n398 8.5005
R4558 VGND_n628 VGND_n320 8.5005
R4559 VGND_n628 VGND_n397 8.5005
R4560 VGND_n628 VGND_n322 8.5005
R4561 VGND_n628 VGND_n396 8.5005
R4562 VGND_n628 VGND_n323 8.5005
R4563 VGND_n628 VGND_n395 8.5005
R4564 VGND_n628 VGND_n324 8.5005
R4565 VGND_n628 VGND_n394 8.5005
R4566 VGND_n628 VGND_n325 8.5005
R4567 VGND_n628 VGND_n393 8.5005
R4568 VGND_n628 VGND_n326 8.5005
R4569 VGND_n628 VGND_n392 8.5005
R4570 VGND_n628 VGND_n328 8.5005
R4571 VGND_n628 VGND_n391 8.5005
R4572 VGND_n628 VGND_n329 8.5005
R4573 VGND_n628 VGND_n389 8.5005
R4574 VGND_n628 VGND_n331 8.5005
R4575 VGND_n628 VGND_n388 8.5005
R4576 VGND_n628 VGND_n332 8.5005
R4577 VGND_n628 VGND_n387 8.5005
R4578 VGND_n628 VGND_n333 8.5005
R4579 VGND_n628 VGND_n386 8.5005
R4580 VGND_n628 VGND_n334 8.5005
R4581 VGND_n628 VGND_n385 8.5005
R4582 VGND_n628 VGND_n335 8.5005
R4583 VGND_n628 VGND_n384 8.5005
R4584 VGND_n628 VGND_n336 8.5005
R4585 VGND_n628 VGND_n382 8.5005
R4586 VGND_n628 VGND_n337 8.5005
R4587 VGND_n628 VGND_n380 8.5005
R4588 VGND_n628 VGND_n338 8.5005
R4589 VGND_n628 VGND_n379 8.5005
R4590 VGND_n628 VGND_n339 8.5005
R4591 VGND_n628 VGND_n378 8.5005
R4592 VGND_n628 VGND_n340 8.5005
R4593 VGND_n628 VGND_n376 8.5005
R4594 VGND_n628 VGND_n341 8.5005
R4595 VGND_n628 VGND_n374 8.5005
R4596 VGND_n628 VGND_n342 8.5005
R4597 VGND_n628 VGND_n372 8.5005
R4598 VGND_n628 VGND_n343 8.5005
R4599 VGND_n628 VGND_n370 8.5005
R4600 VGND_n628 VGND_n344 8.5005
R4601 VGND_n628 VGND_n369 8.5005
R4602 VGND_n628 VGND_n345 8.5005
R4603 VGND_n628 VGND_n368 8.5005
R4604 VGND_n628 VGND_n346 8.5005
R4605 VGND_n628 VGND_n367 8.5005
R4606 VGND_n628 VGND_n347 8.5005
R4607 VGND_n628 VGND_n366 8.5005
R4608 VGND_n628 VGND_n348 8.5005
R4609 VGND_n628 VGND_n364 8.5005
R4610 VGND_n628 VGND_n349 8.5005
R4611 VGND_n628 VGND_n362 8.5005
R4612 VGND_n628 VGND_n350 8.5005
R4613 VGND_n628 VGND_n360 8.5005
R4614 VGND_n628 VGND_n351 8.5005
R4615 VGND_n628 VGND_n359 8.5005
R4616 VGND_n628 VGND_n352 8.5005
R4617 VGND_n628 VGND_n358 8.5005
R4618 VGND_n628 VGND_n353 8.5005
R4619 VGND_n628 VGND_n357 8.5005
R4620 VGND_n628 VGND_n354 8.5005
R4621 VGND_n628 VGND_n356 8.5005
R4622 VGND_n654 VGND_n653 8.5005
R4623 VGND_n656 VGND_n655 8.5005
R4624 VGND_n659 VGND_n658 8.5005
R4625 VGND_n661 VGND_n660 8.5005
R4626 VGND_n663 VGND_n662 8.5005
R4627 VGND_n666 VGND_n665 8.5005
R4628 VGND_n668 VGND_n667 8.5005
R4629 VGND_n670 VGND_n669 8.5005
R4630 VGND_n672 VGND_n671 8.5005
R4631 VGND_n674 VGND_n673 8.5005
R4632 VGND_n677 VGND_n676 8.5005
R4633 VGND_n679 VGND_n678 8.5005
R4634 VGND_n681 VGND_n680 8.5005
R4635 VGND_n683 VGND_n682 8.5005
R4636 VGND_n685 VGND_n684 8.5005
R4637 VGND_n687 VGND_n686 8.5005
R4638 VGND_n691 VGND_n690 8.5005
R4639 VGND_n693 VGND_n692 8.5005
R4640 VGND_n695 VGND_n694 8.5005
R4641 VGND_n698 VGND_n697 8.5005
R4642 VGND_n700 VGND_n699 8.5005
R4643 VGND_n702 VGND_n701 8.5005
R4644 VGND_n704 VGND_n703 8.5005
R4645 VGND_n705 VGND_n274 8.5005
R4646 VGND_n288 VGND_n287 8.5005
R4647 VGND_n286 VGND_n285 8.5005
R4648 VGND_n284 VGND_n283 8.5005
R4649 VGND_n282 VGND_n281 8.5005
R4650 VGND_n280 VGND_n279 8.5005
R4651 VGND_n278 VGND_n277 8.5005
R4652 VGND_n276 VGND_n275 8.5005
R4653 VGND_n253 VGND_n252 8.5005
R4654 VGND_n712 VGND_n711 8.5005
R4655 VGND_n713 VGND_n251 8.5005
R4656 VGND_n715 VGND_n714 8.5005
R4657 VGND_n650 VGND_n7 8.5005
R4658 VGND_n631 VGND_n7 8.5005
R4659 VGND_n642 VGND_n7 8.5005
R4660 VGND_n640 VGND_n7 8.5005
R4661 VGND_n638 VGND_n7 8.5005
R4662 VGND_n225 VGND_n161 8.5005
R4663 VGND_n225 VGND_n137 8.5005
R4664 VGND_n541 VGND_n488 8.47111
R4665 VGND_n624 VGND_n456 8.47111
R4666 VGND_n568 VGND_n565 8.47111
R4667 VGND_n562 VGND_n554 8.47111
R4668 VGND_n562 VGND_n551 8.47111
R4669 VGND_n537 VGND_n534 8.47111
R4670 VGND_n530 VGND_n527 8.47111
R4671 VGND_n525 VGND_n524 8.47111
R4672 VGND_n225 VGND_n208 8.47111
R4673 VGND_n225 VGND_n206 8.47111
R4674 VGND_n225 VGND_n196 8.47111
R4675 VGND_n225 VGND_n193 8.47111
R4676 VGND_n225 VGND_n190 8.47111
R4677 VGND_n225 VGND_n28 8.47111
R4678 VGND_n225 VGND_n31 8.47111
R4679 VGND_n225 VGND_n34 8.47111
R4680 VGND_n225 VGND_n184 8.47111
R4681 VGND_n225 VGND_n180 8.47111
R4682 VGND_n225 VGND_n40 8.47111
R4683 VGND_n225 VGND_n45 8.47111
R4684 VGND_n225 VGND_n48 8.47111
R4685 VGND_n225 VGND_n75 8.47111
R4686 VGND_n225 VGND_n77 8.47111
R4687 VGND_n225 VGND_n81 8.47111
R4688 VGND_n225 VGND_n112 8.47111
R4689 VGND_n225 VGND_n106 8.47111
R4690 VGND_n225 VGND_n90 8.47111
R4691 VGND_t369 VGND_n349 8.41029
R4692 VGND_t511 VGND_n392 8.41029
R4693 VGND_n648 VGND_n635 7.66937
R4694 VGND_t515 VGND_n401 7.25986
R4695 VGND_n522 VGND_t431 6.88123
R4696 VGND_t426 VGND_n338 6.88123
R4697 VGND_n448 VGND_t314 6.88123
R4698 VGND_n446 VGND_t58 6.88123
R4699 VGND_n436 VGND_t55 6.88123
R4700 VGND_n434 VGND_t27 6.88123
R4701 VGND_n430 VGND_t266 6.88123
R4702 VGND_n424 VGND_t510 6.88123
R4703 VGND_n422 VGND_t289 6.88123
R4704 VGND_n709 VGND_n267 5.66778
R4705 VGND_n717 VGND_n241 5.66778
R4706 VGND_n709 VGND_n264 5.66778
R4707 VGND_n717 VGND_n244 5.66778
R4708 VGND_n709 VGND_n270 5.66778
R4709 VGND_n717 VGND_n239 5.66778
R4710 VGND_n717 VGND_n247 5.66778
R4711 VGND_n717 VGND_n236 5.66778
R4712 VGND_n709 VGND_n258 5.66778
R4713 VGND_n717 VGND_n248 5.66778
R4714 VGND_n709 VGND_n708 5.66778
R4715 VGND_n717 VGND_n234 5.66778
R4716 VGND_n648 VGND_n647 5.66778
R4717 VGND_n648 VGND_n633 5.66778
R4718 VGND_n648 VGND_n6 5.66778
R4719 VGND_n646 VGND_n7 5.66717
R4720 VGND_n637 VGND_n7 5.66717
R4721 VGND_n718 VGND_n7 5.66717
R4722 VGND_n225 VGND_n56 5.64868
R4723 VGND_n225 VGND_n89 5.64537
R4724 VGND_n225 VGND_n129 5.6447
R4725 VGND_n624 VGND_n429 5.61485
R4726 VGND_n563 VGND_n562 5.61485
R4727 VGND_n562 VGND_n558 5.61485
R4728 VGND_n225 VGND_n219 5.61485
R4729 VGND_n225 VGND_n20 5.61485
R4730 VGND_n225 VGND_n23 5.61485
R4731 VGND_n225 VGND_n169 5.61485
R4732 VGND_n225 VGND_n52 5.61485
R4733 VGND_n225 VGND_n143 5.61485
R4734 VGND_n635 VGND_n7 5.11388
R4735 VGND_n628 VGND_n242 5.06086
R4736 VGND_n163 VGND_t494 4.28621
R4737 VGND_n174 VGND_t528 4.28621
R4738 VGND_n181 VGND_t454 4.28621
R4739 VGND_t88 VGND_n35 4.28621
R4740 VGND_n709 VGND_n259 4.25113
R4741 VGND_n657 VGND_n294 4.23866
R4742 VGND_n664 VGND_n293 4.23866
R4743 VGND_n675 VGND_n292 4.23866
R4744 VGND_n688 VGND_n291 4.23866
R4745 VGND_n689 VGND_n290 4.23866
R4746 VGND_n696 VGND_n289 4.23866
R4747 VGND_n707 VGND_n706 4.23866
R4748 VGND_n651 VGND_n650 4.23866
R4749 VGND_n631 VGND_n629 4.23866
R4750 VGND_n643 VGND_n642 4.23866
R4751 VGND_n641 VGND_n640 4.23866
R4752 VGND_n639 VGND_n638 4.23866
R4753 VGND_n719 VGND_n718 4.23866
R4754 VGND_n225 VGND_n58 4.20468
R4755 VGND_n225 VGND_n66 4.20376
R4756 VGND_n624 VGND_n612 4.17719
R4757 VGND_n624 VGND_n607 4.17719
R4758 VGND_n624 VGND_n603 4.17719
R4759 VGND_n624 VGND_n599 4.17719
R4760 VGND_n624 VGND_n595 4.17719
R4761 VGND_n624 VGND_n589 4.17719
R4762 VGND_n624 VGND_n584 4.17719
R4763 VGND_n624 VGND_n452 4.17719
R4764 VGND_n225 VGND_n214 4.17719
R4765 VGND_t60 VGND_n353 3.82313
R4766 VGND_t263 VGND_n397 3.82313
R4767 VGND_t301 VGND_n317 3.82313
R4768 VGND_t509 VGND_n313 3.82313
R4769 VGND_t46 VGND_n410 3.82313
R4770 VGND_t508 VGND_n307 3.82313
R4771 VGND_t90 VGND_n421 3.82313
R4772 VGND_n225 VGND_n223 3.36058
R4773 VGND_n624 VGND_n442 3.30723
R4774 VGND_n624 VGND_n580 3.30723
R4775 VGND_n520 VGND_n353 3.0586
R4776 VGND_n515 VGND_n351 3.0586
R4777 VGND_n498 VGND_n346 3.0586
R4778 VGND_n536 VGND_n344 3.0586
R4779 VGND_t384 VGND_n340 3.0586
R4780 VGND_n555 VGND_n338 3.0586
R4781 VGND_n468 VGND_n334 3.0586
R4782 VGND_n567 VGND_n332 3.0586
R4783 VGND_n450 VGND_n325 3.0586
R4784 VGND_n581 VGND_n323 3.0586
R4785 VGND_n444 VGND_n317 3.0586
R4786 VGND_n438 VGND_n313 3.0586
R4787 VGND_n600 VGND_n311 3.0586
R4788 VGND_n432 VGND_n307 3.0586
R4789 VGND_n613 VGND_n305 3.0586
R4790 VGND_n619 VGND_n299 3.0586
R4791 VGND_n646 VGND_n645 2.81258
R4792 VGND_n644 VGND_n637 2.81258
R4793 VGND_n624 VGND_n622 2.76523
R4794 VGND_n524 VGND_n516 2.75431
R4795 VGND_n624 VGND_n618 2.72142
R4796 VGND_n474 VGND_t71 2.29408
R4797 VGND_n560 VGND_t281 2.29408
R4798 VGND_n592 VGND_t515 2.29408
R4799 VGND_n441 VGND_t25 2.29408
R4800 VGND_n615 VGND_t320 2.29408
R4801 VGND_n427 VGND_t428 2.29408
R4802 VGND_n717 VGND_n242 1.82142
R4803 VGND_n628 VGND_n295 1.00383
R4804 VGND_n628 VGND_n297 1.00383
R4805 VGND_n628 VGND_n301 1.00383
R4806 VGND_n628 VGND_n303 1.00383
R4807 VGND_n628 VGND_n411 1.00383
R4808 VGND_n628 VGND_n409 1.00383
R4809 VGND_n628 VGND_n403 1.00383
R4810 VGND_n628 VGND_n401 1.00383
R4811 VGND_n628 VGND_n319 1.00383
R4812 VGND_n628 VGND_n321 1.00383
R4813 VGND_n628 VGND_n327 1.00383
R4814 VGND_n628 VGND_n390 1.00383
R4815 VGND_n628 VGND_n330 1.00383
R4816 VGND_n628 VGND_n383 1.00383
R4817 VGND_n628 VGND_n381 1.00383
R4818 VGND_n628 VGND_n377 1.00383
R4819 VGND_n628 VGND_n375 1.00383
R4820 VGND_n628 VGND_n373 1.00383
R4821 VGND_n628 VGND_n371 1.00383
R4822 VGND_n628 VGND_n365 1.00383
R4823 VGND_n628 VGND_n363 1.00383
R4824 VGND_n628 VGND_n361 1.00383
R4825 VGND_n652 VGND_n651 0.859116
R4826 VGND_t372 VGND_n348 0.765026
R4827 VGND_n575 VGND_t110 0.765026
R4828 VGND_n720 VGND_n2 0.737101
R4829 VGND_n639 VGND_n5 0.68101
R4830 VGND_n714 VGND_n2 0.675425
R4831 VGND_n225 VGND_n10 0.649813
R4832 VGND_n225 VGND_n216 0.649813
R4833 VGND_n225 VGND_n210 0.649813
R4834 VGND_n225 VGND_n18 0.649813
R4835 VGND_n225 VGND_n21 0.649813
R4836 VGND_n225 VGND_n24 0.649813
R4837 VGND_n225 VGND_n26 0.649813
R4838 VGND_n225 VGND_n188 0.649813
R4839 VGND_n225 VGND_n175 0.649813
R4840 VGND_n225 VGND_n170 0.649813
R4841 VGND_n225 VGND_n46 0.649813
R4842 VGND_n225 VGND_n57 0.649813
R4843 VGND_n225 VGND_n153 0.649813
R4844 VGND_n225 VGND_n152 0.649813
R4845 VGND_n225 VGND_n65 0.649813
R4846 VGND_n225 VGND_n67 0.649813
R4847 VGND_n225 VGND_n144 0.649813
R4848 VGND_n225 VGND_n78 0.649813
R4849 VGND_n225 VGND_n107 0.649813
R4850 VGND_n654 VGND_n652 0.644742
R4851 VGND_n722 VGND_n0 0.64347
R4852 VGND_n5 VGND_n1 0.6432
R4853 VGND_n618 VGND_n617 0.364092
R4854 VGND_n580 VGND_n579 0.341433
R4855 VGND_n621 VGND_n618 0.337361
R4856 VGND_n635 VGND_n628 0.334062
R4857 VGND_n622 VGND_n621 0.329417
R4858 VGND_n588 VGND_n442 0.316433
R4859 VGND_n594 VGND_n442 0.305195
R4860 VGND_n516 VGND_n513 0.304367
R4861 VGND_n583 VGND_n580 0.280195
R4862 VGND_n223 VGND_n222 0.278495
R4863 VGND_n584 VGND_n583 0.25778
R4864 VGND_n589 VGND_n587 0.25778
R4865 VGND_n599 VGND_n598 0.25778
R4866 VGND_n603 VGND_n602 0.25778
R4867 VGND_n607 VGND_n606 0.25778
R4868 VGND_n612 VGND_n610 0.25778
R4869 VGND_n214 VGND_n212 0.25528
R4870 VGND_n455 VGND_n452 0.24528
R4871 VGND_n595 VGND_n594 0.23278
R4872 VGND_n564 VGND_n563 0.224236
R4873 VGND_n214 VGND_n213 0.222011
R4874 VGND_n587 VGND_n584 0.222011
R4875 VGND_n589 VGND_n588 0.222011
R4876 VGND_n598 VGND_n595 0.222011
R4877 VGND_n602 VGND_n599 0.222011
R4878 VGND_n606 VGND_n603 0.222011
R4879 VGND_n610 VGND_n607 0.222011
R4880 VGND_n612 VGND_n611 0.222011
R4881 VGND_n147 VGND_n66 0.216269
R4882 VGND_n195 VGND_n23 0.198325
R4883 VGND_n198 VGND_n20 0.198325
R4884 VGND_n611 VGND_n429 0.198325
R4885 VGND_n579 VGND_n452 0.197011
R4886 VGND_n169 VGND_n168 0.195486
R4887 VGND_n558 VGND_n557 0.193325
R4888 VGND_n219 VGND_n217 0.192075
R4889 VGND_n169 VGND_n167 0.188325
R4890 VGND_n563 VGND_n472 0.188325
R4891 VGND_n143 VGND_n141 0.178325
R4892 VGND_n52 VGND_n51 0.175486
R4893 VGND_n558 VGND_n472 0.172986
R4894 VGND_n617 VGND_n429 0.172986
R4895 VGND_n56 VGND_n55 0.171473
R4896 VGND_n526 VGND_n525 0.164539
R4897 VGND_n180 VGND_n179 0.163289
R4898 VGND_n184 VGND_n183 0.163289
R4899 VGND_n199 VGND_n23 0.162986
R4900 VGND_n202 VGND_n20 0.162986
R4901 VGND_n219 VGND_n218 0.162986
R4902 VGND_n541 VGND_n540 0.158289
R4903 VGND_n527 VGND_n526 0.158289
R4904 VGND_n534 VGND_n533 0.158289
R4905 VGND_n565 VGND_n564 0.158289
R4906 VGND_n545 VGND_n480 0.155582
R4907 VGND_n532 VGND_n502 0.155582
R4908 VGND_n539 VGND_n491 0.155582
R4909 VGND_n96 VGND_n95 0.155582
R4910 VGND_n137 VGND_n134 0.155582
R4911 VGND_n69 VGND_n68 0.155582
R4912 VGND_n161 VGND_n159 0.155582
R4913 VGND_n570 VGND_n464 0.155582
R4914 VGND_n33 VGND_n31 0.154539
R4915 VGND_n164 VGND_n48 0.150789
R4916 VGND_n172 VGND_n45 0.150789
R4917 VGND_n208 VGND_n207 0.150789
R4918 VGND_n645 VGND_n644 0.150421
R4919 VGND_n526 VGND_n512 0.149476
R4920 VGND_n533 VGND_n501 0.149476
R4921 VGND_n540 VGND_n489 0.149476
R4922 VGND_n126 VGND_n125 0.149476
R4923 VGND_n60 VGND_n59 0.149476
R4924 VGND_n564 VGND_n471 0.149476
R4925 VGND_n554 VGND_n553 0.148289
R4926 VGND_n94 VGND_n92 0.14062
R4927 VGND_n154 VGND_n58 0.139432
R4928 VGND_n525 VGND_n513 0.138289
R4929 VGND_n93 VGND_n90 0.138289
R4930 VGND_n193 VGND_n192 0.138289
R4931 VGND_n206 VGND_n205 0.138289
R4932 VGND_n101 VGND_n89 0.131399
R4933 VGND_n55 VGND_n52 0.128325
R4934 VGND_n31 VGND_n30 0.128289
R4935 VGND_n190 VGND_n189 0.128289
R4936 VGND_n196 VGND_n194 0.128289
R4937 VGND_n129 VGND_n128 0.127386
R4938 VGND_n124 VGND_n75 0.125789
R4939 VGND_n42 VGND_n40 0.125789
R4940 VGND_n176 VGND_n40 0.125789
R4941 VGND_n182 VGND_n180 0.125789
R4942 VGND_n644 VGND_n643 0.125558
R4943 VGND_n645 VGND_n629 0.125219
R4944 VGND_n112 VGND_n111 0.123289
R4945 VGND_n121 VGND_n77 0.123289
R4946 VGND_n158 VGND_n157 0.121879
R4947 VGND_n547 VGND_n546 0.121879
R4948 VGND_n571 VGND_n463 0.121879
R4949 VGND_n543 VGND_n542 0.1205
R4950 VGND_n531 VGND_n507 0.1205
R4951 VGND_n538 VGND_n496 0.1205
R4952 VGND_n98 VGND_n97 0.1205
R4953 VGND_n109 VGND_n108 0.1205
R4954 VGND_n80 VGND_n79 0.1205
R4955 VGND_n131 VGND_n130 0.1205
R4956 VGND_n142 VGND_n70 0.1205
R4957 VGND_n155 VGND_n154 0.1205
R4958 VGND_n569 VGND_n466 0.1205
R4959 VGND_n143 VGND_n142 0.120486
R4960 VGND_n106 VGND_n105 0.118289
R4961 VGND_n84 VGND_n81 0.118289
R4962 VGND_n111 VGND_n110 0.11591
R4963 VGND_n117 VGND_n116 0.11591
R4964 VGND_n121 VGND_n120 0.11591
R4965 VGND_n128 VGND_n127 0.11591
R4966 VGND_n184 VGND_n182 0.115789
R4967 VGND_n36 VGND_n34 0.115789
R4968 VGND_n456 VGND_n455 0.115789
R4969 VGND_n30 VGND_n28 0.113289
R4970 VGND_n189 VGND_n28 0.113289
R4971 VGND_n194 VGND_n193 0.113289
R4972 VGND_n550 VGND_n548 0.113
R4973 VGND_n459 VGND_n458 0.113
R4974 VGND_n101 VGND_n100 0.111366
R4975 VGND_n105 VGND_n104 0.111366
R4976 VGND_n115 VGND_n114 0.111366
R4977 VGND_n84 VGND_n83 0.111366
R4978 VGND_n141 VGND_n140 0.111366
R4979 VGND_n557 VGND_n554 0.108289
R4980 VGND_n532 VGND_n531 0.10675
R4981 VGND_n539 VGND_n538 0.10675
R4982 VGND_n98 VGND_n96 0.10675
R4983 VGND_n70 VGND_n69 0.10675
R4984 VGND_n570 VGND_n569 0.10675
R4985 VGND_n50 VGND_n48 0.105789
R4986 VGND_n168 VGND_n45 0.105789
R4987 VGND_n192 VGND_n190 0.103289
R4988 VGND_n196 VGND_n195 0.103289
R4989 VGND_n211 VGND_n208 0.103289
R4990 VGND_n641 VGND_n639 0.100356
R4991 VGND_n643 VGND_n641 0.100356
R4992 VGND_n651 VGND_n629 0.100356
R4993 VGND_n689 VGND_n688 0.100356
R4994 VGND VGND_n722 0.09545
R4995 VGND_n553 VGND_n551 0.093289
R4996 VGND_n207 VGND_n206 0.090789
R4997 VGND_n150 VGND_n64 0.0905
R4998 VGND_n146 VGND_n64 0.088
R4999 VGND_n34 VGND_n33 0.087039
R5000 VGND_n548 VGND_n547 0.08675
R5001 VGND_n571 VGND_n459 0.08675
R5002 VGND_n533 VGND_n532 0.0855
R5003 VGND_n540 VGND_n539 0.0855
R5004 VGND_n69 VGND_n66 0.0820245
R5005 VGND_n60 VGND_n58 0.0801811
R5006 VGND_n137 VGND_n133 0.078
R5007 VGND_n200 VGND_n199 0.078
R5008 VGND_n203 VGND_n202 0.078
R5009 VGND_n213 VGND_n15 0.078
R5010 VGND_n218 VGND_n13 0.078
R5011 VGND_n657 VGND_n656 0.0751781
R5012 VGND_n659 VGND_n657 0.0751781
R5013 VGND_n664 VGND_n663 0.0751781
R5014 VGND_n666 VGND_n664 0.0751781
R5015 VGND_n675 VGND_n674 0.0751781
R5016 VGND_n677 VGND_n675 0.0751781
R5017 VGND_n688 VGND_n687 0.0751781
R5018 VGND_n691 VGND_n689 0.0751781
R5019 VGND_n696 VGND_n695 0.0751781
R5020 VGND_n698 VGND_n696 0.0751781
R5021 VGND_n706 VGND_n705 0.0751781
R5022 VGND_n706 VGND_n288 0.0751781
R5023 VGND_n161 VGND_n158 0.07425
R5024 VGND_n547 VGND_n545 0.07425
R5025 VGND_n571 VGND_n570 0.07425
R5026 VGND_n149 VGND_n62 0.073
R5027 VGND_n94 VGND_n93 0.0721489
R5028 VGND_n544 VGND_n543 0.0705
R5029 VGND_n551 VGND_n550 0.068289
R5030 VGND_n458 VGND_n456 0.068289
R5031 VGND_n135 VGND_n131 0.06675
R5032 VGND_n160 VGND_n155 0.0655
R5033 VGND_n173 VGND_n171 0.0655
R5034 VGND_n37 VGND_n36 0.0655
R5035 VGND_n105 VGND_n102 0.063
R5036 VGND_n117 VGND_n86 0.063
R5037 VGND_n118 VGND_n115 0.063
R5038 VGND_n85 VGND_n84 0.063
R5039 VGND_n128 VGND_n122 0.063
R5040 VGND_n141 VGND_n73 0.063
R5041 VGND_n542 VGND_n541 0.060789
R5042 VGND_n527 VGND_n507 0.060789
R5043 VGND_n534 VGND_n496 0.060789
R5044 VGND_n79 VGND_n77 0.060789
R5045 VGND_n112 VGND_n109 0.060789
R5046 VGND_n97 VGND_n90 0.060789
R5047 VGND_n108 VGND_n106 0.060789
R5048 VGND_n81 VGND_n80 0.060789
R5049 VGND_n130 VGND_n75 0.060789
R5050 VGND_n565 VGND_n466 0.060789
R5051 VGND_n102 VGND_n101 0.058
R5052 VGND_n111 VGND_n86 0.058
R5053 VGND_n118 VGND_n117 0.058
R5054 VGND_n115 VGND_n85 0.058
R5055 VGND_n122 VGND_n121 0.058
R5056 VGND_n171 VGND_n43 0.0555
R5057 VGND_n43 VGND_n42 0.0555
R5058 VGND_n177 VGND_n176 0.0555
R5059 VGND_n62 VGND_n61 0.053
R5060 VGND_n167 VGND_n165 0.053
R5061 VGND_n719 VGND_n1 0.0518031
R5062 VGND_n61 VGND_n60 0.05175
R5063 VGND_n656 VGND_n654 0.05
R5064 VGND_n661 VGND_n659 0.05
R5065 VGND_n663 VGND_n661 0.05
R5066 VGND_n668 VGND_n666 0.05
R5067 VGND_n670 VGND_n668 0.05
R5068 VGND_n672 VGND_n670 0.05
R5069 VGND_n674 VGND_n672 0.05
R5070 VGND_n679 VGND_n677 0.05
R5071 VGND_n681 VGND_n679 0.05
R5072 VGND_n683 VGND_n681 0.05
R5073 VGND_n685 VGND_n683 0.05
R5074 VGND_n687 VGND_n685 0.05
R5075 VGND_n693 VGND_n691 0.05
R5076 VGND_n695 VGND_n693 0.05
R5077 VGND_n700 VGND_n698 0.05
R5078 VGND_n702 VGND_n700 0.05
R5079 VGND_n704 VGND_n702 0.05
R5080 VGND_n705 VGND_n704 0.05
R5081 VGND_n288 VGND_n286 0.05
R5082 VGND_n286 VGND_n284 0.05
R5083 VGND_n284 VGND_n282 0.05
R5084 VGND_n282 VGND_n280 0.05
R5085 VGND_n280 VGND_n278 0.05
R5086 VGND_n278 VGND_n276 0.05
R5087 VGND_n276 VGND_n252 0.05
R5088 VGND_n712 VGND_n252 0.05
R5089 VGND_n713 VGND_n712 0.05
R5090 VGND_n714 VGND_n713 0.05
R5091 VGND_n217 VGND_n15 0.04925
R5092 VGND_n151 VGND_n149 0.048
R5093 VGND_n720 VGND_n719 0.0463031
R5094 VGND_n148 VGND_n147 0.0455
R5095 VGND_n200 VGND_n198 0.043
R5096 VGND_n205 VGND_n203 0.043
R5097 VGND_n161 VGND_n160 0.04175
R5098 VGND_n545 VGND_n544 0.03675
R5099 VGND_n137 VGND_n136 0.03675
R5100 VGND_n129 VGND_n126 0.0354432
R5101 VGND_n96 VGND_n89 0.0349482
R5102 VGND_n126 VGND_n124 0.033
R5103 VGND_n148 VGND_n146 0.033
R5104 VGND_n151 VGND_n150 0.0305
R5105 VGND_n165 VGND_n164 0.0305
R5106 VGND_n173 VGND_n172 0.0305
R5107 VGND_n158 VGND_n56 0.029985
R5108 VGND_n222 VGND_n13 0.02675
R5109 VGND_n225 VGND_n53 0.0258175
R5110 VGND_n225 VGND_n156 0.0258175
R5111 VGND_n225 VGND_n132 0.0258175
R5112 VGND_n225 VGND_n82 0.0258175
R5113 VGND_n225 VGND_n103 0.0258175
R5114 VGND_n225 VGND_n99 0.0258175
R5115 VGND_n133 VGND_n73 0.02425
R5116 VGND_n51 VGND_n50 0.0205
R5117 VGND_n179 VGND_n177 0.018
R5118 VGND_n183 VGND_n37 0.018
R5119 VGND_n718 VGND_n5 0.0144475
R5120 VGND_n652 VGND_n628 0.00681802
R5121 VGND_n718 VGND_n2 0.00651943
R5122 VGND_n136 VGND_n135 0.00425
R5123 VGND_n212 VGND_n211 0.003
R5124 VGND_n290 VGND_n259 0.002125
R5125 VGND_n225 VGND_n123 0.00194928
R5126 VGND_n291 VGND_n259 0.00187493
R5127 VGND_n638 VGND_n6 0.00166667
R5128 VGND_n642 VGND_n633 0.00166667
R5129 VGND_n647 VGND_n637 0.00166667
R5130 VGND_n655 VGND_n267 0.00166667
R5131 VGND_n658 VGND_n241 0.00166667
R5132 VGND_n662 VGND_n264 0.00166667
R5133 VGND_n665 VGND_n244 0.00166667
R5134 VGND_n673 VGND_n270 0.00166667
R5135 VGND_n676 VGND_n239 0.00166667
R5136 VGND_n686 VGND_n247 0.00166667
R5137 VGND_n690 VGND_n236 0.00166667
R5138 VGND_n694 VGND_n258 0.00166667
R5139 VGND_n697 VGND_n248 0.00166667
R5140 VGND_n708 VGND_n274 0.00166667
R5141 VGND_n287 VGND_n234 0.00166667
R5142 VGND_n294 VGND_n241 0.00133332
R5143 VGND_n294 VGND_n267 0.00133332
R5144 VGND_n293 VGND_n244 0.00133332
R5145 VGND_n293 VGND_n264 0.00133332
R5146 VGND_n292 VGND_n239 0.00133332
R5147 VGND_n292 VGND_n270 0.00133332
R5148 VGND_n291 VGND_n247 0.00133332
R5149 VGND_n290 VGND_n236 0.00133332
R5150 VGND_n289 VGND_n248 0.00133332
R5151 VGND_n289 VGND_n258 0.00133332
R5152 VGND_n707 VGND_n234 0.00133332
R5153 VGND_n708 VGND_n707 0.00133332
R5154 VGND_n647 VGND_n646 0.00133332
R5155 VGND_n637 VGND_n633 0.00133332
R5156 VGND_n718 VGND_n6 0.00133332
R5157 VGND_n718 VGND_n3 0.00131272
R5158 VGND_n628 VGND_n265 0.00100762
R5159 VGND_n628 VGND_n627 0.00100727
R5160 VGND_n718 VGND_n8 0.00100167
R5161 VGND_n718 VGND_n4 0.00100002
R5162 VGND_n718 VGND_n228 0.00100001
R5163 VGND_n572 VGND_n462 0.001
R5164 VGND_n568 VGND_n465 0.001
R5165 VGND_n562 VGND_n469 0.001
R5166 VGND_n488 VGND_n479 0.001
R5167 VGND_n494 VGND_n490 0.001
R5168 VGND_n537 VGND_n495 0.001
R5169 VGND_n505 VGND_n499 0.001
R5170 VGND_n530 VGND_n506 0.001
R5171 VGND_n524 VGND_n510 0.001
R5172 VGND_n530 VGND_n510 0.001
R5173 VGND_n506 VGND_n505 0.001
R5174 VGND_n537 VGND_n499 0.001
R5175 VGND_n495 VGND_n494 0.001
R5176 VGND_n490 VGND_n488 0.001
R5177 VGND_n562 VGND_n479 0.001
R5178 VGND_n568 VGND_n469 0.001
R5179 VGND_n465 VGND_n462 0.001
R5180 VGND_n624 VGND_n572 0.001
R5181 VGND_n653 VGND_n243 0.001
R5182 VGND_n653 VGND_n266 0.001
R5183 VGND_n658 VGND_n268 0.001
R5184 VGND_n660 VGND_n240 0.001
R5185 VGND_n665 VGND_n263 0.001
R5186 VGND_n667 VGND_n245 0.001
R5187 VGND_n671 VGND_n246 0.001
R5188 VGND_n671 VGND_n269 0.001
R5189 VGND_n678 VGND_n238 0.001
R5190 VGND_n678 VGND_n262 0.001
R5191 VGND_n682 VGND_n237 0.001
R5192 VGND_n682 VGND_n261 0.001
R5193 VGND_n686 VGND_n260 0.001
R5194 VGND_n690 VGND_n271 0.001
R5195 VGND_n692 VGND_n235 0.001
R5196 VGND_n699 VGND_n249 0.001
R5197 VGND_n699 VGND_n272 0.001
R5198 VGND_n703 VGND_n250 0.001
R5199 VGND_n703 VGND_n273 0.001
R5200 VGND_n285 VGND_n233 0.001
R5201 VGND_n285 VGND_n257 0.001
R5202 VGND_n281 VGND_n232 0.001
R5203 VGND_n281 VGND_n256 0.001
R5204 VGND_n277 VGND_n231 0.001
R5205 VGND_n277 VGND_n255 0.001
R5206 VGND_n253 VGND_n230 0.001
R5207 VGND_n254 VGND_n253 0.001
R5208 VGND_n710 VGND_n251 0.001
R5209 VGND_n716 VGND_n715 0.001
R5210 VGND_n718 VGND_n229 0.001
R5211 VGND_n649 VGND_n628 0.001
R5212 VGND_n650 VGND_n630 0.001
R5213 VGND_n632 VGND_n631 0.001
R5214 VGND_n642 VGND_n634 0.001
R5215 VGND_n638 VGND_n636 0.001
R5216 VGND_n640 VGND_n636 0.001
R5217 VGND_n640 VGND_n634 0.001
R5218 VGND_n646 VGND_n632 0.001
R5219 VGND_n631 VGND_n630 0.001
R5220 VGND_n650 VGND_n649 0.001
R5221 VGND_n628 VGND_n266 0.001
R5222 VGND_n655 VGND_n243 0.001
R5223 VGND_n660 VGND_n268 0.001
R5224 VGND_n662 VGND_n240 0.001
R5225 VGND_n667 VGND_n263 0.001
R5226 VGND_n669 VGND_n245 0.001
R5227 VGND_n669 VGND_n269 0.001
R5228 VGND_n673 VGND_n246 0.001
R5229 VGND_n676 VGND_n262 0.001
R5230 VGND_n680 VGND_n238 0.001
R5231 VGND_n680 VGND_n261 0.001
R5232 VGND_n684 VGND_n237 0.001
R5233 VGND_n684 VGND_n260 0.001
R5234 VGND_n692 VGND_n271 0.001
R5235 VGND_n694 VGND_n235 0.001
R5236 VGND_n697 VGND_n272 0.001
R5237 VGND_n701 VGND_n249 0.001
R5238 VGND_n701 VGND_n273 0.001
R5239 VGND_n274 VGND_n250 0.001
R5240 VGND_n287 VGND_n257 0.001
R5241 VGND_n283 VGND_n233 0.001
R5242 VGND_n283 VGND_n256 0.001
R5243 VGND_n279 VGND_n232 0.001
R5244 VGND_n279 VGND_n255 0.001
R5245 VGND_n275 VGND_n231 0.001
R5246 VGND_n275 VGND_n254 0.001
R5247 VGND_n711 VGND_n230 0.001
R5248 VGND_n711 VGND_n710 0.001
R5249 VGND_n716 VGND_n251 0.001
R5250 VGND_n715 VGND_n229 0.001
R5251 AVSS_n664 AVSS_n663 124251
R5252 AVSS_n720 AVSS_n719 81166.7
R5253 AVSS_n724 AVSS_n723 71274.1
R5254 AVSS_n2415 AVSS_n772 58348.3
R5255 AVSS_n2424 AVSS_n770 54900
R5256 AVSS_n2820 AVSS_n770 46258
R5257 AVSS_n725 AVSS_n724 33765.3
R5258 AVSS_n2809 AVSS_n772 33142.4
R5259 AVSS_n663 AVSS_n649 29695.1
R5260 AVSS_n768 AVSS_n309 25641
R5261 AVSS_n2810 AVSS_n2809 23011.9
R5262 AVSS_n2444 AVSS_n2443 20987.2
R5263 AVSS_n687 AVSS_n205 19777.6
R5264 AVSS_n719 AVSS_n653 18850.2
R5265 AVSS_n721 AVSS_n649 17211.4
R5266 AVSS_n1533 AVSS_n1426 15471.2
R5267 AVSS_n3231 AVSS_n205 15019.2
R5268 AVSS_n1037 AVSS_n772 14336.4
R5269 AVSS_n2819 AVSS_n771 13911.4
R5270 AVSS_n2440 AVSS_n2406 11290.5
R5271 AVSS_n3498 AVSS_n3497 8622.94
R5272 AVSS_n768 AVSS_n767 5384.87
R5273 AVSS_n2432 AVSS_n2409 5209.3
R5274 AVSS_n2444 AVSS_n1426 4746.79
R5275 AVSS_n2433 AVSS_n2432 4477.82
R5276 AVSS_n3499 AVSS_n3498 3735.61
R5277 AVSS_n724 AVSS_n649 3306.82
R5278 AVSS_n2819 AVSS_n772 3306.82
R5279 AVSS_n2102 AVSS_n1911 3195.82
R5280 AVSS_n2425 AVSS_n2424 3112.01
R5281 AVSS_n721 AVSS_n720 2938.64
R5282 AVSS_n2424 AVSS_n771 2938.64
R5283 AVSS_n655 AVSS_n650 2843.06
R5284 AVSS_n2414 AVSS_n2413 2843.06
R5285 AVSS_n2819 AVSS_n2818 2835.63
R5286 AVSS_n2772 AVSS_n2771 2753.91
R5287 AVSS_n695 AVSS_n694 2605.04
R5288 AVSS_n2434 AVSS_n2407 2605.04
R5289 AVSS_n658 AVSS_n657 2543.11
R5290 AVSS_n2431 AVSS_n2430 2543.11
R5291 AVSS_n2758 AVSS_n2102 2513.74
R5292 AVSS_n2432 AVSS_n2431 2414.68
R5293 AVSS_n2772 AVSS_n1426 2388.49
R5294 AVSS_n718 AVSS_n658 2356.9
R5295 AVSS_n702 AVSS_n701 2330.14
R5296 AVSS_n685 AVSS_n683 2231.92
R5297 AVSS_n668 AVSS_n177 2186.86
R5298 AVSS_n682 AVSS_n681 2081.98
R5299 AVSS_n2432 AVSS_n2410 2080.28
R5300 AVSS_n689 AVSS_n688 2073.57
R5301 AVSS_n2442 AVSS_n2441 2073.57
R5302 AVSS_n688 AVSS_n683 2058.25
R5303 AVSS_n2441 AVSS_n2405 2058.25
R5304 AVSS_n2063 AVSS_n2062 1978.5
R5305 AVSS_n3498 AVSS_n8 1781.13
R5306 AVSS_n2820 AVSS_n769 1772.08
R5307 AVSS_n684 AVSS_n658 1594.34
R5308 AVSS_n2431 AVSS_n2412 1594.34
R5309 AVSS_n769 AVSS_n308 1504.94
R5310 AVSS_n3494 AVSS_n8 1467.2
R5311 AVSS_n2424 AVSS_n2423 1456.96
R5312 AVSS_n2406 AVSS_n2102 1426.63
R5313 AVSS_n8 AVSS_n4 1409.56
R5314 AVSS_n2412 AVSS_n2409 1363.57
R5315 AVSS_n701 AVSS_n684 1363.57
R5316 AVSS_n769 AVSS_n768 1297.13
R5317 AVSS_n3494 AVSS_n3493 1257.03
R5318 AVSS_n2431 AVSS_n2411 1243.96
R5319 AVSS_n660 AVSS_n654 1169.22
R5320 AVSS_n2546 AVSS_n2444 1145.24
R5321 AVSS_n3495 AVSS_n3494 1116.3
R5322 AVSS_n2435 AVSS_n2433 1109.21
R5323 AVSS_n696 AVSS_n685 1109.21
R5324 AVSS_n2430 AVSS_n2413 1056.29
R5325 AVSS_n657 AVSS_n650 1056.28
R5326 AVSS_n720 AVSS_n652 1052.7
R5327 AVSS_n717 AVSS_n702 1014.2
R5328 AVSS_n658 AVSS_n655 980.885
R5329 AVSS_n2414 AVSS_n2411 980.885
R5330 AVSS_n2434 AVSS_n2218 917.362
R5331 AVSS_n695 AVSS_n693 917.361
R5332 AVSS_n694 AVSS_n683 890.756
R5333 AVSS_n2410 AVSS_n2407 890.756
R5334 AVSS_n3497 AVSS_n7 888.436
R5335 AVSS_n3497 AVSS_n4 810.101
R5336 AVSS_n2410 AVSS_n2405 782.487
R5337 AVSS_n3222 AVSS_n2820 738.923
R5338 AVSS_n718 AVSS_n682 734.841
R5339 AVSS_n688 AVSS_n687 649.077
R5340 AVSS_n2441 AVSS_n2440 649.077
R5341 AVSS_n723 AVSS_n650 639.515
R5342 AVSS_n2415 AVSS_n2413 639.514
R5343 AVSS_n714 AVSS_n205 638.126
R5344 AVSS_n3499 AVSS_n7 622.67
R5345 AVSS_n2820 AVSS_n2819 601.607
R5346 AVSS_n696 AVSS_n695 504.346
R5347 AVSS_n2435 AVSS_n2434 504.346
R5348 AVSS_n3495 AVSS_n10 494.505
R5349 AVSS_n702 AVSS_n683 489.695
R5350 AVSS_n693 AVSS_n309 466.8
R5351 AVSS_n2443 AVSS_n2218 466.798
R5352 AVSS_n719 AVSS_n654 391.536
R5353 AVSS_n717 AVSS_n716 326.872
R5354 AVSS_n2820 AVSS_n307 311.45
R5355 AVSS_n710 AVSS_n205 303.51
R5356 AVSS_n2411 AVSS_n770 279.37
R5357 AVSS_n670 AVSS_n205 278.406
R5358 AVSS_n562 AVSS_n398 236.69
R5359 AVSS_n664 AVSS_n653 173.411
R5360 AVSS_n2406 AVSS_n2405 173.077
R5361 AVSS_n673 AVSS_n205 132.417
R5362 AVSS_n690 AVSS_n689 94.3576
R5363 AVSS_n2442 AVSS_n2404 94.3576
R5364 AVSS_n3496 AVSS_n3495 91.7347
R5365 AVSS_n663 AVSS_n662 82.1973
R5366 AVSS_n689 AVSS_n309 74.2088
R5367 AVSS_n2443 AVSS_n2442 74.2088
R5368 AVSS_n2444 AVSS_n2102 66.6308
R5369 AVSS_n662 AVSS_n177 64.6182
R5370 AVSS_n2759 AVSS_n2758 64.2283
R5371 AVSS_n2428 AVSS_n2427 59.337
R5372 AVSS_n690 AVSS_n1 45.9005
R5373 AVSS_n2404 AVSS_n2403 45.9001
R5374 AVSS_n371 AVSS_n370 36.5595
R5375 AVSS_n1379 AVSS_n1162 33.3286
R5376 AVSS_n3424 AVSS_n132 31.3455
R5377 AVSS_n1303 AVSS_n1291 30.6982
R5378 AVSS_n2785 AVSS_n2783 29.7679
R5379 AVSS_n445 AVSS_n444 28.8652
R5380 AVSS_n1307 AVSS_n1306 28.4712
R5381 AVSS_n1155 AVSS_n1154 27.9075
R5382 AVSS_n2784 AVSS_n1277 27.9075
R5383 AVSS_n2774 AVSS_n2773 27.9075
R5384 AVSS_n1377 AVSS_n1376 26.9772
R5385 AVSS_n1366 AVSS_n1246 26.9772
R5386 AVSS_n1157 AVSS_n1156 26.047
R5387 AVSS_n1393 AVSS_n1263 26.047
R5388 AVSS_n2779 AVSS_n2775 26.047
R5389 AVSS_n1369 AVSS_n1368 25.1168
R5390 AVSS_n1218 AVSS_n1217 24.1865
R5391 AVSS_n1159 AVSS_n1158 24.1865
R5392 AVSS_n1252 AVSS_n1251 24.1865
R5393 AVSS_n1262 AVSS_n1261 24.1865
R5394 AVSS_n1305 AVSS_n1289 24.1865
R5395 AVSS_n2778 AVSS_n2777 24.1865
R5396 AVSS_n1365 AVSS_n1364 23.2563
R5397 AVSS_n2808 AVSS_n2807 23.0933
R5398 AVSS_n719 AVSS_n718 22.5056
R5399 AVSS_n2230 AVSS_n2229 22.3261
R5400 AVSS_n1216 AVSS_n1215 22.3261
R5401 AVSS_n2792 AVSS_n1164 22.3261
R5402 AVSS_n1260 AVSS_n1259 22.3261
R5403 AVSS_n1310 AVSS_n1309 22.3261
R5404 AVSS_n2776 AVSS_n1318 22.3261
R5405 AVSS_n3418 AVSS_n177 21.5406
R5406 AVSS_n1117 AVSS_n1116 21.3958
R5407 AVSS_n1371 AVSS_n1370 21.3958
R5408 AVSS_n2783 AVSS_n2782 21.3958
R5409 AVSS_n1299 AVSS_n1298 21.3958
R5410 AVSS_n356 AVSS_n313 20.5265
R5411 AVSS_n363 AVSS_n333 20.5265
R5412 AVSS_n354 AVSS_n353 20.5265
R5413 AVSS_n764 AVSS_n763 20.5265
R5414 AVSS_n370 AVSS_n335 20.5265
R5415 AVSS_n1087 AVSS_n1086 20.4656
R5416 AVSS_n2238 AVSS_n1082 20.4656
R5417 AVSS_n1214 AVSS_n1213 20.4656
R5418 AVSS_n1380 AVSS_n1258 20.4656
R5419 AVSS_n1308 AVSS_n1288 20.4656
R5420 AVSS_n1317 AVSS_n1286 20.4656
R5421 AVSS_n1326 AVSS_n1294 19.5354
R5422 AVSS_n636 AVSS_n468 19.2436
R5423 AVSS_n640 AVSS_n482 19.2436
R5424 AVSS_n637 AVSS_n467 19.2436
R5425 AVSS_n642 AVSS_n483 19.2436
R5426 AVSS_n1067 AVSS_n1066 18.6052
R5427 AVSS_n2232 AVSS_n1090 18.6052
R5428 AVSS_n1210 AVSS_n1209 18.6052
R5429 AVSS_n1383 AVSS_n1257 18.6052
R5430 AVSS_n1271 AVSS_n1270 18.6052
R5431 AVSS_n1313 AVSS_n1312 18.6052
R5432 AVSS_n1316 AVSS_n1314 18.6052
R5433 AVSS_n410 AVSS_n393 18.6022
R5434 AVSS_n403 AVSS_n394 18.6022
R5435 AVSS_n413 AVSS_n412 18.6022
R5436 AVSS_n411 AVSS_n395 18.6022
R5437 AVSS_n754 AVSS_n753 18.6022
R5438 AVSS_n694 AVSS_n686 18.0501
R5439 AVSS_n2437 AVSS_n2407 18.0501
R5440 AVSS_n691 AVSS_n687 18.0201
R5441 AVSS_n2440 AVSS_n2439 18.0201
R5442 AVSS_n436 AVSS_n371 17.9468
R5443 AVSS_n1127 AVSS_n1096 17.6749
R5444 AVSS_n1129 AVSS_n1076 17.6749
R5445 AVSS_n1131 AVSS_n1097 17.6749
R5446 AVSS_n1133 AVSS_n1075 17.6749
R5447 AVSS_n1135 AVSS_n1098 17.6749
R5448 AVSS_n1137 AVSS_n1136 17.6749
R5449 AVSS_n2801 AVSS_n1100 17.6749
R5450 AVSS_n2795 AVSS_n2794 17.6749
R5451 AVSS_n2797 AVSS_n2796 17.6749
R5452 AVSS_n1330 AVSS_n1282 17.6749
R5453 AVSS_n1334 AVSS_n1297 17.6749
R5454 AVSS_n2427 AVSS_n2426 17.001
R5455 AVSS_n3493 AVSS_n12 17.0005
R5456 AVSS_n3493 AVSS_n3492 17.0005
R5457 AVSS_n3493 AVSS_n13 17.0005
R5458 AVSS_n3493 AVSS_n23 17.0005
R5459 AVSS_n3493 AVSS_n14 17.0005
R5460 AVSS_n3493 AVSS_n22 17.0005
R5461 AVSS_n3493 AVSS_n15 17.0005
R5462 AVSS_n3493 AVSS_n20 17.0005
R5463 AVSS_n3493 AVSS_n16 17.0005
R5464 AVSS_n3493 AVSS_n19 17.0005
R5465 AVSS_n3493 AVSS_n17 17.0005
R5466 AVSS_n3493 AVSS_n18 17.0005
R5467 AVSS_n18 AVSS_n10 17.0005
R5468 AVSS_n3478 AVSS_n10 17.0005
R5469 AVSS_n3475 AVSS_n10 17.0005
R5470 AVSS_n39 AVSS_n10 17.0005
R5471 AVSS_n85 AVSS_n10 17.0005
R5472 AVSS_n40 AVSS_n10 17.0005
R5473 AVSS_n84 AVSS_n10 17.0005
R5474 AVSS_n41 AVSS_n10 17.0005
R5475 AVSS_n83 AVSS_n10 17.0005
R5476 AVSS_n3470 AVSS_n10 17.0005
R5477 AVSS_n43 AVSS_n10 17.0005
R5478 AVSS_n81 AVSS_n10 17.0005
R5479 AVSS_n44 AVSS_n10 17.0005
R5480 AVSS_n80 AVSS_n10 17.0005
R5481 AVSS_n45 AVSS_n10 17.0005
R5482 AVSS_n79 AVSS_n10 17.0005
R5483 AVSS_n46 AVSS_n10 17.0005
R5484 AVSS_n78 AVSS_n10 17.0005
R5485 AVSS_n47 AVSS_n10 17.0005
R5486 AVSS_n76 AVSS_n10 17.0005
R5487 AVSS_n48 AVSS_n10 17.0005
R5488 AVSS_n75 AVSS_n10 17.0005
R5489 AVSS_n49 AVSS_n10 17.0005
R5490 AVSS_n73 AVSS_n10 17.0005
R5491 AVSS_n50 AVSS_n10 17.0005
R5492 AVSS_n72 AVSS_n10 17.0005
R5493 AVSS_n51 AVSS_n10 17.0005
R5494 AVSS_n3450 AVSS_n10 17.0005
R5495 AVSS_n52 AVSS_n10 17.0005
R5496 AVSS_n70 AVSS_n10 17.0005
R5497 AVSS_n53 AVSS_n10 17.0005
R5498 AVSS_n69 AVSS_n10 17.0005
R5499 AVSS_n54 AVSS_n10 17.0005
R5500 AVSS_n68 AVSS_n10 17.0005
R5501 AVSS_n55 AVSS_n10 17.0005
R5502 AVSS_n67 AVSS_n10 17.0005
R5503 AVSS_n56 AVSS_n10 17.0005
R5504 AVSS_n66 AVSS_n10 17.0005
R5505 AVSS_n57 AVSS_n10 17.0005
R5506 AVSS_n64 AVSS_n10 17.0005
R5507 AVSS_n58 AVSS_n10 17.0005
R5508 AVSS_n63 AVSS_n10 17.0005
R5509 AVSS_n59 AVSS_n10 17.0005
R5510 AVSS_n61 AVSS_n10 17.0005
R5511 AVSS_n10 AVSS_n9 17.0005
R5512 AVSS_n3418 AVSS_n9 17.0005
R5513 AVSS_n3418 AVSS_n141 17.0005
R5514 AVSS_n3418 AVSS_n3417 17.0005
R5515 AVSS_n3418 AVSS_n142 17.0005
R5516 AVSS_n3418 AVSS_n3279 17.0005
R5517 AVSS_n3418 AVSS_n143 17.0005
R5518 AVSS_n3418 AVSS_n3278 17.0005
R5519 AVSS_n3418 AVSS_n144 17.0005
R5520 AVSS_n3418 AVSS_n3277 17.0005
R5521 AVSS_n3418 AVSS_n145 17.0005
R5522 AVSS_n3418 AVSS_n3276 17.0005
R5523 AVSS_n3418 AVSS_n146 17.0005
R5524 AVSS_n3418 AVSS_n3275 17.0005
R5525 AVSS_n3418 AVSS_n147 17.0005
R5526 AVSS_n3418 AVSS_n3274 17.0005
R5527 AVSS_n3418 AVSS_n148 17.0005
R5528 AVSS_n3418 AVSS_n3273 17.0005
R5529 AVSS_n3418 AVSS_n149 17.0005
R5530 AVSS_n3418 AVSS_n3272 17.0005
R5531 AVSS_n3418 AVSS_n150 17.0005
R5532 AVSS_n3418 AVSS_n3271 17.0005
R5533 AVSS_n3418 AVSS_n151 17.0005
R5534 AVSS_n3418 AVSS_n3270 17.0005
R5535 AVSS_n3418 AVSS_n152 17.0005
R5536 AVSS_n3418 AVSS_n3269 17.0005
R5537 AVSS_n3418 AVSS_n153 17.0005
R5538 AVSS_n3418 AVSS_n3268 17.0005
R5539 AVSS_n3418 AVSS_n154 17.0005
R5540 AVSS_n3418 AVSS_n3267 17.0005
R5541 AVSS_n3418 AVSS_n155 17.0005
R5542 AVSS_n3418 AVSS_n3266 17.0005
R5543 AVSS_n3418 AVSS_n156 17.0005
R5544 AVSS_n3418 AVSS_n3265 17.0005
R5545 AVSS_n3418 AVSS_n157 17.0005
R5546 AVSS_n3418 AVSS_n3264 17.0005
R5547 AVSS_n3418 AVSS_n158 17.0005
R5548 AVSS_n3418 AVSS_n3263 17.0005
R5549 AVSS_n3418 AVSS_n159 17.0005
R5550 AVSS_n3418 AVSS_n3262 17.0005
R5551 AVSS_n3418 AVSS_n160 17.0005
R5552 AVSS_n3418 AVSS_n3261 17.0005
R5553 AVSS_n3418 AVSS_n161 17.0005
R5554 AVSS_n3418 AVSS_n3260 17.0005
R5555 AVSS_n3418 AVSS_n162 17.0005
R5556 AVSS_n3418 AVSS_n3259 17.0005
R5557 AVSS_n3418 AVSS_n163 17.0005
R5558 AVSS_n3418 AVSS_n3258 17.0005
R5559 AVSS_n3418 AVSS_n3257 17.0005
R5560 AVSS_n3418 AVSS_n164 17.0005
R5561 AVSS_n3418 AVSS_n3256 17.0005
R5562 AVSS_n3418 AVSS_n165 17.0005
R5563 AVSS_n3418 AVSS_n3255 17.0005
R5564 AVSS_n3418 AVSS_n166 17.0005
R5565 AVSS_n3418 AVSS_n3254 17.0005
R5566 AVSS_n3418 AVSS_n167 17.0005
R5567 AVSS_n3418 AVSS_n3253 17.0005
R5568 AVSS_n3418 AVSS_n168 17.0005
R5569 AVSS_n3418 AVSS_n3252 17.0005
R5570 AVSS_n3418 AVSS_n169 17.0005
R5571 AVSS_n3418 AVSS_n3251 17.0005
R5572 AVSS_n3418 AVSS_n170 17.0005
R5573 AVSS_n3418 AVSS_n184 17.0005
R5574 AVSS_n3418 AVSS_n171 17.0005
R5575 AVSS_n3418 AVSS_n183 17.0005
R5576 AVSS_n3418 AVSS_n172 17.0005
R5577 AVSS_n3418 AVSS_n182 17.0005
R5578 AVSS_n3418 AVSS_n173 17.0005
R5579 AVSS_n3418 AVSS_n181 17.0005
R5580 AVSS_n3418 AVSS_n174 17.0005
R5581 AVSS_n3418 AVSS_n180 17.0005
R5582 AVSS_n3418 AVSS_n175 17.0005
R5583 AVSS_n3418 AVSS_n179 17.0005
R5584 AVSS_n3418 AVSS_n176 17.0005
R5585 AVSS_n3418 AVSS_n178 17.0005
R5586 AVSS_n3231 AVSS_n178 17.0005
R5587 AVSS_n3232 AVSS_n3231 17.0005
R5588 AVSS_n3231 AVSS_n193 17.0005
R5589 AVSS_n3231 AVSS_n198 17.0005
R5590 AVSS_n3231 AVSS_n203 17.0005
R5591 AVSS_n3231 AVSS_n3230 17.0005
R5592 AVSS_n3231 AVSS_n204 17.0005
R5593 AVSS_n3231 AVSS_n197 17.0005
R5594 AVSS_n3231 AVSS_n195 17.0005
R5595 AVSS_n3231 AVSS_n196 17.0005
R5596 AVSS_n3222 AVSS_n196 17.0005
R5597 AVSS_n3223 AVSS_n3222 17.0005
R5598 AVSS_n3222 AVSS_n3221 17.0005
R5599 AVSS_n3222 AVSS_n227 17.0005
R5600 AVSS_n3222 AVSS_n2913 17.0005
R5601 AVSS_n3222 AVSS_n228 17.0005
R5602 AVSS_n3222 AVSS_n2912 17.0005
R5603 AVSS_n3222 AVSS_n229 17.0005
R5604 AVSS_n3222 AVSS_n2911 17.0005
R5605 AVSS_n3222 AVSS_n230 17.0005
R5606 AVSS_n3222 AVSS_n2910 17.0005
R5607 AVSS_n3222 AVSS_n231 17.0005
R5608 AVSS_n3222 AVSS_n2908 17.0005
R5609 AVSS_n3222 AVSS_n232 17.0005
R5610 AVSS_n3222 AVSS_n2907 17.0005
R5611 AVSS_n3222 AVSS_n233 17.0005
R5612 AVSS_n3222 AVSS_n2906 17.0005
R5613 AVSS_n3222 AVSS_n234 17.0005
R5614 AVSS_n3222 AVSS_n2905 17.0005
R5615 AVSS_n3222 AVSS_n235 17.0005
R5616 AVSS_n3222 AVSS_n2904 17.0005
R5617 AVSS_n3222 AVSS_n236 17.0005
R5618 AVSS_n3222 AVSS_n2903 17.0005
R5619 AVSS_n3222 AVSS_n237 17.0005
R5620 AVSS_n3222 AVSS_n2901 17.0005
R5621 AVSS_n3222 AVSS_n238 17.0005
R5622 AVSS_n3222 AVSS_n2900 17.0005
R5623 AVSS_n3222 AVSS_n239 17.0005
R5624 AVSS_n3222 AVSS_n2899 17.0005
R5625 AVSS_n3222 AVSS_n240 17.0005
R5626 AVSS_n3222 AVSS_n2898 17.0005
R5627 AVSS_n3222 AVSS_n241 17.0005
R5628 AVSS_n3222 AVSS_n2897 17.0005
R5629 AVSS_n3222 AVSS_n242 17.0005
R5630 AVSS_n3222 AVSS_n2895 17.0005
R5631 AVSS_n3222 AVSS_n243 17.0005
R5632 AVSS_n3222 AVSS_n2894 17.0005
R5633 AVSS_n3222 AVSS_n244 17.0005
R5634 AVSS_n3222 AVSS_n2893 17.0005
R5635 AVSS_n3222 AVSS_n247 17.0005
R5636 AVSS_n3222 AVSS_n2891 17.0005
R5637 AVSS_n3222 AVSS_n248 17.0005
R5638 AVSS_n3222 AVSS_n2890 17.0005
R5639 AVSS_n3222 AVSS_n249 17.0005
R5640 AVSS_n3222 AVSS_n2889 17.0005
R5641 AVSS_n3222 AVSS_n250 17.0005
R5642 AVSS_n3222 AVSS_n2888 17.0005
R5643 AVSS_n3222 AVSS_n251 17.0005
R5644 AVSS_n3222 AVSS_n2886 17.0005
R5645 AVSS_n3222 AVSS_n252 17.0005
R5646 AVSS_n3222 AVSS_n2885 17.0005
R5647 AVSS_n3222 AVSS_n253 17.0005
R5648 AVSS_n3222 AVSS_n2884 17.0005
R5649 AVSS_n3222 AVSS_n254 17.0005
R5650 AVSS_n3222 AVSS_n2883 17.0005
R5651 AVSS_n3222 AVSS_n255 17.0005
R5652 AVSS_n3222 AVSS_n2882 17.0005
R5653 AVSS_n3222 AVSS_n256 17.0005
R5654 AVSS_n3222 AVSS_n2881 17.0005
R5655 AVSS_n3222 AVSS_n257 17.0005
R5656 AVSS_n3222 AVSS_n2879 17.0005
R5657 AVSS_n3222 AVSS_n258 17.0005
R5658 AVSS_n3222 AVSS_n2878 17.0005
R5659 AVSS_n3222 AVSS_n259 17.0005
R5660 AVSS_n3222 AVSS_n2877 17.0005
R5661 AVSS_n3222 AVSS_n260 17.0005
R5662 AVSS_n3222 AVSS_n2876 17.0005
R5663 AVSS_n3222 AVSS_n261 17.0005
R5664 AVSS_n3222 AVSS_n2875 17.0005
R5665 AVSS_n3222 AVSS_n262 17.0005
R5666 AVSS_n3222 AVSS_n2873 17.0005
R5667 AVSS_n3222 AVSS_n263 17.0005
R5668 AVSS_n3222 AVSS_n2872 17.0005
R5669 AVSS_n3222 AVSS_n264 17.0005
R5670 AVSS_n3222 AVSS_n2871 17.0005
R5671 AVSS_n3222 AVSS_n265 17.0005
R5672 AVSS_n3222 AVSS_n2870 17.0005
R5673 AVSS_n3222 AVSS_n266 17.0005
R5674 AVSS_n3222 AVSS_n2869 17.0005
R5675 AVSS_n3222 AVSS_n267 17.0005
R5676 AVSS_n3222 AVSS_n2868 17.0005
R5677 AVSS_n3222 AVSS_n268 17.0005
R5678 AVSS_n3222 AVSS_n2866 17.0005
R5679 AVSS_n3222 AVSS_n269 17.0005
R5680 AVSS_n3222 AVSS_n2865 17.0005
R5681 AVSS_n3222 AVSS_n270 17.0005
R5682 AVSS_n3222 AVSS_n2864 17.0005
R5683 AVSS_n3222 AVSS_n271 17.0005
R5684 AVSS_n3222 AVSS_n2863 17.0005
R5685 AVSS_n3222 AVSS_n272 17.0005
R5686 AVSS_n3222 AVSS_n2862 17.0005
R5687 AVSS_n3222 AVSS_n273 17.0005
R5688 AVSS_n3222 AVSS_n2860 17.0005
R5689 AVSS_n3222 AVSS_n274 17.0005
R5690 AVSS_n3222 AVSS_n2859 17.0005
R5691 AVSS_n3222 AVSS_n275 17.0005
R5692 AVSS_n3222 AVSS_n2858 17.0005
R5693 AVSS_n3222 AVSS_n276 17.0005
R5694 AVSS_n3222 AVSS_n2857 17.0005
R5695 AVSS_n3222 AVSS_n277 17.0005
R5696 AVSS_n3222 AVSS_n2856 17.0005
R5697 AVSS_n3222 AVSS_n278 17.0005
R5698 AVSS_n3222 AVSS_n2855 17.0005
R5699 AVSS_n3222 AVSS_n279 17.0005
R5700 AVSS_n3222 AVSS_n2853 17.0005
R5701 AVSS_n3222 AVSS_n280 17.0005
R5702 AVSS_n3222 AVSS_n2852 17.0005
R5703 AVSS_n3222 AVSS_n281 17.0005
R5704 AVSS_n3222 AVSS_n2851 17.0005
R5705 AVSS_n3222 AVSS_n282 17.0005
R5706 AVSS_n3222 AVSS_n2850 17.0005
R5707 AVSS_n3222 AVSS_n283 17.0005
R5708 AVSS_n3222 AVSS_n2849 17.0005
R5709 AVSS_n3222 AVSS_n284 17.0005
R5710 AVSS_n3222 AVSS_n2847 17.0005
R5711 AVSS_n3222 AVSS_n285 17.0005
R5712 AVSS_n3222 AVSS_n2846 17.0005
R5713 AVSS_n3222 AVSS_n286 17.0005
R5714 AVSS_n3222 AVSS_n2845 17.0005
R5715 AVSS_n3222 AVSS_n2843 17.0005
R5716 AVSS_n3222 AVSS_n287 17.0005
R5717 AVSS_n3222 AVSS_n2842 17.0005
R5718 AVSS_n3222 AVSS_n288 17.0005
R5719 AVSS_n3222 AVSS_n2841 17.0005
R5720 AVSS_n3222 AVSS_n289 17.0005
R5721 AVSS_n3222 AVSS_n2840 17.0005
R5722 AVSS_n3222 AVSS_n290 17.0005
R5723 AVSS_n3222 AVSS_n2839 17.0005
R5724 AVSS_n3222 AVSS_n291 17.0005
R5725 AVSS_n3222 AVSS_n2837 17.0005
R5726 AVSS_n3222 AVSS_n292 17.0005
R5727 AVSS_n3222 AVSS_n2836 17.0005
R5728 AVSS_n3222 AVSS_n293 17.0005
R5729 AVSS_n3222 AVSS_n2835 17.0005
R5730 AVSS_n3222 AVSS_n294 17.0005
R5731 AVSS_n3222 AVSS_n2834 17.0005
R5732 AVSS_n3222 AVSS_n295 17.0005
R5733 AVSS_n3222 AVSS_n2833 17.0005
R5734 AVSS_n3222 AVSS_n296 17.0005
R5735 AVSS_n3222 AVSS_n2832 17.0005
R5736 AVSS_n3222 AVSS_n297 17.0005
R5737 AVSS_n3222 AVSS_n2830 17.0005
R5738 AVSS_n3222 AVSS_n298 17.0005
R5739 AVSS_n3222 AVSS_n2829 17.0005
R5740 AVSS_n3222 AVSS_n299 17.0005
R5741 AVSS_n3222 AVSS_n2828 17.0005
R5742 AVSS_n3222 AVSS_n300 17.0005
R5743 AVSS_n3222 AVSS_n2827 17.0005
R5744 AVSS_n3222 AVSS_n301 17.0005
R5745 AVSS_n3222 AVSS_n2826 17.0005
R5746 AVSS_n3222 AVSS_n302 17.0005
R5747 AVSS_n3222 AVSS_n2824 17.0005
R5748 AVSS_n3222 AVSS_n303 17.0005
R5749 AVSS_n3222 AVSS_n2823 17.0005
R5750 AVSS_n3222 AVSS_n304 17.0005
R5751 AVSS_n3222 AVSS_n2822 17.0005
R5752 AVSS_n3222 AVSS_n305 17.0005
R5753 AVSS_n3222 AVSS_n2821 17.0005
R5754 AVSS_n24 AVSS_n12 17.0005
R5755 AVSS_n3492 AVSS_n24 17.0005
R5756 AVSS_n24 AVSS_n13 17.0005
R5757 AVSS_n24 AVSS_n23 17.0005
R5758 AVSS_n24 AVSS_n14 17.0005
R5759 AVSS_n24 AVSS_n22 17.0005
R5760 AVSS_n24 AVSS_n15 17.0005
R5761 AVSS_n24 AVSS_n20 17.0005
R5762 AVSS_n24 AVSS_n16 17.0005
R5763 AVSS_n24 AVSS_n19 17.0005
R5764 AVSS_n24 AVSS_n17 17.0005
R5765 AVSS_n24 AVSS_n18 17.0005
R5766 AVSS_n37 AVSS_n18 17.0005
R5767 AVSS_n3475 AVSS_n37 17.0005
R5768 AVSS_n39 AVSS_n37 17.0005
R5769 AVSS_n85 AVSS_n37 17.0005
R5770 AVSS_n40 AVSS_n37 17.0005
R5771 AVSS_n84 AVSS_n37 17.0005
R5772 AVSS_n41 AVSS_n37 17.0005
R5773 AVSS_n83 AVSS_n37 17.0005
R5774 AVSS_n3470 AVSS_n37 17.0005
R5775 AVSS_n43 AVSS_n37 17.0005
R5776 AVSS_n81 AVSS_n37 17.0005
R5777 AVSS_n44 AVSS_n37 17.0005
R5778 AVSS_n80 AVSS_n37 17.0005
R5779 AVSS_n45 AVSS_n37 17.0005
R5780 AVSS_n79 AVSS_n37 17.0005
R5781 AVSS_n46 AVSS_n37 17.0005
R5782 AVSS_n78 AVSS_n37 17.0005
R5783 AVSS_n47 AVSS_n37 17.0005
R5784 AVSS_n76 AVSS_n37 17.0005
R5785 AVSS_n48 AVSS_n37 17.0005
R5786 AVSS_n75 AVSS_n37 17.0005
R5787 AVSS_n49 AVSS_n37 17.0005
R5788 AVSS_n73 AVSS_n37 17.0005
R5789 AVSS_n50 AVSS_n37 17.0005
R5790 AVSS_n72 AVSS_n37 17.0005
R5791 AVSS_n51 AVSS_n37 17.0005
R5792 AVSS_n3450 AVSS_n37 17.0005
R5793 AVSS_n52 AVSS_n37 17.0005
R5794 AVSS_n70 AVSS_n37 17.0005
R5795 AVSS_n53 AVSS_n37 17.0005
R5796 AVSS_n69 AVSS_n37 17.0005
R5797 AVSS_n54 AVSS_n37 17.0005
R5798 AVSS_n68 AVSS_n37 17.0005
R5799 AVSS_n55 AVSS_n37 17.0005
R5800 AVSS_n67 AVSS_n37 17.0005
R5801 AVSS_n56 AVSS_n37 17.0005
R5802 AVSS_n66 AVSS_n37 17.0005
R5803 AVSS_n57 AVSS_n37 17.0005
R5804 AVSS_n64 AVSS_n37 17.0005
R5805 AVSS_n58 AVSS_n37 17.0005
R5806 AVSS_n63 AVSS_n37 17.0005
R5807 AVSS_n59 AVSS_n37 17.0005
R5808 AVSS_n61 AVSS_n37 17.0005
R5809 AVSS_n37 AVSS_n9 17.0005
R5810 AVSS_n3280 AVSS_n9 17.0005
R5811 AVSS_n3280 AVSS_n141 17.0005
R5812 AVSS_n3417 AVSS_n3280 17.0005
R5813 AVSS_n3280 AVSS_n142 17.0005
R5814 AVSS_n3280 AVSS_n3279 17.0005
R5815 AVSS_n3280 AVSS_n143 17.0005
R5816 AVSS_n3280 AVSS_n3278 17.0005
R5817 AVSS_n3280 AVSS_n144 17.0005
R5818 AVSS_n3280 AVSS_n3277 17.0005
R5819 AVSS_n3280 AVSS_n145 17.0005
R5820 AVSS_n3280 AVSS_n3276 17.0005
R5821 AVSS_n3280 AVSS_n146 17.0005
R5822 AVSS_n3280 AVSS_n3275 17.0005
R5823 AVSS_n3280 AVSS_n147 17.0005
R5824 AVSS_n3280 AVSS_n3274 17.0005
R5825 AVSS_n3280 AVSS_n148 17.0005
R5826 AVSS_n3280 AVSS_n3273 17.0005
R5827 AVSS_n3280 AVSS_n149 17.0005
R5828 AVSS_n3280 AVSS_n3272 17.0005
R5829 AVSS_n3280 AVSS_n150 17.0005
R5830 AVSS_n3280 AVSS_n3271 17.0005
R5831 AVSS_n3280 AVSS_n151 17.0005
R5832 AVSS_n3280 AVSS_n3270 17.0005
R5833 AVSS_n3280 AVSS_n152 17.0005
R5834 AVSS_n3280 AVSS_n3269 17.0005
R5835 AVSS_n3280 AVSS_n153 17.0005
R5836 AVSS_n3280 AVSS_n3268 17.0005
R5837 AVSS_n3280 AVSS_n154 17.0005
R5838 AVSS_n3280 AVSS_n3267 17.0005
R5839 AVSS_n3280 AVSS_n155 17.0005
R5840 AVSS_n3280 AVSS_n3266 17.0005
R5841 AVSS_n3280 AVSS_n156 17.0005
R5842 AVSS_n3280 AVSS_n3265 17.0005
R5843 AVSS_n3280 AVSS_n157 17.0005
R5844 AVSS_n3280 AVSS_n3264 17.0005
R5845 AVSS_n3280 AVSS_n158 17.0005
R5846 AVSS_n3280 AVSS_n3263 17.0005
R5847 AVSS_n3280 AVSS_n159 17.0005
R5848 AVSS_n3280 AVSS_n3262 17.0005
R5849 AVSS_n3280 AVSS_n160 17.0005
R5850 AVSS_n3280 AVSS_n3261 17.0005
R5851 AVSS_n3280 AVSS_n161 17.0005
R5852 AVSS_n3280 AVSS_n3260 17.0005
R5853 AVSS_n3280 AVSS_n162 17.0005
R5854 AVSS_n3280 AVSS_n3259 17.0005
R5855 AVSS_n3280 AVSS_n163 17.0005
R5856 AVSS_n3280 AVSS_n3258 17.0005
R5857 AVSS_n3280 AVSS_n3257 17.0005
R5858 AVSS_n3280 AVSS_n164 17.0005
R5859 AVSS_n3280 AVSS_n3256 17.0005
R5860 AVSS_n3280 AVSS_n165 17.0005
R5861 AVSS_n3280 AVSS_n3255 17.0005
R5862 AVSS_n3280 AVSS_n166 17.0005
R5863 AVSS_n3280 AVSS_n3254 17.0005
R5864 AVSS_n3280 AVSS_n167 17.0005
R5865 AVSS_n3280 AVSS_n3253 17.0005
R5866 AVSS_n3280 AVSS_n168 17.0005
R5867 AVSS_n3280 AVSS_n3252 17.0005
R5868 AVSS_n3280 AVSS_n169 17.0005
R5869 AVSS_n3280 AVSS_n3251 17.0005
R5870 AVSS_n3280 AVSS_n170 17.0005
R5871 AVSS_n3280 AVSS_n184 17.0005
R5872 AVSS_n3280 AVSS_n171 17.0005
R5873 AVSS_n3280 AVSS_n183 17.0005
R5874 AVSS_n3280 AVSS_n172 17.0005
R5875 AVSS_n3280 AVSS_n182 17.0005
R5876 AVSS_n3280 AVSS_n173 17.0005
R5877 AVSS_n3280 AVSS_n181 17.0005
R5878 AVSS_n3280 AVSS_n174 17.0005
R5879 AVSS_n3280 AVSS_n180 17.0005
R5880 AVSS_n3280 AVSS_n175 17.0005
R5881 AVSS_n3280 AVSS_n179 17.0005
R5882 AVSS_n3280 AVSS_n176 17.0005
R5883 AVSS_n3280 AVSS_n178 17.0005
R5884 AVSS_n199 AVSS_n178 17.0005
R5885 AVSS_n3232 AVSS_n199 17.0005
R5886 AVSS_n199 AVSS_n193 17.0005
R5887 AVSS_n199 AVSS_n198 17.0005
R5888 AVSS_n203 AVSS_n199 17.0005
R5889 AVSS_n3230 AVSS_n199 17.0005
R5890 AVSS_n204 AVSS_n199 17.0005
R5891 AVSS_n199 AVSS_n197 17.0005
R5892 AVSS_n199 AVSS_n195 17.0005
R5893 AVSS_n199 AVSS_n196 17.0005
R5894 AVSS_n222 AVSS_n196 17.0005
R5895 AVSS_n3223 AVSS_n222 17.0005
R5896 AVSS_n3221 AVSS_n222 17.0005
R5897 AVSS_n227 AVSS_n222 17.0005
R5898 AVSS_n2913 AVSS_n222 17.0005
R5899 AVSS_n228 AVSS_n222 17.0005
R5900 AVSS_n2912 AVSS_n222 17.0005
R5901 AVSS_n229 AVSS_n222 17.0005
R5902 AVSS_n2911 AVSS_n222 17.0005
R5903 AVSS_n230 AVSS_n222 17.0005
R5904 AVSS_n2910 AVSS_n222 17.0005
R5905 AVSS_n231 AVSS_n222 17.0005
R5906 AVSS_n2908 AVSS_n222 17.0005
R5907 AVSS_n232 AVSS_n222 17.0005
R5908 AVSS_n2907 AVSS_n222 17.0005
R5909 AVSS_n233 AVSS_n222 17.0005
R5910 AVSS_n2906 AVSS_n222 17.0005
R5911 AVSS_n234 AVSS_n222 17.0005
R5912 AVSS_n2905 AVSS_n222 17.0005
R5913 AVSS_n235 AVSS_n222 17.0005
R5914 AVSS_n2904 AVSS_n222 17.0005
R5915 AVSS_n236 AVSS_n222 17.0005
R5916 AVSS_n2903 AVSS_n222 17.0005
R5917 AVSS_n237 AVSS_n222 17.0005
R5918 AVSS_n2901 AVSS_n222 17.0005
R5919 AVSS_n238 AVSS_n222 17.0005
R5920 AVSS_n2900 AVSS_n222 17.0005
R5921 AVSS_n239 AVSS_n222 17.0005
R5922 AVSS_n2899 AVSS_n222 17.0005
R5923 AVSS_n240 AVSS_n222 17.0005
R5924 AVSS_n2898 AVSS_n222 17.0005
R5925 AVSS_n241 AVSS_n222 17.0005
R5926 AVSS_n2897 AVSS_n222 17.0005
R5927 AVSS_n242 AVSS_n222 17.0005
R5928 AVSS_n2895 AVSS_n222 17.0005
R5929 AVSS_n243 AVSS_n222 17.0005
R5930 AVSS_n2894 AVSS_n222 17.0005
R5931 AVSS_n244 AVSS_n222 17.0005
R5932 AVSS_n2893 AVSS_n222 17.0005
R5933 AVSS_n247 AVSS_n222 17.0005
R5934 AVSS_n2891 AVSS_n222 17.0005
R5935 AVSS_n248 AVSS_n222 17.0005
R5936 AVSS_n2890 AVSS_n222 17.0005
R5937 AVSS_n249 AVSS_n222 17.0005
R5938 AVSS_n2889 AVSS_n222 17.0005
R5939 AVSS_n250 AVSS_n222 17.0005
R5940 AVSS_n2888 AVSS_n222 17.0005
R5941 AVSS_n251 AVSS_n222 17.0005
R5942 AVSS_n2886 AVSS_n222 17.0005
R5943 AVSS_n252 AVSS_n222 17.0005
R5944 AVSS_n2885 AVSS_n222 17.0005
R5945 AVSS_n253 AVSS_n222 17.0005
R5946 AVSS_n2884 AVSS_n222 17.0005
R5947 AVSS_n254 AVSS_n222 17.0005
R5948 AVSS_n2883 AVSS_n222 17.0005
R5949 AVSS_n255 AVSS_n222 17.0005
R5950 AVSS_n2882 AVSS_n222 17.0005
R5951 AVSS_n256 AVSS_n222 17.0005
R5952 AVSS_n2881 AVSS_n222 17.0005
R5953 AVSS_n257 AVSS_n222 17.0005
R5954 AVSS_n2879 AVSS_n222 17.0005
R5955 AVSS_n258 AVSS_n222 17.0005
R5956 AVSS_n2878 AVSS_n222 17.0005
R5957 AVSS_n259 AVSS_n222 17.0005
R5958 AVSS_n2877 AVSS_n222 17.0005
R5959 AVSS_n260 AVSS_n222 17.0005
R5960 AVSS_n2876 AVSS_n222 17.0005
R5961 AVSS_n261 AVSS_n222 17.0005
R5962 AVSS_n2875 AVSS_n222 17.0005
R5963 AVSS_n262 AVSS_n222 17.0005
R5964 AVSS_n2873 AVSS_n222 17.0005
R5965 AVSS_n263 AVSS_n222 17.0005
R5966 AVSS_n2872 AVSS_n222 17.0005
R5967 AVSS_n264 AVSS_n222 17.0005
R5968 AVSS_n2871 AVSS_n222 17.0005
R5969 AVSS_n265 AVSS_n222 17.0005
R5970 AVSS_n2870 AVSS_n222 17.0005
R5971 AVSS_n266 AVSS_n222 17.0005
R5972 AVSS_n2869 AVSS_n222 17.0005
R5973 AVSS_n267 AVSS_n222 17.0005
R5974 AVSS_n2868 AVSS_n222 17.0005
R5975 AVSS_n268 AVSS_n222 17.0005
R5976 AVSS_n2866 AVSS_n222 17.0005
R5977 AVSS_n269 AVSS_n222 17.0005
R5978 AVSS_n2865 AVSS_n222 17.0005
R5979 AVSS_n270 AVSS_n222 17.0005
R5980 AVSS_n2864 AVSS_n222 17.0005
R5981 AVSS_n271 AVSS_n222 17.0005
R5982 AVSS_n2863 AVSS_n222 17.0005
R5983 AVSS_n272 AVSS_n222 17.0005
R5984 AVSS_n2862 AVSS_n222 17.0005
R5985 AVSS_n273 AVSS_n222 17.0005
R5986 AVSS_n2860 AVSS_n222 17.0005
R5987 AVSS_n274 AVSS_n222 17.0005
R5988 AVSS_n2859 AVSS_n222 17.0005
R5989 AVSS_n275 AVSS_n222 17.0005
R5990 AVSS_n2858 AVSS_n222 17.0005
R5991 AVSS_n276 AVSS_n222 17.0005
R5992 AVSS_n2857 AVSS_n222 17.0005
R5993 AVSS_n277 AVSS_n222 17.0005
R5994 AVSS_n2856 AVSS_n222 17.0005
R5995 AVSS_n278 AVSS_n222 17.0005
R5996 AVSS_n2855 AVSS_n222 17.0005
R5997 AVSS_n279 AVSS_n222 17.0005
R5998 AVSS_n2853 AVSS_n222 17.0005
R5999 AVSS_n280 AVSS_n222 17.0005
R6000 AVSS_n2852 AVSS_n222 17.0005
R6001 AVSS_n281 AVSS_n222 17.0005
R6002 AVSS_n2851 AVSS_n222 17.0005
R6003 AVSS_n282 AVSS_n222 17.0005
R6004 AVSS_n2850 AVSS_n222 17.0005
R6005 AVSS_n283 AVSS_n222 17.0005
R6006 AVSS_n2849 AVSS_n222 17.0005
R6007 AVSS_n284 AVSS_n222 17.0005
R6008 AVSS_n2847 AVSS_n222 17.0005
R6009 AVSS_n285 AVSS_n222 17.0005
R6010 AVSS_n2846 AVSS_n222 17.0005
R6011 AVSS_n286 AVSS_n222 17.0005
R6012 AVSS_n2845 AVSS_n222 17.0005
R6013 AVSS_n2843 AVSS_n222 17.0005
R6014 AVSS_n287 AVSS_n222 17.0005
R6015 AVSS_n2842 AVSS_n222 17.0005
R6016 AVSS_n288 AVSS_n222 17.0005
R6017 AVSS_n2841 AVSS_n222 17.0005
R6018 AVSS_n289 AVSS_n222 17.0005
R6019 AVSS_n2840 AVSS_n222 17.0005
R6020 AVSS_n290 AVSS_n222 17.0005
R6021 AVSS_n2839 AVSS_n222 17.0005
R6022 AVSS_n291 AVSS_n222 17.0005
R6023 AVSS_n2837 AVSS_n222 17.0005
R6024 AVSS_n292 AVSS_n222 17.0005
R6025 AVSS_n2836 AVSS_n222 17.0005
R6026 AVSS_n293 AVSS_n222 17.0005
R6027 AVSS_n2835 AVSS_n222 17.0005
R6028 AVSS_n294 AVSS_n222 17.0005
R6029 AVSS_n2834 AVSS_n222 17.0005
R6030 AVSS_n295 AVSS_n222 17.0005
R6031 AVSS_n2833 AVSS_n222 17.0005
R6032 AVSS_n296 AVSS_n222 17.0005
R6033 AVSS_n2832 AVSS_n222 17.0005
R6034 AVSS_n297 AVSS_n222 17.0005
R6035 AVSS_n2830 AVSS_n222 17.0005
R6036 AVSS_n298 AVSS_n222 17.0005
R6037 AVSS_n2829 AVSS_n222 17.0005
R6038 AVSS_n299 AVSS_n222 17.0005
R6039 AVSS_n2828 AVSS_n222 17.0005
R6040 AVSS_n300 AVSS_n222 17.0005
R6041 AVSS_n2827 AVSS_n222 17.0005
R6042 AVSS_n301 AVSS_n222 17.0005
R6043 AVSS_n2826 AVSS_n222 17.0005
R6044 AVSS_n302 AVSS_n222 17.0005
R6045 AVSS_n2824 AVSS_n222 17.0005
R6046 AVSS_n303 AVSS_n222 17.0005
R6047 AVSS_n2823 AVSS_n222 17.0005
R6048 AVSS_n304 AVSS_n222 17.0005
R6049 AVSS_n2822 AVSS_n222 17.0005
R6050 AVSS_n305 AVSS_n222 17.0005
R6051 AVSS_n2821 AVSS_n222 17.0005
R6052 AVSS_n31 AVSS_n12 17.0005
R6053 AVSS_n3492 AVSS_n31 17.0005
R6054 AVSS_n31 AVSS_n13 17.0005
R6055 AVSS_n31 AVSS_n23 17.0005
R6056 AVSS_n31 AVSS_n15 17.0005
R6057 AVSS_n31 AVSS_n20 17.0005
R6058 AVSS_n31 AVSS_n16 17.0005
R6059 AVSS_n31 AVSS_n19 17.0005
R6060 AVSS_n31 AVSS_n17 17.0005
R6061 AVSS_n31 AVSS_n18 17.0005
R6062 AVSS_n3476 AVSS_n18 17.0005
R6063 AVSS_n3476 AVSS_n3475 17.0005
R6064 AVSS_n3476 AVSS_n39 17.0005
R6065 AVSS_n3476 AVSS_n85 17.0005
R6066 AVSS_n3476 AVSS_n40 17.0005
R6067 AVSS_n3476 AVSS_n84 17.0005
R6068 AVSS_n3476 AVSS_n41 17.0005
R6069 AVSS_n3476 AVSS_n83 17.0005
R6070 AVSS_n3476 AVSS_n43 17.0005
R6071 AVSS_n3476 AVSS_n81 17.0005
R6072 AVSS_n3476 AVSS_n44 17.0005
R6073 AVSS_n3476 AVSS_n80 17.0005
R6074 AVSS_n3476 AVSS_n45 17.0005
R6075 AVSS_n3476 AVSS_n79 17.0005
R6076 AVSS_n3476 AVSS_n46 17.0005
R6077 AVSS_n3476 AVSS_n78 17.0005
R6078 AVSS_n3476 AVSS_n47 17.0005
R6079 AVSS_n3476 AVSS_n76 17.0005
R6080 AVSS_n3476 AVSS_n48 17.0005
R6081 AVSS_n3476 AVSS_n75 17.0005
R6082 AVSS_n3476 AVSS_n49 17.0005
R6083 AVSS_n3476 AVSS_n73 17.0005
R6084 AVSS_n3476 AVSS_n50 17.0005
R6085 AVSS_n3476 AVSS_n72 17.0005
R6086 AVSS_n3476 AVSS_n51 17.0005
R6087 AVSS_n3476 AVSS_n52 17.0005
R6088 AVSS_n3476 AVSS_n70 17.0005
R6089 AVSS_n3476 AVSS_n53 17.0005
R6090 AVSS_n3476 AVSS_n69 17.0005
R6091 AVSS_n3476 AVSS_n54 17.0005
R6092 AVSS_n3476 AVSS_n68 17.0005
R6093 AVSS_n3476 AVSS_n55 17.0005
R6094 AVSS_n3476 AVSS_n67 17.0005
R6095 AVSS_n3476 AVSS_n56 17.0005
R6096 AVSS_n3476 AVSS_n66 17.0005
R6097 AVSS_n3476 AVSS_n57 17.0005
R6098 AVSS_n3476 AVSS_n64 17.0005
R6099 AVSS_n3476 AVSS_n58 17.0005
R6100 AVSS_n3476 AVSS_n63 17.0005
R6101 AVSS_n3476 AVSS_n59 17.0005
R6102 AVSS_n3476 AVSS_n61 17.0005
R6103 AVSS_n3476 AVSS_n9 17.0005
R6104 AVSS_n3315 AVSS_n9 17.0005
R6105 AVSS_n3315 AVSS_n141 17.0005
R6106 AVSS_n3417 AVSS_n3315 17.0005
R6107 AVSS_n3315 AVSS_n142 17.0005
R6108 AVSS_n3315 AVSS_n3279 17.0005
R6109 AVSS_n3315 AVSS_n143 17.0005
R6110 AVSS_n3315 AVSS_n3278 17.0005
R6111 AVSS_n3315 AVSS_n144 17.0005
R6112 AVSS_n3315 AVSS_n3277 17.0005
R6113 AVSS_n3315 AVSS_n145 17.0005
R6114 AVSS_n3315 AVSS_n3276 17.0005
R6115 AVSS_n3315 AVSS_n146 17.0005
R6116 AVSS_n3315 AVSS_n3275 17.0005
R6117 AVSS_n3315 AVSS_n147 17.0005
R6118 AVSS_n3315 AVSS_n3274 17.0005
R6119 AVSS_n3315 AVSS_n148 17.0005
R6120 AVSS_n3315 AVSS_n3273 17.0005
R6121 AVSS_n3315 AVSS_n149 17.0005
R6122 AVSS_n3315 AVSS_n3272 17.0005
R6123 AVSS_n3315 AVSS_n150 17.0005
R6124 AVSS_n3315 AVSS_n3271 17.0005
R6125 AVSS_n3315 AVSS_n151 17.0005
R6126 AVSS_n3315 AVSS_n3270 17.0005
R6127 AVSS_n3315 AVSS_n152 17.0005
R6128 AVSS_n3315 AVSS_n3269 17.0005
R6129 AVSS_n3315 AVSS_n153 17.0005
R6130 AVSS_n3315 AVSS_n3268 17.0005
R6131 AVSS_n3315 AVSS_n154 17.0005
R6132 AVSS_n3315 AVSS_n3267 17.0005
R6133 AVSS_n3315 AVSS_n155 17.0005
R6134 AVSS_n3315 AVSS_n3266 17.0005
R6135 AVSS_n3315 AVSS_n156 17.0005
R6136 AVSS_n3315 AVSS_n3265 17.0005
R6137 AVSS_n3315 AVSS_n157 17.0005
R6138 AVSS_n3315 AVSS_n3264 17.0005
R6139 AVSS_n3315 AVSS_n158 17.0005
R6140 AVSS_n3315 AVSS_n3263 17.0005
R6141 AVSS_n3315 AVSS_n159 17.0005
R6142 AVSS_n3315 AVSS_n3262 17.0005
R6143 AVSS_n3315 AVSS_n160 17.0005
R6144 AVSS_n3315 AVSS_n3261 17.0005
R6145 AVSS_n3315 AVSS_n161 17.0005
R6146 AVSS_n3315 AVSS_n3260 17.0005
R6147 AVSS_n3315 AVSS_n162 17.0005
R6148 AVSS_n3315 AVSS_n3259 17.0005
R6149 AVSS_n3315 AVSS_n163 17.0005
R6150 AVSS_n3315 AVSS_n3258 17.0005
R6151 AVSS_n3315 AVSS_n3257 17.0005
R6152 AVSS_n3315 AVSS_n164 17.0005
R6153 AVSS_n3315 AVSS_n3256 17.0005
R6154 AVSS_n3315 AVSS_n165 17.0005
R6155 AVSS_n3315 AVSS_n3255 17.0005
R6156 AVSS_n3315 AVSS_n166 17.0005
R6157 AVSS_n3315 AVSS_n3254 17.0005
R6158 AVSS_n3315 AVSS_n167 17.0005
R6159 AVSS_n3315 AVSS_n3253 17.0005
R6160 AVSS_n3315 AVSS_n168 17.0005
R6161 AVSS_n3315 AVSS_n3252 17.0005
R6162 AVSS_n3315 AVSS_n169 17.0005
R6163 AVSS_n3315 AVSS_n3251 17.0005
R6164 AVSS_n3315 AVSS_n170 17.0005
R6165 AVSS_n3315 AVSS_n184 17.0005
R6166 AVSS_n3315 AVSS_n171 17.0005
R6167 AVSS_n3315 AVSS_n183 17.0005
R6168 AVSS_n3315 AVSS_n172 17.0005
R6169 AVSS_n3315 AVSS_n182 17.0005
R6170 AVSS_n3315 AVSS_n173 17.0005
R6171 AVSS_n3315 AVSS_n181 17.0005
R6172 AVSS_n3315 AVSS_n174 17.0005
R6173 AVSS_n3315 AVSS_n180 17.0005
R6174 AVSS_n3315 AVSS_n175 17.0005
R6175 AVSS_n3315 AVSS_n179 17.0005
R6176 AVSS_n3315 AVSS_n176 17.0005
R6177 AVSS_n3315 AVSS_n178 17.0005
R6178 AVSS_n3233 AVSS_n178 17.0005
R6179 AVSS_n3234 AVSS_n3233 17.0005
R6180 AVSS_n3233 AVSS_n3232 17.0005
R6181 AVSS_n3233 AVSS_n193 17.0005
R6182 AVSS_n3233 AVSS_n198 17.0005
R6183 AVSS_n3233 AVSS_n197 17.0005
R6184 AVSS_n3233 AVSS_n195 17.0005
R6185 AVSS_n3233 AVSS_n196 17.0005
R6186 AVSS_n225 AVSS_n196 17.0005
R6187 AVSS_n3223 AVSS_n225 17.0005
R6188 AVSS_n3221 AVSS_n225 17.0005
R6189 AVSS_n227 AVSS_n225 17.0005
R6190 AVSS_n2913 AVSS_n225 17.0005
R6191 AVSS_n228 AVSS_n225 17.0005
R6192 AVSS_n2912 AVSS_n225 17.0005
R6193 AVSS_n229 AVSS_n225 17.0005
R6194 AVSS_n2911 AVSS_n225 17.0005
R6195 AVSS_n230 AVSS_n225 17.0005
R6196 AVSS_n2910 AVSS_n225 17.0005
R6197 AVSS_n231 AVSS_n225 17.0005
R6198 AVSS_n2908 AVSS_n225 17.0005
R6199 AVSS_n232 AVSS_n225 17.0005
R6200 AVSS_n2907 AVSS_n225 17.0005
R6201 AVSS_n233 AVSS_n225 17.0005
R6202 AVSS_n2906 AVSS_n225 17.0005
R6203 AVSS_n234 AVSS_n225 17.0005
R6204 AVSS_n2905 AVSS_n225 17.0005
R6205 AVSS_n235 AVSS_n225 17.0005
R6206 AVSS_n2904 AVSS_n225 17.0005
R6207 AVSS_n236 AVSS_n225 17.0005
R6208 AVSS_n2903 AVSS_n225 17.0005
R6209 AVSS_n237 AVSS_n225 17.0005
R6210 AVSS_n2901 AVSS_n225 17.0005
R6211 AVSS_n238 AVSS_n225 17.0005
R6212 AVSS_n2900 AVSS_n225 17.0005
R6213 AVSS_n239 AVSS_n225 17.0005
R6214 AVSS_n2899 AVSS_n225 17.0005
R6215 AVSS_n240 AVSS_n225 17.0005
R6216 AVSS_n2898 AVSS_n225 17.0005
R6217 AVSS_n241 AVSS_n225 17.0005
R6218 AVSS_n2897 AVSS_n225 17.0005
R6219 AVSS_n242 AVSS_n225 17.0005
R6220 AVSS_n2895 AVSS_n225 17.0005
R6221 AVSS_n243 AVSS_n225 17.0005
R6222 AVSS_n2894 AVSS_n225 17.0005
R6223 AVSS_n244 AVSS_n225 17.0005
R6224 AVSS_n2893 AVSS_n225 17.0005
R6225 AVSS_n247 AVSS_n225 17.0005
R6226 AVSS_n2891 AVSS_n225 17.0005
R6227 AVSS_n248 AVSS_n225 17.0005
R6228 AVSS_n2890 AVSS_n225 17.0005
R6229 AVSS_n249 AVSS_n225 17.0005
R6230 AVSS_n2889 AVSS_n225 17.0005
R6231 AVSS_n250 AVSS_n225 17.0005
R6232 AVSS_n2888 AVSS_n225 17.0005
R6233 AVSS_n251 AVSS_n225 17.0005
R6234 AVSS_n2886 AVSS_n225 17.0005
R6235 AVSS_n252 AVSS_n225 17.0005
R6236 AVSS_n2885 AVSS_n225 17.0005
R6237 AVSS_n253 AVSS_n225 17.0005
R6238 AVSS_n2884 AVSS_n225 17.0005
R6239 AVSS_n254 AVSS_n225 17.0005
R6240 AVSS_n2883 AVSS_n225 17.0005
R6241 AVSS_n255 AVSS_n225 17.0005
R6242 AVSS_n2882 AVSS_n225 17.0005
R6243 AVSS_n256 AVSS_n225 17.0005
R6244 AVSS_n2881 AVSS_n225 17.0005
R6245 AVSS_n257 AVSS_n225 17.0005
R6246 AVSS_n2879 AVSS_n225 17.0005
R6247 AVSS_n258 AVSS_n225 17.0005
R6248 AVSS_n2878 AVSS_n225 17.0005
R6249 AVSS_n259 AVSS_n225 17.0005
R6250 AVSS_n2877 AVSS_n225 17.0005
R6251 AVSS_n260 AVSS_n225 17.0005
R6252 AVSS_n2876 AVSS_n225 17.0005
R6253 AVSS_n261 AVSS_n225 17.0005
R6254 AVSS_n2875 AVSS_n225 17.0005
R6255 AVSS_n262 AVSS_n225 17.0005
R6256 AVSS_n2873 AVSS_n225 17.0005
R6257 AVSS_n263 AVSS_n225 17.0005
R6258 AVSS_n2872 AVSS_n225 17.0005
R6259 AVSS_n264 AVSS_n225 17.0005
R6260 AVSS_n2871 AVSS_n225 17.0005
R6261 AVSS_n265 AVSS_n225 17.0005
R6262 AVSS_n2870 AVSS_n225 17.0005
R6263 AVSS_n266 AVSS_n225 17.0005
R6264 AVSS_n2869 AVSS_n225 17.0005
R6265 AVSS_n267 AVSS_n225 17.0005
R6266 AVSS_n2868 AVSS_n225 17.0005
R6267 AVSS_n268 AVSS_n225 17.0005
R6268 AVSS_n2866 AVSS_n225 17.0005
R6269 AVSS_n269 AVSS_n225 17.0005
R6270 AVSS_n2865 AVSS_n225 17.0005
R6271 AVSS_n270 AVSS_n225 17.0005
R6272 AVSS_n2864 AVSS_n225 17.0005
R6273 AVSS_n271 AVSS_n225 17.0005
R6274 AVSS_n2863 AVSS_n225 17.0005
R6275 AVSS_n272 AVSS_n225 17.0005
R6276 AVSS_n2862 AVSS_n225 17.0005
R6277 AVSS_n273 AVSS_n225 17.0005
R6278 AVSS_n2860 AVSS_n225 17.0005
R6279 AVSS_n274 AVSS_n225 17.0005
R6280 AVSS_n2859 AVSS_n225 17.0005
R6281 AVSS_n275 AVSS_n225 17.0005
R6282 AVSS_n2858 AVSS_n225 17.0005
R6283 AVSS_n276 AVSS_n225 17.0005
R6284 AVSS_n2857 AVSS_n225 17.0005
R6285 AVSS_n277 AVSS_n225 17.0005
R6286 AVSS_n2856 AVSS_n225 17.0005
R6287 AVSS_n278 AVSS_n225 17.0005
R6288 AVSS_n2855 AVSS_n225 17.0005
R6289 AVSS_n279 AVSS_n225 17.0005
R6290 AVSS_n2853 AVSS_n225 17.0005
R6291 AVSS_n280 AVSS_n225 17.0005
R6292 AVSS_n2852 AVSS_n225 17.0005
R6293 AVSS_n281 AVSS_n225 17.0005
R6294 AVSS_n2851 AVSS_n225 17.0005
R6295 AVSS_n282 AVSS_n225 17.0005
R6296 AVSS_n2850 AVSS_n225 17.0005
R6297 AVSS_n283 AVSS_n225 17.0005
R6298 AVSS_n2849 AVSS_n225 17.0005
R6299 AVSS_n284 AVSS_n225 17.0005
R6300 AVSS_n2847 AVSS_n225 17.0005
R6301 AVSS_n285 AVSS_n225 17.0005
R6302 AVSS_n2846 AVSS_n225 17.0005
R6303 AVSS_n286 AVSS_n225 17.0005
R6304 AVSS_n2845 AVSS_n225 17.0005
R6305 AVSS_n2843 AVSS_n225 17.0005
R6306 AVSS_n287 AVSS_n225 17.0005
R6307 AVSS_n2842 AVSS_n225 17.0005
R6308 AVSS_n288 AVSS_n225 17.0005
R6309 AVSS_n2841 AVSS_n225 17.0005
R6310 AVSS_n289 AVSS_n225 17.0005
R6311 AVSS_n2840 AVSS_n225 17.0005
R6312 AVSS_n290 AVSS_n225 17.0005
R6313 AVSS_n2839 AVSS_n225 17.0005
R6314 AVSS_n291 AVSS_n225 17.0005
R6315 AVSS_n2837 AVSS_n225 17.0005
R6316 AVSS_n292 AVSS_n225 17.0005
R6317 AVSS_n2836 AVSS_n225 17.0005
R6318 AVSS_n293 AVSS_n225 17.0005
R6319 AVSS_n2835 AVSS_n225 17.0005
R6320 AVSS_n294 AVSS_n225 17.0005
R6321 AVSS_n2834 AVSS_n225 17.0005
R6322 AVSS_n295 AVSS_n225 17.0005
R6323 AVSS_n2833 AVSS_n225 17.0005
R6324 AVSS_n296 AVSS_n225 17.0005
R6325 AVSS_n2832 AVSS_n225 17.0005
R6326 AVSS_n297 AVSS_n225 17.0005
R6327 AVSS_n2830 AVSS_n225 17.0005
R6328 AVSS_n298 AVSS_n225 17.0005
R6329 AVSS_n2829 AVSS_n225 17.0005
R6330 AVSS_n299 AVSS_n225 17.0005
R6331 AVSS_n2828 AVSS_n225 17.0005
R6332 AVSS_n300 AVSS_n225 17.0005
R6333 AVSS_n2827 AVSS_n225 17.0005
R6334 AVSS_n301 AVSS_n225 17.0005
R6335 AVSS_n2826 AVSS_n225 17.0005
R6336 AVSS_n302 AVSS_n225 17.0005
R6337 AVSS_n2824 AVSS_n225 17.0005
R6338 AVSS_n303 AVSS_n225 17.0005
R6339 AVSS_n2823 AVSS_n225 17.0005
R6340 AVSS_n304 AVSS_n225 17.0005
R6341 AVSS_n2822 AVSS_n225 17.0005
R6342 AVSS_n305 AVSS_n225 17.0005
R6343 AVSS_n2821 AVSS_n225 17.0005
R6344 AVSS_n26 AVSS_n12 17.0005
R6345 AVSS_n3492 AVSS_n26 17.0005
R6346 AVSS_n26 AVSS_n13 17.0005
R6347 AVSS_n26 AVSS_n22 17.0005
R6348 AVSS_n26 AVSS_n15 17.0005
R6349 AVSS_n26 AVSS_n20 17.0005
R6350 AVSS_n26 AVSS_n16 17.0005
R6351 AVSS_n26 AVSS_n19 17.0005
R6352 AVSS_n26 AVSS_n17 17.0005
R6353 AVSS_n26 AVSS_n18 17.0005
R6354 AVSS_n34 AVSS_n18 17.0005
R6355 AVSS_n3478 AVSS_n34 17.0005
R6356 AVSS_n85 AVSS_n34 17.0005
R6357 AVSS_n40 AVSS_n34 17.0005
R6358 AVSS_n84 AVSS_n34 17.0005
R6359 AVSS_n3470 AVSS_n34 17.0005
R6360 AVSS_n43 AVSS_n34 17.0005
R6361 AVSS_n81 AVSS_n34 17.0005
R6362 AVSS_n44 AVSS_n34 17.0005
R6363 AVSS_n80 AVSS_n34 17.0005
R6364 AVSS_n45 AVSS_n34 17.0005
R6365 AVSS_n79 AVSS_n34 17.0005
R6366 AVSS_n46 AVSS_n34 17.0005
R6367 AVSS_n76 AVSS_n34 17.0005
R6368 AVSS_n49 AVSS_n34 17.0005
R6369 AVSS_n73 AVSS_n34 17.0005
R6370 AVSS_n50 AVSS_n34 17.0005
R6371 AVSS_n52 AVSS_n34 17.0005
R6372 AVSS_n70 AVSS_n34 17.0005
R6373 AVSS_n53 AVSS_n34 17.0005
R6374 AVSS_n69 AVSS_n34 17.0005
R6375 AVSS_n54 AVSS_n34 17.0005
R6376 AVSS_n68 AVSS_n34 17.0005
R6377 AVSS_n55 AVSS_n34 17.0005
R6378 AVSS_n67 AVSS_n34 17.0005
R6379 AVSS_n57 AVSS_n34 17.0005
R6380 AVSS_n64 AVSS_n34 17.0005
R6381 AVSS_n58 AVSS_n34 17.0005
R6382 AVSS_n3368 AVSS_n9 17.0005
R6383 AVSS_n3368 AVSS_n141 17.0005
R6384 AVSS_n3368 AVSS_n3279 17.0005
R6385 AVSS_n3368 AVSS_n143 17.0005
R6386 AVSS_n3368 AVSS_n3278 17.0005
R6387 AVSS_n3368 AVSS_n145 17.0005
R6388 AVSS_n3368 AVSS_n3276 17.0005
R6389 AVSS_n3368 AVSS_n146 17.0005
R6390 AVSS_n3368 AVSS_n3275 17.0005
R6391 AVSS_n3368 AVSS_n147 17.0005
R6392 AVSS_n3368 AVSS_n3274 17.0005
R6393 AVSS_n3368 AVSS_n148 17.0005
R6394 AVSS_n3368 AVSS_n3273 17.0005
R6395 AVSS_n3368 AVSS_n149 17.0005
R6396 AVSS_n3368 AVSS_n3271 17.0005
R6397 AVSS_n3368 AVSS_n151 17.0005
R6398 AVSS_n3368 AVSS_n3270 17.0005
R6399 AVSS_n3368 AVSS_n152 17.0005
R6400 AVSS_n3368 AVSS_n3269 17.0005
R6401 AVSS_n3368 AVSS_n153 17.0005
R6402 AVSS_n3368 AVSS_n3268 17.0005
R6403 AVSS_n3368 AVSS_n154 17.0005
R6404 AVSS_n3368 AVSS_n3267 17.0005
R6405 AVSS_n3368 AVSS_n156 17.0005
R6406 AVSS_n3368 AVSS_n3265 17.0005
R6407 AVSS_n3368 AVSS_n157 17.0005
R6408 AVSS_n3368 AVSS_n3264 17.0005
R6409 AVSS_n3368 AVSS_n158 17.0005
R6410 AVSS_n3368 AVSS_n3263 17.0005
R6411 AVSS_n3368 AVSS_n159 17.0005
R6412 AVSS_n3368 AVSS_n3262 17.0005
R6413 AVSS_n3368 AVSS_n160 17.0005
R6414 AVSS_n3368 AVSS_n3260 17.0005
R6415 AVSS_n3368 AVSS_n162 17.0005
R6416 AVSS_n3368 AVSS_n3259 17.0005
R6417 AVSS_n3368 AVSS_n3257 17.0005
R6418 AVSS_n3368 AVSS_n164 17.0005
R6419 AVSS_n3368 AVSS_n3256 17.0005
R6420 AVSS_n3368 AVSS_n165 17.0005
R6421 AVSS_n3368 AVSS_n3255 17.0005
R6422 AVSS_n3368 AVSS_n166 17.0005
R6423 AVSS_n3368 AVSS_n3254 17.0005
R6424 AVSS_n3368 AVSS_n167 17.0005
R6425 AVSS_n3368 AVSS_n3252 17.0005
R6426 AVSS_n3368 AVSS_n169 17.0005
R6427 AVSS_n3368 AVSS_n3251 17.0005
R6428 AVSS_n3368 AVSS_n170 17.0005
R6429 AVSS_n3368 AVSS_n184 17.0005
R6430 AVSS_n3368 AVSS_n171 17.0005
R6431 AVSS_n3368 AVSS_n183 17.0005
R6432 AVSS_n3368 AVSS_n173 17.0005
R6433 AVSS_n3368 AVSS_n181 17.0005
R6434 AVSS_n3368 AVSS_n174 17.0005
R6435 AVSS_n3368 AVSS_n180 17.0005
R6436 AVSS_n3368 AVSS_n175 17.0005
R6437 AVSS_n3368 AVSS_n179 17.0005
R6438 AVSS_n188 AVSS_n178 17.0005
R6439 AVSS_n3234 AVSS_n188 17.0005
R6440 AVSS_n3232 AVSS_n188 17.0005
R6441 AVSS_n193 AVSS_n188 17.0005
R6442 AVSS_n3230 AVSS_n188 17.0005
R6443 AVSS_n197 AVSS_n188 17.0005
R6444 AVSS_n195 AVSS_n188 17.0005
R6445 AVSS_n196 AVSS_n188 17.0005
R6446 AVSS_n223 AVSS_n196 17.0005
R6447 AVSS_n3223 AVSS_n223 17.0005
R6448 AVSS_n3221 AVSS_n223 17.0005
R6449 AVSS_n227 AVSS_n223 17.0005
R6450 AVSS_n2913 AVSS_n223 17.0005
R6451 AVSS_n228 AVSS_n223 17.0005
R6452 AVSS_n2912 AVSS_n223 17.0005
R6453 AVSS_n229 AVSS_n223 17.0005
R6454 AVSS_n2911 AVSS_n223 17.0005
R6455 AVSS_n230 AVSS_n223 17.0005
R6456 AVSS_n2908 AVSS_n223 17.0005
R6457 AVSS_n232 AVSS_n223 17.0005
R6458 AVSS_n2907 AVSS_n223 17.0005
R6459 AVSS_n233 AVSS_n223 17.0005
R6460 AVSS_n2906 AVSS_n223 17.0005
R6461 AVSS_n234 AVSS_n223 17.0005
R6462 AVSS_n2905 AVSS_n223 17.0005
R6463 AVSS_n235 AVSS_n223 17.0005
R6464 AVSS_n2904 AVSS_n223 17.0005
R6465 AVSS_n237 AVSS_n223 17.0005
R6466 AVSS_n2901 AVSS_n223 17.0005
R6467 AVSS_n238 AVSS_n223 17.0005
R6468 AVSS_n2900 AVSS_n223 17.0005
R6469 AVSS_n239 AVSS_n223 17.0005
R6470 AVSS_n2899 AVSS_n223 17.0005
R6471 AVSS_n240 AVSS_n223 17.0005
R6472 AVSS_n2898 AVSS_n223 17.0005
R6473 AVSS_n241 AVSS_n223 17.0005
R6474 AVSS_n2895 AVSS_n223 17.0005
R6475 AVSS_n243 AVSS_n223 17.0005
R6476 AVSS_n2894 AVSS_n223 17.0005
R6477 AVSS_n247 AVSS_n223 17.0005
R6478 AVSS_n2891 AVSS_n223 17.0005
R6479 AVSS_n248 AVSS_n223 17.0005
R6480 AVSS_n2890 AVSS_n223 17.0005
R6481 AVSS_n249 AVSS_n223 17.0005
R6482 AVSS_n2889 AVSS_n223 17.0005
R6483 AVSS_n250 AVSS_n223 17.0005
R6484 AVSS_n2886 AVSS_n223 17.0005
R6485 AVSS_n252 AVSS_n223 17.0005
R6486 AVSS_n2885 AVSS_n223 17.0005
R6487 AVSS_n253 AVSS_n223 17.0005
R6488 AVSS_n2884 AVSS_n223 17.0005
R6489 AVSS_n254 AVSS_n223 17.0005
R6490 AVSS_n2883 AVSS_n223 17.0005
R6491 AVSS_n255 AVSS_n223 17.0005
R6492 AVSS_n2882 AVSS_n223 17.0005
R6493 AVSS_n257 AVSS_n223 17.0005
R6494 AVSS_n2879 AVSS_n223 17.0005
R6495 AVSS_n258 AVSS_n223 17.0005
R6496 AVSS_n2878 AVSS_n223 17.0005
R6497 AVSS_n259 AVSS_n223 17.0005
R6498 AVSS_n2877 AVSS_n223 17.0005
R6499 AVSS_n260 AVSS_n223 17.0005
R6500 AVSS_n2876 AVSS_n223 17.0005
R6501 AVSS_n261 AVSS_n223 17.0005
R6502 AVSS_n2873 AVSS_n223 17.0005
R6503 AVSS_n263 AVSS_n223 17.0005
R6504 AVSS_n2872 AVSS_n223 17.0005
R6505 AVSS_n264 AVSS_n223 17.0005
R6506 AVSS_n2871 AVSS_n223 17.0005
R6507 AVSS_n265 AVSS_n223 17.0005
R6508 AVSS_n2870 AVSS_n223 17.0005
R6509 AVSS_n266 AVSS_n223 17.0005
R6510 AVSS_n2869 AVSS_n223 17.0005
R6511 AVSS_n268 AVSS_n223 17.0005
R6512 AVSS_n2866 AVSS_n223 17.0005
R6513 AVSS_n269 AVSS_n223 17.0005
R6514 AVSS_n2865 AVSS_n223 17.0005
R6515 AVSS_n270 AVSS_n223 17.0005
R6516 AVSS_n2864 AVSS_n223 17.0005
R6517 AVSS_n271 AVSS_n223 17.0005
R6518 AVSS_n2863 AVSS_n223 17.0005
R6519 AVSS_n272 AVSS_n223 17.0005
R6520 AVSS_n2860 AVSS_n223 17.0005
R6521 AVSS_n274 AVSS_n223 17.0005
R6522 AVSS_n2859 AVSS_n223 17.0005
R6523 AVSS_n275 AVSS_n223 17.0005
R6524 AVSS_n2858 AVSS_n223 17.0005
R6525 AVSS_n276 AVSS_n223 17.0005
R6526 AVSS_n2857 AVSS_n223 17.0005
R6527 AVSS_n277 AVSS_n223 17.0005
R6528 AVSS_n2856 AVSS_n223 17.0005
R6529 AVSS_n279 AVSS_n223 17.0005
R6530 AVSS_n2853 AVSS_n223 17.0005
R6531 AVSS_n280 AVSS_n223 17.0005
R6532 AVSS_n2852 AVSS_n223 17.0005
R6533 AVSS_n281 AVSS_n223 17.0005
R6534 AVSS_n2851 AVSS_n223 17.0005
R6535 AVSS_n282 AVSS_n223 17.0005
R6536 AVSS_n2850 AVSS_n223 17.0005
R6537 AVSS_n283 AVSS_n223 17.0005
R6538 AVSS_n2847 AVSS_n223 17.0005
R6539 AVSS_n285 AVSS_n223 17.0005
R6540 AVSS_n2846 AVSS_n223 17.0005
R6541 AVSS_n2843 AVSS_n223 17.0005
R6542 AVSS_n287 AVSS_n223 17.0005
R6543 AVSS_n2842 AVSS_n223 17.0005
R6544 AVSS_n288 AVSS_n223 17.0005
R6545 AVSS_n2841 AVSS_n223 17.0005
R6546 AVSS_n289 AVSS_n223 17.0005
R6547 AVSS_n2840 AVSS_n223 17.0005
R6548 AVSS_n290 AVSS_n223 17.0005
R6549 AVSS_n2837 AVSS_n223 17.0005
R6550 AVSS_n292 AVSS_n223 17.0005
R6551 AVSS_n2836 AVSS_n223 17.0005
R6552 AVSS_n293 AVSS_n223 17.0005
R6553 AVSS_n2835 AVSS_n223 17.0005
R6554 AVSS_n294 AVSS_n223 17.0005
R6555 AVSS_n2834 AVSS_n223 17.0005
R6556 AVSS_n295 AVSS_n223 17.0005
R6557 AVSS_n2833 AVSS_n223 17.0005
R6558 AVSS_n297 AVSS_n223 17.0005
R6559 AVSS_n2830 AVSS_n223 17.0005
R6560 AVSS_n298 AVSS_n223 17.0005
R6561 AVSS_n2829 AVSS_n223 17.0005
R6562 AVSS_n299 AVSS_n223 17.0005
R6563 AVSS_n2828 AVSS_n223 17.0005
R6564 AVSS_n300 AVSS_n223 17.0005
R6565 AVSS_n2827 AVSS_n223 17.0005
R6566 AVSS_n301 AVSS_n223 17.0005
R6567 AVSS_n2824 AVSS_n223 17.0005
R6568 AVSS_n303 AVSS_n223 17.0005
R6569 AVSS_n2823 AVSS_n223 17.0005
R6570 AVSS_n304 AVSS_n223 17.0005
R6571 AVSS_n2822 AVSS_n223 17.0005
R6572 AVSS_n305 AVSS_n223 17.0005
R6573 AVSS_n2821 AVSS_n223 17.0005
R6574 AVSS_n2060 AVSS_n2058 17.0005
R6575 AVSS_n2058 AVSS_n18 17.0005
R6576 AVSS_n118 AVSS_n18 17.0005
R6577 AVSS_n118 AVSS_n39 17.0005
R6578 AVSS_n118 AVSS_n83 17.0005
R6579 AVSS_n3470 AVSS_n118 17.0005
R6580 AVSS_n118 AVSS_n47 17.0005
R6581 AVSS_n118 AVSS_n75 17.0005
R6582 AVSS_n118 AVSS_n51 17.0005
R6583 AVSS_n118 AVSS_n66 17.0005
R6584 AVSS_n118 AVSS_n59 17.0005
R6585 AVSS_n118 AVSS_n61 17.0005
R6586 AVSS_n3358 AVSS_n9 17.0005
R6587 AVSS_n3358 AVSS_n142 17.0005
R6588 AVSS_n3358 AVSS_n3277 17.0005
R6589 AVSS_n3358 AVSS_n150 17.0005
R6590 AVSS_n3358 AVSS_n3266 17.0005
R6591 AVSS_n3358 AVSS_n161 17.0005
R6592 AVSS_n3358 AVSS_n3258 17.0005
R6593 AVSS_n3358 AVSS_n168 17.0005
R6594 AVSS_n3358 AVSS_n182 17.0005
R6595 AVSS_n3358 AVSS_n176 17.0005
R6596 AVSS_n215 AVSS_n178 17.0005
R6597 AVSS_n3230 AVSS_n215 17.0005
R6598 AVSS_n3217 AVSS_n196 17.0005
R6599 AVSS_n3217 AVSS_n231 17.0005
R6600 AVSS_n3217 AVSS_n2903 17.0005
R6601 AVSS_n3217 AVSS_n242 17.0005
R6602 AVSS_n3217 AVSS_n2893 17.0005
R6603 AVSS_n3217 AVSS_n251 17.0005
R6604 AVSS_n3217 AVSS_n2881 17.0005
R6605 AVSS_n3217 AVSS_n262 17.0005
R6606 AVSS_n3217 AVSS_n2868 17.0005
R6607 AVSS_n3217 AVSS_n273 17.0005
R6608 AVSS_n3217 AVSS_n2855 17.0005
R6609 AVSS_n3217 AVSS_n284 17.0005
R6610 AVSS_n3217 AVSS_n2845 17.0005
R6611 AVSS_n3217 AVSS_n291 17.0005
R6612 AVSS_n3217 AVSS_n2832 17.0005
R6613 AVSS_n3217 AVSS_n302 17.0005
R6614 AVSS_n2062 AVSS_n23 17.0005
R6615 AVSS_n2062 AVSS_n22 17.0005
R6616 AVSS_n3475 AVSS_n3473 17.0005
R6617 AVSS_n3473 AVSS_n41 17.0005
R6618 AVSS_n3473 AVSS_n78 17.0005
R6619 AVSS_n3473 AVSS_n48 17.0005
R6620 AVSS_n3473 AVSS_n72 17.0005
R6621 AVSS_n3473 AVSS_n56 17.0005
R6622 AVSS_n3473 AVSS_n63 17.0005
R6623 AVSS_n3417 AVSS_n3312 17.0005
R6624 AVSS_n3312 AVSS_n144 17.0005
R6625 AVSS_n3312 AVSS_n3272 17.0005
R6626 AVSS_n3312 AVSS_n155 17.0005
R6627 AVSS_n3312 AVSS_n3261 17.0005
R6628 AVSS_n3312 AVSS_n163 17.0005
R6629 AVSS_n3312 AVSS_n3253 17.0005
R6630 AVSS_n3312 AVSS_n172 17.0005
R6631 AVSS_n209 AVSS_n198 17.0005
R6632 AVSS_n209 AVSS_n196 17.0005
R6633 AVSS_n3219 AVSS_n2910 17.0005
R6634 AVSS_n3219 AVSS_n236 17.0005
R6635 AVSS_n3219 AVSS_n2897 17.0005
R6636 AVSS_n3219 AVSS_n244 17.0005
R6637 AVSS_n3219 AVSS_n2888 17.0005
R6638 AVSS_n3219 AVSS_n256 17.0005
R6639 AVSS_n3219 AVSS_n2875 17.0005
R6640 AVSS_n3219 AVSS_n267 17.0005
R6641 AVSS_n3219 AVSS_n2862 17.0005
R6642 AVSS_n3219 AVSS_n278 17.0005
R6643 AVSS_n3219 AVSS_n2849 17.0005
R6644 AVSS_n3219 AVSS_n286 17.0005
R6645 AVSS_n3219 AVSS_n2839 17.0005
R6646 AVSS_n3219 AVSS_n296 17.0005
R6647 AVSS_n3219 AVSS_n2826 17.0005
R6648 AVSS_n2763 AVSS_n2762 17.0005
R6649 AVSS_n2763 AVSS_n1916 17.0005
R6650 AVSS_n2763 AVSS_n2046 17.0005
R6651 AVSS_n2763 AVSS_n1917 17.0005
R6652 AVSS_n2763 AVSS_n2044 17.0005
R6653 AVSS_n2763 AVSS_n1918 17.0005
R6654 AVSS_n2763 AVSS_n2042 17.0005
R6655 AVSS_n2763 AVSS_n1919 17.0005
R6656 AVSS_n2763 AVSS_n2040 17.0005
R6657 AVSS_n2763 AVSS_n1920 17.0005
R6658 AVSS_n2763 AVSS_n2035 17.0005
R6659 AVSS_n2763 AVSS_n1921 17.0005
R6660 AVSS_n2763 AVSS_n2033 17.0005
R6661 AVSS_n2763 AVSS_n1922 17.0005
R6662 AVSS_n2763 AVSS_n2031 17.0005
R6663 AVSS_n2763 AVSS_n1923 17.0005
R6664 AVSS_n2763 AVSS_n2029 17.0005
R6665 AVSS_n2763 AVSS_n1924 17.0005
R6666 AVSS_n2763 AVSS_n2027 17.0005
R6667 AVSS_n2763 AVSS_n1925 17.0005
R6668 AVSS_n2763 AVSS_n2025 17.0005
R6669 AVSS_n2763 AVSS_n1926 17.0005
R6670 AVSS_n2763 AVSS_n1927 17.0005
R6671 AVSS_n2763 AVSS_n2023 17.0005
R6672 AVSS_n2763 AVSS_n1928 17.0005
R6673 AVSS_n2763 AVSS_n2021 17.0005
R6674 AVSS_n2763 AVSS_n1929 17.0005
R6675 AVSS_n2763 AVSS_n2018 17.0005
R6676 AVSS_n2763 AVSS_n1930 17.0005
R6677 AVSS_n2763 AVSS_n2016 17.0005
R6678 AVSS_n2763 AVSS_n1931 17.0005
R6679 AVSS_n2763 AVSS_n2013 17.0005
R6680 AVSS_n2763 AVSS_n1932 17.0005
R6681 AVSS_n2763 AVSS_n2010 17.0005
R6682 AVSS_n2763 AVSS_n1933 17.0005
R6683 AVSS_n2763 AVSS_n2008 17.0005
R6684 AVSS_n2763 AVSS_n1934 17.0005
R6685 AVSS_n2763 AVSS_n2006 17.0005
R6686 AVSS_n2763 AVSS_n1935 17.0005
R6687 AVSS_n2763 AVSS_n2004 17.0005
R6688 AVSS_n2763 AVSS_n1936 17.0005
R6689 AVSS_n2763 AVSS_n2002 17.0005
R6690 AVSS_n2763 AVSS_n1937 17.0005
R6691 AVSS_n2763 AVSS_n2000 17.0005
R6692 AVSS_n2763 AVSS_n1938 17.0005
R6693 AVSS_n2763 AVSS_n1998 17.0005
R6694 AVSS_n2763 AVSS_n1939 17.0005
R6695 AVSS_n2763 AVSS_n1996 17.0005
R6696 AVSS_n2763 AVSS_n1940 17.0005
R6697 AVSS_n2763 AVSS_n1994 17.0005
R6698 AVSS_n2763 AVSS_n1941 17.0005
R6699 AVSS_n2763 AVSS_n1991 17.0005
R6700 AVSS_n2763 AVSS_n1942 17.0005
R6701 AVSS_n2763 AVSS_n1989 17.0005
R6702 AVSS_n2763 AVSS_n1943 17.0005
R6703 AVSS_n2763 AVSS_n1987 17.0005
R6704 AVSS_n2763 AVSS_n1944 17.0005
R6705 AVSS_n2763 AVSS_n1985 17.0005
R6706 AVSS_n2763 AVSS_n1945 17.0005
R6707 AVSS_n2763 AVSS_n1983 17.0005
R6708 AVSS_n2763 AVSS_n1946 17.0005
R6709 AVSS_n2763 AVSS_n1981 17.0005
R6710 AVSS_n2763 AVSS_n1947 17.0005
R6711 AVSS_n2763 AVSS_n1979 17.0005
R6712 AVSS_n2763 AVSS_n1948 17.0005
R6713 AVSS_n2763 AVSS_n1977 17.0005
R6714 AVSS_n2763 AVSS_n1949 17.0005
R6715 AVSS_n2763 AVSS_n1974 17.0005
R6716 AVSS_n2763 AVSS_n1950 17.0005
R6717 AVSS_n2763 AVSS_n1972 17.0005
R6718 AVSS_n2763 AVSS_n1951 17.0005
R6719 AVSS_n2763 AVSS_n1970 17.0005
R6720 AVSS_n2763 AVSS_n1952 17.0005
R6721 AVSS_n2763 AVSS_n1968 17.0005
R6722 AVSS_n2763 AVSS_n1953 17.0005
R6723 AVSS_n2763 AVSS_n1966 17.0005
R6724 AVSS_n2763 AVSS_n1954 17.0005
R6725 AVSS_n2763 AVSS_n1964 17.0005
R6726 AVSS_n2763 AVSS_n1955 17.0005
R6727 AVSS_n2763 AVSS_n1962 17.0005
R6728 AVSS_n2763 AVSS_n1956 17.0005
R6729 AVSS_n2763 AVSS_n1960 17.0005
R6730 AVSS_n2763 AVSS_n1957 17.0005
R6731 AVSS_n2764 AVSS_n2763 17.0005
R6732 AVSS_n2765 AVSS_n2764 17.0005
R6733 AVSS_n2765 AVSS_n1558 17.0005
R6734 AVSS_n2765 AVSS_n1907 17.0005
R6735 AVSS_n2765 AVSS_n1559 17.0005
R6736 AVSS_n2765 AVSS_n1905 17.0005
R6737 AVSS_n2765 AVSS_n1560 17.0005
R6738 AVSS_n2765 AVSS_n1903 17.0005
R6739 AVSS_n2765 AVSS_n1561 17.0005
R6740 AVSS_n2765 AVSS_n1901 17.0005
R6741 AVSS_n2765 AVSS_n1562 17.0005
R6742 AVSS_n2765 AVSS_n1899 17.0005
R6743 AVSS_n2765 AVSS_n1563 17.0005
R6744 AVSS_n2765 AVSS_n1896 17.0005
R6745 AVSS_n2765 AVSS_n1564 17.0005
R6746 AVSS_n2765 AVSS_n1894 17.0005
R6747 AVSS_n2765 AVSS_n1565 17.0005
R6748 AVSS_n2765 AVSS_n1892 17.0005
R6749 AVSS_n2765 AVSS_n1566 17.0005
R6750 AVSS_n2765 AVSS_n1886 17.0005
R6751 AVSS_n2765 AVSS_n1567 17.0005
R6752 AVSS_n2765 AVSS_n1885 17.0005
R6753 AVSS_n2765 AVSS_n1568 17.0005
R6754 AVSS_n2765 AVSS_n1883 17.0005
R6755 AVSS_n2765 AVSS_n1881 17.0005
R6756 AVSS_n2765 AVSS_n1569 17.0005
R6757 AVSS_n2765 AVSS_n1879 17.0005
R6758 AVSS_n2765 AVSS_n1570 17.0005
R6759 AVSS_n2765 AVSS_n1877 17.0005
R6760 AVSS_n2765 AVSS_n1571 17.0005
R6761 AVSS_n2765 AVSS_n1875 17.0005
R6762 AVSS_n2765 AVSS_n1572 17.0005
R6763 AVSS_n2765 AVSS_n1873 17.0005
R6764 AVSS_n2765 AVSS_n1573 17.0005
R6765 AVSS_n2765 AVSS_n1871 17.0005
R6766 AVSS_n2765 AVSS_n1574 17.0005
R6767 AVSS_n2765 AVSS_n1869 17.0005
R6768 AVSS_n2765 AVSS_n1575 17.0005
R6769 AVSS_n2765 AVSS_n1867 17.0005
R6770 AVSS_n2765 AVSS_n1576 17.0005
R6771 AVSS_n2765 AVSS_n1865 17.0005
R6772 AVSS_n2765 AVSS_n1577 17.0005
R6773 AVSS_n2765 AVSS_n1863 17.0005
R6774 AVSS_n2765 AVSS_n1578 17.0005
R6775 AVSS_n2765 AVSS_n1860 17.0005
R6776 AVSS_n2765 AVSS_n1579 17.0005
R6777 AVSS_n2765 AVSS_n1858 17.0005
R6778 AVSS_n2765 AVSS_n1580 17.0005
R6779 AVSS_n2765 AVSS_n1856 17.0005
R6780 AVSS_n2765 AVSS_n1581 17.0005
R6781 AVSS_n2765 AVSS_n1854 17.0005
R6782 AVSS_n2765 AVSS_n1582 17.0005
R6783 AVSS_n2765 AVSS_n1852 17.0005
R6784 AVSS_n2765 AVSS_n1583 17.0005
R6785 AVSS_n2765 AVSS_n1849 17.0005
R6786 AVSS_n2765 AVSS_n1584 17.0005
R6787 AVSS_n2765 AVSS_n1847 17.0005
R6788 AVSS_n2765 AVSS_n1585 17.0005
R6789 AVSS_n2765 AVSS_n1845 17.0005
R6790 AVSS_n2765 AVSS_n1586 17.0005
R6791 AVSS_n2765 AVSS_n1843 17.0005
R6792 AVSS_n2765 AVSS_n1587 17.0005
R6793 AVSS_n2765 AVSS_n1841 17.0005
R6794 AVSS_n2765 AVSS_n1588 17.0005
R6795 AVSS_n2765 AVSS_n1838 17.0005
R6796 AVSS_n2765 AVSS_n1589 17.0005
R6797 AVSS_n2765 AVSS_n1836 17.0005
R6798 AVSS_n2765 AVSS_n1590 17.0005
R6799 AVSS_n2765 AVSS_n1834 17.0005
R6800 AVSS_n2765 AVSS_n1591 17.0005
R6801 AVSS_n2765 AVSS_n1831 17.0005
R6802 AVSS_n2765 AVSS_n1592 17.0005
R6803 AVSS_n2765 AVSS_n1829 17.0005
R6804 AVSS_n2765 AVSS_n1593 17.0005
R6805 AVSS_n2765 AVSS_n1827 17.0005
R6806 AVSS_n2765 AVSS_n1594 17.0005
R6807 AVSS_n2765 AVSS_n1825 17.0005
R6808 AVSS_n2765 AVSS_n1595 17.0005
R6809 AVSS_n2765 AVSS_n1823 17.0005
R6810 AVSS_n2765 AVSS_n1596 17.0005
R6811 AVSS_n2765 AVSS_n1821 17.0005
R6812 AVSS_n2765 AVSS_n1597 17.0005
R6813 AVSS_n2765 AVSS_n1819 17.0005
R6814 AVSS_n2765 AVSS_n1598 17.0005
R6815 AVSS_n2765 AVSS_n1817 17.0005
R6816 AVSS_n2765 AVSS_n1599 17.0005
R6817 AVSS_n2765 AVSS_n1815 17.0005
R6818 AVSS_n2765 AVSS_n1600 17.0005
R6819 AVSS_n2765 AVSS_n1813 17.0005
R6820 AVSS_n2765 AVSS_n1601 17.0005
R6821 AVSS_n2765 AVSS_n1810 17.0005
R6822 AVSS_n2765 AVSS_n1602 17.0005
R6823 AVSS_n2765 AVSS_n1808 17.0005
R6824 AVSS_n2765 AVSS_n1603 17.0005
R6825 AVSS_n2765 AVSS_n1806 17.0005
R6826 AVSS_n2765 AVSS_n1604 17.0005
R6827 AVSS_n2765 AVSS_n1804 17.0005
R6828 AVSS_n2765 AVSS_n1605 17.0005
R6829 AVSS_n2765 AVSS_n1802 17.0005
R6830 AVSS_n2765 AVSS_n1606 17.0005
R6831 AVSS_n2765 AVSS_n1800 17.0005
R6832 AVSS_n2765 AVSS_n1607 17.0005
R6833 AVSS_n2765 AVSS_n1798 17.0005
R6834 AVSS_n2765 AVSS_n1608 17.0005
R6835 AVSS_n2765 AVSS_n1796 17.0005
R6836 AVSS_n2765 AVSS_n1609 17.0005
R6837 AVSS_n2765 AVSS_n1794 17.0005
R6838 AVSS_n2765 AVSS_n1610 17.0005
R6839 AVSS_n2765 AVSS_n1792 17.0005
R6840 AVSS_n2765 AVSS_n1611 17.0005
R6841 AVSS_n2765 AVSS_n1790 17.0005
R6842 AVSS_n2765 AVSS_n1612 17.0005
R6843 AVSS_n2765 AVSS_n1788 17.0005
R6844 AVSS_n2765 AVSS_n1613 17.0005
R6845 AVSS_n2765 AVSS_n1786 17.0005
R6846 AVSS_n2765 AVSS_n1614 17.0005
R6847 AVSS_n2765 AVSS_n1784 17.0005
R6848 AVSS_n2765 AVSS_n1615 17.0005
R6849 AVSS_n2765 AVSS_n1781 17.0005
R6850 AVSS_n2765 AVSS_n1616 17.0005
R6851 AVSS_n2765 AVSS_n1779 17.0005
R6852 AVSS_n2765 AVSS_n1617 17.0005
R6853 AVSS_n2765 AVSS_n1777 17.0005
R6854 AVSS_n2765 AVSS_n1618 17.0005
R6855 AVSS_n2765 AVSS_n1775 17.0005
R6856 AVSS_n2765 AVSS_n1619 17.0005
R6857 AVSS_n2765 AVSS_n1773 17.0005
R6858 AVSS_n2765 AVSS_n1620 17.0005
R6859 AVSS_n2765 AVSS_n1771 17.0005
R6860 AVSS_n2765 AVSS_n1621 17.0005
R6861 AVSS_n2765 AVSS_n1769 17.0005
R6862 AVSS_n2765 AVSS_n1622 17.0005
R6863 AVSS_n2765 AVSS_n1766 17.0005
R6864 AVSS_n2765 AVSS_n1623 17.0005
R6865 AVSS_n2765 AVSS_n1764 17.0005
R6866 AVSS_n2765 AVSS_n1624 17.0005
R6867 AVSS_n2765 AVSS_n1762 17.0005
R6868 AVSS_n2765 AVSS_n1625 17.0005
R6869 AVSS_n2765 AVSS_n1760 17.0005
R6870 AVSS_n2765 AVSS_n1626 17.0005
R6871 AVSS_n2765 AVSS_n1758 17.0005
R6872 AVSS_n2765 AVSS_n1627 17.0005
R6873 AVSS_n2765 AVSS_n1756 17.0005
R6874 AVSS_n2765 AVSS_n1628 17.0005
R6875 AVSS_n2765 AVSS_n1753 17.0005
R6876 AVSS_n2765 AVSS_n1629 17.0005
R6877 AVSS_n2765 AVSS_n1751 17.0005
R6878 AVSS_n2765 AVSS_n1630 17.0005
R6879 AVSS_n2765 AVSS_n1749 17.0005
R6880 AVSS_n2765 AVSS_n1631 17.0005
R6881 AVSS_n2765 AVSS_n1747 17.0005
R6882 AVSS_n2765 AVSS_n1632 17.0005
R6883 AVSS_n2765 AVSS_n1745 17.0005
R6884 AVSS_n2765 AVSS_n1633 17.0005
R6885 AVSS_n2765 AVSS_n1743 17.0005
R6886 AVSS_n2765 AVSS_n1634 17.0005
R6887 AVSS_n2765 AVSS_n1741 17.0005
R6888 AVSS_n2765 AVSS_n1635 17.0005
R6889 AVSS_n2765 AVSS_n1739 17.0005
R6890 AVSS_n2765 AVSS_n1636 17.0005
R6891 AVSS_n2765 AVSS_n1737 17.0005
R6892 AVSS_n2765 AVSS_n1637 17.0005
R6893 AVSS_n2765 AVSS_n1735 17.0005
R6894 AVSS_n2765 AVSS_n1638 17.0005
R6895 AVSS_n2765 AVSS_n1733 17.0005
R6896 AVSS_n2765 AVSS_n1639 17.0005
R6897 AVSS_n2765 AVSS_n1731 17.0005
R6898 AVSS_n2765 AVSS_n1640 17.0005
R6899 AVSS_n2765 AVSS_n1729 17.0005
R6900 AVSS_n2765 AVSS_n1641 17.0005
R6901 AVSS_n2765 AVSS_n1727 17.0005
R6902 AVSS_n2765 AVSS_n1642 17.0005
R6903 AVSS_n2765 AVSS_n1725 17.0005
R6904 AVSS_n2765 AVSS_n1643 17.0005
R6905 AVSS_n2765 AVSS_n1723 17.0005
R6906 AVSS_n2765 AVSS_n1644 17.0005
R6907 AVSS_n2765 AVSS_n1721 17.0005
R6908 AVSS_n2765 AVSS_n1645 17.0005
R6909 AVSS_n2765 AVSS_n1719 17.0005
R6910 AVSS_n2765 AVSS_n1646 17.0005
R6911 AVSS_n2765 AVSS_n1717 17.0005
R6912 AVSS_n2765 AVSS_n1647 17.0005
R6913 AVSS_n2765 AVSS_n1715 17.0005
R6914 AVSS_n2765 AVSS_n1648 17.0005
R6915 AVSS_n2765 AVSS_n1713 17.0005
R6916 AVSS_n2765 AVSS_n1649 17.0005
R6917 AVSS_n2765 AVSS_n1711 17.0005
R6918 AVSS_n2765 AVSS_n1650 17.0005
R6919 AVSS_n2765 AVSS_n1709 17.0005
R6920 AVSS_n2765 AVSS_n1651 17.0005
R6921 AVSS_n2765 AVSS_n1707 17.0005
R6922 AVSS_n2765 AVSS_n1652 17.0005
R6923 AVSS_n2765 AVSS_n1704 17.0005
R6924 AVSS_n2765 AVSS_n1653 17.0005
R6925 AVSS_n2765 AVSS_n1702 17.0005
R6926 AVSS_n2765 AVSS_n1654 17.0005
R6927 AVSS_n2765 AVSS_n1700 17.0005
R6928 AVSS_n2765 AVSS_n1655 17.0005
R6929 AVSS_n2765 AVSS_n1698 17.0005
R6930 AVSS_n2765 AVSS_n1656 17.0005
R6931 AVSS_n2765 AVSS_n1696 17.0005
R6932 AVSS_n2765 AVSS_n1657 17.0005
R6933 AVSS_n2765 AVSS_n1694 17.0005
R6934 AVSS_n2765 AVSS_n1658 17.0005
R6935 AVSS_n2765 AVSS_n1692 17.0005
R6936 AVSS_n2765 AVSS_n1659 17.0005
R6937 AVSS_n2765 AVSS_n1690 17.0005
R6938 AVSS_n2765 AVSS_n1660 17.0005
R6939 AVSS_n2765 AVSS_n1688 17.0005
R6940 AVSS_n2765 AVSS_n1661 17.0005
R6941 AVSS_n2765 AVSS_n1686 17.0005
R6942 AVSS_n2765 AVSS_n1662 17.0005
R6943 AVSS_n2765 AVSS_n1684 17.0005
R6944 AVSS_n2765 AVSS_n1663 17.0005
R6945 AVSS_n2765 AVSS_n1682 17.0005
R6946 AVSS_n2765 AVSS_n1664 17.0005
R6947 AVSS_n2765 AVSS_n1680 17.0005
R6948 AVSS_n2765 AVSS_n1665 17.0005
R6949 AVSS_n2765 AVSS_n1678 17.0005
R6950 AVSS_n2765 AVSS_n1666 17.0005
R6951 AVSS_n2765 AVSS_n1675 17.0005
R6952 AVSS_n2765 AVSS_n1667 17.0005
R6953 AVSS_n2765 AVSS_n1673 17.0005
R6954 AVSS_n2765 AVSS_n1668 17.0005
R6955 AVSS_n2765 AVSS_n1671 17.0005
R6956 AVSS_n2765 AVSS_n1669 17.0005
R6957 AVSS_n2766 AVSS_n2765 17.0005
R6958 AVSS_n2767 AVSS_n2766 17.0005
R6959 AVSS_n2767 AVSS_n1514 17.0005
R6960 AVSS_n2767 AVSS_n1522 17.0005
R6961 AVSS_n2767 AVSS_n1515 17.0005
R6962 AVSS_n2767 AVSS_n1521 17.0005
R6963 AVSS_n2767 AVSS_n1516 17.0005
R6964 AVSS_n2767 AVSS_n1520 17.0005
R6965 AVSS_n2767 AVSS_n1517 17.0005
R6966 AVSS_n2767 AVSS_n1519 17.0005
R6967 AVSS_n2767 AVSS_n1518 17.0005
R6968 AVSS_n2769 AVSS_n2768 17.0005
R6969 AVSS_n2769 AVSS_n1453 17.0005
R6970 AVSS_n2769 AVSS_n1487 17.0005
R6971 AVSS_n2769 AVSS_n1454 17.0005
R6972 AVSS_n2770 AVSS_n2769 17.0005
R6973 AVSS_n2769 AVSS_n1455 17.0005
R6974 AVSS_n2769 AVSS_n1486 17.0005
R6975 AVSS_n2769 AVSS_n1456 17.0005
R6976 AVSS_n2769 AVSS_n1484 17.0005
R6977 AVSS_n2769 AVSS_n1457 17.0005
R6978 AVSS_n2769 AVSS_n1483 17.0005
R6979 AVSS_n2769 AVSS_n1458 17.0005
R6980 AVSS_n2769 AVSS_n1482 17.0005
R6981 AVSS_n2769 AVSS_n1459 17.0005
R6982 AVSS_n2769 AVSS_n1481 17.0005
R6983 AVSS_n2769 AVSS_n1460 17.0005
R6984 AVSS_n2769 AVSS_n1480 17.0005
R6985 AVSS_n2769 AVSS_n1461 17.0005
R6986 AVSS_n2769 AVSS_n1479 17.0005
R6987 AVSS_n2769 AVSS_n1462 17.0005
R6988 AVSS_n2769 AVSS_n1443 17.0005
R6989 AVSS_n2769 AVSS_n1463 17.0005
R6990 AVSS_n2769 AVSS_n1478 17.0005
R6991 AVSS_n2769 AVSS_n1464 17.0005
R6992 AVSS_n2769 AVSS_n1477 17.0005
R6993 AVSS_n2769 AVSS_n1465 17.0005
R6994 AVSS_n2769 AVSS_n1476 17.0005
R6995 AVSS_n2769 AVSS_n1466 17.0005
R6996 AVSS_n2769 AVSS_n1475 17.0005
R6997 AVSS_n2769 AVSS_n1467 17.0005
R6998 AVSS_n2769 AVSS_n1474 17.0005
R6999 AVSS_n2769 AVSS_n1468 17.0005
R7000 AVSS_n2769 AVSS_n1471 17.0005
R7001 AVSS_n2769 AVSS_n1469 17.0005
R7002 AVSS_n2769 AVSS_n1470 17.0005
R7003 AVSS_n2769 AVSS_n1059 17.0005
R7004 AVSS_n2813 AVSS_n2812 17.0005
R7005 AVSS_n2813 AVSS_n1007 17.0005
R7006 AVSS_n2813 AVSS_n1029 17.0005
R7007 AVSS_n2813 AVSS_n1008 17.0005
R7008 AVSS_n2813 AVSS_n1009 17.0005
R7009 AVSS_n2813 AVSS_n1026 17.0005
R7010 AVSS_n2813 AVSS_n1010 17.0005
R7011 AVSS_n2813 AVSS_n1024 17.0005
R7012 AVSS_n2813 AVSS_n1011 17.0005
R7013 AVSS_n2813 AVSS_n1018 17.0005
R7014 AVSS_n2813 AVSS_n1012 17.0005
R7015 AVSS_n2813 AVSS_n1017 17.0005
R7016 AVSS_n2813 AVSS_n1013 17.0005
R7017 AVSS_n2813 AVSS_n1015 17.0005
R7018 AVSS_n2814 AVSS_n2813 17.0005
R7019 AVSS_n2815 AVSS_n2814 17.0005
R7020 AVSS_n2815 AVSS_n843 17.0005
R7021 AVSS_n2815 AVSS_n952 17.0005
R7022 AVSS_n2815 AVSS_n844 17.0005
R7023 AVSS_n2815 AVSS_n951 17.0005
R7024 AVSS_n2815 AVSS_n845 17.0005
R7025 AVSS_n2815 AVSS_n950 17.0005
R7026 AVSS_n2815 AVSS_n846 17.0005
R7027 AVSS_n2815 AVSS_n949 17.0005
R7028 AVSS_n2815 AVSS_n847 17.0005
R7029 AVSS_n2815 AVSS_n778 17.0005
R7030 AVSS_n2815 AVSS_n849 17.0005
R7031 AVSS_n2815 AVSS_n948 17.0005
R7032 AVSS_n2815 AVSS_n850 17.0005
R7033 AVSS_n2815 AVSS_n946 17.0005
R7034 AVSS_n2815 AVSS_n851 17.0005
R7035 AVSS_n2815 AVSS_n945 17.0005
R7036 AVSS_n2815 AVSS_n852 17.0005
R7037 AVSS_n2815 AVSS_n782 17.0005
R7038 AVSS_n2815 AVSS_n854 17.0005
R7039 AVSS_n2815 AVSS_n944 17.0005
R7040 AVSS_n2815 AVSS_n855 17.0005
R7041 AVSS_n2815 AVSS_n943 17.0005
R7042 AVSS_n2815 AVSS_n856 17.0005
R7043 AVSS_n2815 AVSS_n942 17.0005
R7044 AVSS_n2815 AVSS_n857 17.0005
R7045 AVSS_n2815 AVSS_n941 17.0005
R7046 AVSS_n2815 AVSS_n858 17.0005
R7047 AVSS_n2815 AVSS_n940 17.0005
R7048 AVSS_n2815 AVSS_n859 17.0005
R7049 AVSS_n2815 AVSS_n939 17.0005
R7050 AVSS_n2815 AVSS_n860 17.0005
R7051 AVSS_n2815 AVSS_n938 17.0005
R7052 AVSS_n2815 AVSS_n790 17.0005
R7053 AVSS_n2815 AVSS_n937 17.0005
R7054 AVSS_n2815 AVSS_n861 17.0005
R7055 AVSS_n2815 AVSS_n935 17.0005
R7056 AVSS_n2815 AVSS_n862 17.0005
R7057 AVSS_n2815 AVSS_n793 17.0005
R7058 AVSS_n2815 AVSS_n864 17.0005
R7059 AVSS_n2815 AVSS_n934 17.0005
R7060 AVSS_n2815 AVSS_n795 17.0005
R7061 AVSS_n2815 AVSS_n933 17.0005
R7062 AVSS_n2815 AVSS_n865 17.0005
R7063 AVSS_n2815 AVSS_n931 17.0005
R7064 AVSS_n2815 AVSS_n866 17.0005
R7065 AVSS_n2815 AVSS_n930 17.0005
R7066 AVSS_n2815 AVSS_n867 17.0005
R7067 AVSS_n2815 AVSS_n929 17.0005
R7068 AVSS_n2815 AVSS_n868 17.0005
R7069 AVSS_n2815 AVSS_n928 17.0005
R7070 AVSS_n2815 AVSS_n871 17.0005
R7071 AVSS_n2815 AVSS_n927 17.0005
R7072 AVSS_n2815 AVSS_n803 17.0005
R7073 AVSS_n2815 AVSS_n873 17.0005
R7074 AVSS_n2815 AVSS_n926 17.0005
R7075 AVSS_n2815 AVSS_n805 17.0005
R7076 AVSS_n2815 AVSS_n925 17.0005
R7077 AVSS_n2815 AVSS_n874 17.0005
R7078 AVSS_n2815 AVSS_n923 17.0005
R7079 AVSS_n2815 AVSS_n875 17.0005
R7080 AVSS_n2815 AVSS_n922 17.0005
R7081 AVSS_n2815 AVSS_n876 17.0005
R7082 AVSS_n2815 AVSS_n809 17.0005
R7083 AVSS_n2815 AVSS_n878 17.0005
R7084 AVSS_n2815 AVSS_n921 17.0005
R7085 AVSS_n2815 AVSS_n879 17.0005
R7086 AVSS_n2815 AVSS_n920 17.0005
R7087 AVSS_n2815 AVSS_n880 17.0005
R7088 AVSS_n2815 AVSS_n919 17.0005
R7089 AVSS_n2815 AVSS_n813 17.0005
R7090 AVSS_n2815 AVSS_n918 17.0005
R7091 AVSS_n2815 AVSS_n881 17.0005
R7092 AVSS_n2815 AVSS_n815 17.0005
R7093 AVSS_n2815 AVSS_n883 17.0005
R7094 AVSS_n2815 AVSS_n916 17.0005
R7095 AVSS_n2815 AVSS_n884 17.0005
R7096 AVSS_n2815 AVSS_n915 17.0005
R7097 AVSS_n2815 AVSS_n885 17.0005
R7098 AVSS_n2815 AVSS_n914 17.0005
R7099 AVSS_n2815 AVSS_n819 17.0005
R7100 AVSS_n2815 AVSS_n913 17.0005
R7101 AVSS_n2815 AVSS_n886 17.0005
R7102 AVSS_n2815 AVSS_n821 17.0005
R7103 AVSS_n2815 AVSS_n888 17.0005
R7104 AVSS_n2815 AVSS_n911 17.0005
R7105 AVSS_n2815 AVSS_n889 17.0005
R7106 AVSS_n2815 AVSS_n910 17.0005
R7107 AVSS_n2815 AVSS_n890 17.0005
R7108 AVSS_n2815 AVSS_n909 17.0005
R7109 AVSS_n2815 AVSS_n825 17.0005
R7110 AVSS_n2815 AVSS_n908 17.0005
R7111 AVSS_n2815 AVSS_n891 17.0005
R7112 AVSS_n2815 AVSS_n906 17.0005
R7113 AVSS_n2815 AVSS_n892 17.0005
R7114 AVSS_n2815 AVSS_n905 17.0005
R7115 AVSS_n2815 AVSS_n893 17.0005
R7116 AVSS_n2815 AVSS_n829 17.0005
R7117 AVSS_n2815 AVSS_n895 17.0005
R7118 AVSS_n2815 AVSS_n904 17.0005
R7119 AVSS_n2815 AVSS_n896 17.0005
R7120 AVSS_n2815 AVSS_n903 17.0005
R7121 AVSS_n2815 AVSS_n897 17.0005
R7122 AVSS_n2815 AVSS_n902 17.0005
R7123 AVSS_n2815 AVSS_n898 17.0005
R7124 AVSS_n2815 AVSS_n901 17.0005
R7125 AVSS_n2815 AVSS_n899 17.0005
R7126 AVSS_n2815 AVSS_n900 17.0005
R7127 AVSS_n2816 AVSS_n2815 17.0005
R7128 AVSS_n2762 AVSS_n1909 17.0005
R7129 AVSS_n1916 AVSS_n1909 17.0005
R7130 AVSS_n2046 AVSS_n1909 17.0005
R7131 AVSS_n1917 AVSS_n1909 17.0005
R7132 AVSS_n2044 AVSS_n1909 17.0005
R7133 AVSS_n1918 AVSS_n1909 17.0005
R7134 AVSS_n2042 AVSS_n1909 17.0005
R7135 AVSS_n1919 AVSS_n1909 17.0005
R7136 AVSS_n2040 AVSS_n1909 17.0005
R7137 AVSS_n1920 AVSS_n1909 17.0005
R7138 AVSS_n2035 AVSS_n1909 17.0005
R7139 AVSS_n1921 AVSS_n1909 17.0005
R7140 AVSS_n2033 AVSS_n1909 17.0005
R7141 AVSS_n1922 AVSS_n1909 17.0005
R7142 AVSS_n2031 AVSS_n1909 17.0005
R7143 AVSS_n1923 AVSS_n1909 17.0005
R7144 AVSS_n2029 AVSS_n1909 17.0005
R7145 AVSS_n1924 AVSS_n1909 17.0005
R7146 AVSS_n2027 AVSS_n1909 17.0005
R7147 AVSS_n1925 AVSS_n1909 17.0005
R7148 AVSS_n2025 AVSS_n1909 17.0005
R7149 AVSS_n1926 AVSS_n1909 17.0005
R7150 AVSS_n1927 AVSS_n1909 17.0005
R7151 AVSS_n2023 AVSS_n1909 17.0005
R7152 AVSS_n1928 AVSS_n1909 17.0005
R7153 AVSS_n2021 AVSS_n1909 17.0005
R7154 AVSS_n1929 AVSS_n1909 17.0005
R7155 AVSS_n2018 AVSS_n1909 17.0005
R7156 AVSS_n1930 AVSS_n1909 17.0005
R7157 AVSS_n2016 AVSS_n1909 17.0005
R7158 AVSS_n1931 AVSS_n1909 17.0005
R7159 AVSS_n2013 AVSS_n1909 17.0005
R7160 AVSS_n1932 AVSS_n1909 17.0005
R7161 AVSS_n2010 AVSS_n1909 17.0005
R7162 AVSS_n1933 AVSS_n1909 17.0005
R7163 AVSS_n2008 AVSS_n1909 17.0005
R7164 AVSS_n1934 AVSS_n1909 17.0005
R7165 AVSS_n2006 AVSS_n1909 17.0005
R7166 AVSS_n1935 AVSS_n1909 17.0005
R7167 AVSS_n2004 AVSS_n1909 17.0005
R7168 AVSS_n1936 AVSS_n1909 17.0005
R7169 AVSS_n2002 AVSS_n1909 17.0005
R7170 AVSS_n1937 AVSS_n1909 17.0005
R7171 AVSS_n2000 AVSS_n1909 17.0005
R7172 AVSS_n1938 AVSS_n1909 17.0005
R7173 AVSS_n1998 AVSS_n1909 17.0005
R7174 AVSS_n1939 AVSS_n1909 17.0005
R7175 AVSS_n1996 AVSS_n1909 17.0005
R7176 AVSS_n1940 AVSS_n1909 17.0005
R7177 AVSS_n1994 AVSS_n1909 17.0005
R7178 AVSS_n1941 AVSS_n1909 17.0005
R7179 AVSS_n1991 AVSS_n1909 17.0005
R7180 AVSS_n1942 AVSS_n1909 17.0005
R7181 AVSS_n1989 AVSS_n1909 17.0005
R7182 AVSS_n1943 AVSS_n1909 17.0005
R7183 AVSS_n1987 AVSS_n1909 17.0005
R7184 AVSS_n1944 AVSS_n1909 17.0005
R7185 AVSS_n1985 AVSS_n1909 17.0005
R7186 AVSS_n1945 AVSS_n1909 17.0005
R7187 AVSS_n1983 AVSS_n1909 17.0005
R7188 AVSS_n1946 AVSS_n1909 17.0005
R7189 AVSS_n1981 AVSS_n1909 17.0005
R7190 AVSS_n1947 AVSS_n1909 17.0005
R7191 AVSS_n1979 AVSS_n1909 17.0005
R7192 AVSS_n1948 AVSS_n1909 17.0005
R7193 AVSS_n1977 AVSS_n1909 17.0005
R7194 AVSS_n1949 AVSS_n1909 17.0005
R7195 AVSS_n1974 AVSS_n1909 17.0005
R7196 AVSS_n1950 AVSS_n1909 17.0005
R7197 AVSS_n1972 AVSS_n1909 17.0005
R7198 AVSS_n1951 AVSS_n1909 17.0005
R7199 AVSS_n1970 AVSS_n1909 17.0005
R7200 AVSS_n1952 AVSS_n1909 17.0005
R7201 AVSS_n1968 AVSS_n1909 17.0005
R7202 AVSS_n1953 AVSS_n1909 17.0005
R7203 AVSS_n1966 AVSS_n1909 17.0005
R7204 AVSS_n1954 AVSS_n1909 17.0005
R7205 AVSS_n1964 AVSS_n1909 17.0005
R7206 AVSS_n1955 AVSS_n1909 17.0005
R7207 AVSS_n1962 AVSS_n1909 17.0005
R7208 AVSS_n1956 AVSS_n1909 17.0005
R7209 AVSS_n1960 AVSS_n1909 17.0005
R7210 AVSS_n1957 AVSS_n1909 17.0005
R7211 AVSS_n2764 AVSS_n1909 17.0005
R7212 AVSS_n2764 AVSS_n1537 17.0005
R7213 AVSS_n1558 AVSS_n1537 17.0005
R7214 AVSS_n1907 AVSS_n1537 17.0005
R7215 AVSS_n1559 AVSS_n1537 17.0005
R7216 AVSS_n1905 AVSS_n1537 17.0005
R7217 AVSS_n1560 AVSS_n1537 17.0005
R7218 AVSS_n1903 AVSS_n1537 17.0005
R7219 AVSS_n1561 AVSS_n1537 17.0005
R7220 AVSS_n1901 AVSS_n1537 17.0005
R7221 AVSS_n1562 AVSS_n1537 17.0005
R7222 AVSS_n1899 AVSS_n1537 17.0005
R7223 AVSS_n1563 AVSS_n1537 17.0005
R7224 AVSS_n1896 AVSS_n1537 17.0005
R7225 AVSS_n1564 AVSS_n1537 17.0005
R7226 AVSS_n1894 AVSS_n1537 17.0005
R7227 AVSS_n1565 AVSS_n1537 17.0005
R7228 AVSS_n1892 AVSS_n1537 17.0005
R7229 AVSS_n1566 AVSS_n1537 17.0005
R7230 AVSS_n1886 AVSS_n1537 17.0005
R7231 AVSS_n1567 AVSS_n1537 17.0005
R7232 AVSS_n1885 AVSS_n1537 17.0005
R7233 AVSS_n1568 AVSS_n1537 17.0005
R7234 AVSS_n1883 AVSS_n1537 17.0005
R7235 AVSS_n1881 AVSS_n1537 17.0005
R7236 AVSS_n1569 AVSS_n1537 17.0005
R7237 AVSS_n1879 AVSS_n1537 17.0005
R7238 AVSS_n1570 AVSS_n1537 17.0005
R7239 AVSS_n1877 AVSS_n1537 17.0005
R7240 AVSS_n1571 AVSS_n1537 17.0005
R7241 AVSS_n1875 AVSS_n1537 17.0005
R7242 AVSS_n1572 AVSS_n1537 17.0005
R7243 AVSS_n1873 AVSS_n1537 17.0005
R7244 AVSS_n1573 AVSS_n1537 17.0005
R7245 AVSS_n1871 AVSS_n1537 17.0005
R7246 AVSS_n1574 AVSS_n1537 17.0005
R7247 AVSS_n1869 AVSS_n1537 17.0005
R7248 AVSS_n1575 AVSS_n1537 17.0005
R7249 AVSS_n1867 AVSS_n1537 17.0005
R7250 AVSS_n1576 AVSS_n1537 17.0005
R7251 AVSS_n1865 AVSS_n1537 17.0005
R7252 AVSS_n1577 AVSS_n1537 17.0005
R7253 AVSS_n1863 AVSS_n1537 17.0005
R7254 AVSS_n1578 AVSS_n1537 17.0005
R7255 AVSS_n1860 AVSS_n1537 17.0005
R7256 AVSS_n1579 AVSS_n1537 17.0005
R7257 AVSS_n1858 AVSS_n1537 17.0005
R7258 AVSS_n1580 AVSS_n1537 17.0005
R7259 AVSS_n1856 AVSS_n1537 17.0005
R7260 AVSS_n1581 AVSS_n1537 17.0005
R7261 AVSS_n1854 AVSS_n1537 17.0005
R7262 AVSS_n1582 AVSS_n1537 17.0005
R7263 AVSS_n1852 AVSS_n1537 17.0005
R7264 AVSS_n1583 AVSS_n1537 17.0005
R7265 AVSS_n1849 AVSS_n1537 17.0005
R7266 AVSS_n1584 AVSS_n1537 17.0005
R7267 AVSS_n1847 AVSS_n1537 17.0005
R7268 AVSS_n1585 AVSS_n1537 17.0005
R7269 AVSS_n1845 AVSS_n1537 17.0005
R7270 AVSS_n1586 AVSS_n1537 17.0005
R7271 AVSS_n1843 AVSS_n1537 17.0005
R7272 AVSS_n1587 AVSS_n1537 17.0005
R7273 AVSS_n1841 AVSS_n1537 17.0005
R7274 AVSS_n1588 AVSS_n1537 17.0005
R7275 AVSS_n1838 AVSS_n1537 17.0005
R7276 AVSS_n1589 AVSS_n1537 17.0005
R7277 AVSS_n1836 AVSS_n1537 17.0005
R7278 AVSS_n1590 AVSS_n1537 17.0005
R7279 AVSS_n1834 AVSS_n1537 17.0005
R7280 AVSS_n1591 AVSS_n1537 17.0005
R7281 AVSS_n1831 AVSS_n1537 17.0005
R7282 AVSS_n1592 AVSS_n1537 17.0005
R7283 AVSS_n1829 AVSS_n1537 17.0005
R7284 AVSS_n1593 AVSS_n1537 17.0005
R7285 AVSS_n1827 AVSS_n1537 17.0005
R7286 AVSS_n1594 AVSS_n1537 17.0005
R7287 AVSS_n1825 AVSS_n1537 17.0005
R7288 AVSS_n1595 AVSS_n1537 17.0005
R7289 AVSS_n1823 AVSS_n1537 17.0005
R7290 AVSS_n1596 AVSS_n1537 17.0005
R7291 AVSS_n1821 AVSS_n1537 17.0005
R7292 AVSS_n1597 AVSS_n1537 17.0005
R7293 AVSS_n1819 AVSS_n1537 17.0005
R7294 AVSS_n1598 AVSS_n1537 17.0005
R7295 AVSS_n1817 AVSS_n1537 17.0005
R7296 AVSS_n1599 AVSS_n1537 17.0005
R7297 AVSS_n1815 AVSS_n1537 17.0005
R7298 AVSS_n1600 AVSS_n1537 17.0005
R7299 AVSS_n1813 AVSS_n1537 17.0005
R7300 AVSS_n1601 AVSS_n1537 17.0005
R7301 AVSS_n1810 AVSS_n1537 17.0005
R7302 AVSS_n1602 AVSS_n1537 17.0005
R7303 AVSS_n1808 AVSS_n1537 17.0005
R7304 AVSS_n1603 AVSS_n1537 17.0005
R7305 AVSS_n1806 AVSS_n1537 17.0005
R7306 AVSS_n1604 AVSS_n1537 17.0005
R7307 AVSS_n1804 AVSS_n1537 17.0005
R7308 AVSS_n1605 AVSS_n1537 17.0005
R7309 AVSS_n1802 AVSS_n1537 17.0005
R7310 AVSS_n1606 AVSS_n1537 17.0005
R7311 AVSS_n1800 AVSS_n1537 17.0005
R7312 AVSS_n1607 AVSS_n1537 17.0005
R7313 AVSS_n1798 AVSS_n1537 17.0005
R7314 AVSS_n1608 AVSS_n1537 17.0005
R7315 AVSS_n1796 AVSS_n1537 17.0005
R7316 AVSS_n1609 AVSS_n1537 17.0005
R7317 AVSS_n1794 AVSS_n1537 17.0005
R7318 AVSS_n1610 AVSS_n1537 17.0005
R7319 AVSS_n1792 AVSS_n1537 17.0005
R7320 AVSS_n1611 AVSS_n1537 17.0005
R7321 AVSS_n1790 AVSS_n1537 17.0005
R7322 AVSS_n1612 AVSS_n1537 17.0005
R7323 AVSS_n1788 AVSS_n1537 17.0005
R7324 AVSS_n1613 AVSS_n1537 17.0005
R7325 AVSS_n1786 AVSS_n1537 17.0005
R7326 AVSS_n1614 AVSS_n1537 17.0005
R7327 AVSS_n1784 AVSS_n1537 17.0005
R7328 AVSS_n1615 AVSS_n1537 17.0005
R7329 AVSS_n1781 AVSS_n1537 17.0005
R7330 AVSS_n1616 AVSS_n1537 17.0005
R7331 AVSS_n1779 AVSS_n1537 17.0005
R7332 AVSS_n1617 AVSS_n1537 17.0005
R7333 AVSS_n1777 AVSS_n1537 17.0005
R7334 AVSS_n1618 AVSS_n1537 17.0005
R7335 AVSS_n1775 AVSS_n1537 17.0005
R7336 AVSS_n1619 AVSS_n1537 17.0005
R7337 AVSS_n1773 AVSS_n1537 17.0005
R7338 AVSS_n1620 AVSS_n1537 17.0005
R7339 AVSS_n1771 AVSS_n1537 17.0005
R7340 AVSS_n1621 AVSS_n1537 17.0005
R7341 AVSS_n1769 AVSS_n1537 17.0005
R7342 AVSS_n1622 AVSS_n1537 17.0005
R7343 AVSS_n1766 AVSS_n1537 17.0005
R7344 AVSS_n1623 AVSS_n1537 17.0005
R7345 AVSS_n1764 AVSS_n1537 17.0005
R7346 AVSS_n1624 AVSS_n1537 17.0005
R7347 AVSS_n1762 AVSS_n1537 17.0005
R7348 AVSS_n1625 AVSS_n1537 17.0005
R7349 AVSS_n1760 AVSS_n1537 17.0005
R7350 AVSS_n1626 AVSS_n1537 17.0005
R7351 AVSS_n1758 AVSS_n1537 17.0005
R7352 AVSS_n1627 AVSS_n1537 17.0005
R7353 AVSS_n1756 AVSS_n1537 17.0005
R7354 AVSS_n1628 AVSS_n1537 17.0005
R7355 AVSS_n1753 AVSS_n1537 17.0005
R7356 AVSS_n1629 AVSS_n1537 17.0005
R7357 AVSS_n1751 AVSS_n1537 17.0005
R7358 AVSS_n1630 AVSS_n1537 17.0005
R7359 AVSS_n1749 AVSS_n1537 17.0005
R7360 AVSS_n1631 AVSS_n1537 17.0005
R7361 AVSS_n1747 AVSS_n1537 17.0005
R7362 AVSS_n1632 AVSS_n1537 17.0005
R7363 AVSS_n1745 AVSS_n1537 17.0005
R7364 AVSS_n1633 AVSS_n1537 17.0005
R7365 AVSS_n1743 AVSS_n1537 17.0005
R7366 AVSS_n1634 AVSS_n1537 17.0005
R7367 AVSS_n1741 AVSS_n1537 17.0005
R7368 AVSS_n1635 AVSS_n1537 17.0005
R7369 AVSS_n1739 AVSS_n1537 17.0005
R7370 AVSS_n1636 AVSS_n1537 17.0005
R7371 AVSS_n1737 AVSS_n1537 17.0005
R7372 AVSS_n1637 AVSS_n1537 17.0005
R7373 AVSS_n1735 AVSS_n1537 17.0005
R7374 AVSS_n1638 AVSS_n1537 17.0005
R7375 AVSS_n1733 AVSS_n1537 17.0005
R7376 AVSS_n1639 AVSS_n1537 17.0005
R7377 AVSS_n1731 AVSS_n1537 17.0005
R7378 AVSS_n1640 AVSS_n1537 17.0005
R7379 AVSS_n1729 AVSS_n1537 17.0005
R7380 AVSS_n1641 AVSS_n1537 17.0005
R7381 AVSS_n1727 AVSS_n1537 17.0005
R7382 AVSS_n1642 AVSS_n1537 17.0005
R7383 AVSS_n1725 AVSS_n1537 17.0005
R7384 AVSS_n1643 AVSS_n1537 17.0005
R7385 AVSS_n1723 AVSS_n1537 17.0005
R7386 AVSS_n1644 AVSS_n1537 17.0005
R7387 AVSS_n1721 AVSS_n1537 17.0005
R7388 AVSS_n1645 AVSS_n1537 17.0005
R7389 AVSS_n1719 AVSS_n1537 17.0005
R7390 AVSS_n1646 AVSS_n1537 17.0005
R7391 AVSS_n1717 AVSS_n1537 17.0005
R7392 AVSS_n1647 AVSS_n1537 17.0005
R7393 AVSS_n1715 AVSS_n1537 17.0005
R7394 AVSS_n1648 AVSS_n1537 17.0005
R7395 AVSS_n1713 AVSS_n1537 17.0005
R7396 AVSS_n1649 AVSS_n1537 17.0005
R7397 AVSS_n1711 AVSS_n1537 17.0005
R7398 AVSS_n1650 AVSS_n1537 17.0005
R7399 AVSS_n1709 AVSS_n1537 17.0005
R7400 AVSS_n1651 AVSS_n1537 17.0005
R7401 AVSS_n1707 AVSS_n1537 17.0005
R7402 AVSS_n1652 AVSS_n1537 17.0005
R7403 AVSS_n1704 AVSS_n1537 17.0005
R7404 AVSS_n1653 AVSS_n1537 17.0005
R7405 AVSS_n1702 AVSS_n1537 17.0005
R7406 AVSS_n1654 AVSS_n1537 17.0005
R7407 AVSS_n1700 AVSS_n1537 17.0005
R7408 AVSS_n1655 AVSS_n1537 17.0005
R7409 AVSS_n1698 AVSS_n1537 17.0005
R7410 AVSS_n1656 AVSS_n1537 17.0005
R7411 AVSS_n1696 AVSS_n1537 17.0005
R7412 AVSS_n1657 AVSS_n1537 17.0005
R7413 AVSS_n1694 AVSS_n1537 17.0005
R7414 AVSS_n1658 AVSS_n1537 17.0005
R7415 AVSS_n1692 AVSS_n1537 17.0005
R7416 AVSS_n1659 AVSS_n1537 17.0005
R7417 AVSS_n1690 AVSS_n1537 17.0005
R7418 AVSS_n1660 AVSS_n1537 17.0005
R7419 AVSS_n1688 AVSS_n1537 17.0005
R7420 AVSS_n1661 AVSS_n1537 17.0005
R7421 AVSS_n1686 AVSS_n1537 17.0005
R7422 AVSS_n1662 AVSS_n1537 17.0005
R7423 AVSS_n1684 AVSS_n1537 17.0005
R7424 AVSS_n1663 AVSS_n1537 17.0005
R7425 AVSS_n1682 AVSS_n1537 17.0005
R7426 AVSS_n1664 AVSS_n1537 17.0005
R7427 AVSS_n1680 AVSS_n1537 17.0005
R7428 AVSS_n1665 AVSS_n1537 17.0005
R7429 AVSS_n1678 AVSS_n1537 17.0005
R7430 AVSS_n1666 AVSS_n1537 17.0005
R7431 AVSS_n1675 AVSS_n1537 17.0005
R7432 AVSS_n1667 AVSS_n1537 17.0005
R7433 AVSS_n1673 AVSS_n1537 17.0005
R7434 AVSS_n1668 AVSS_n1537 17.0005
R7435 AVSS_n1671 AVSS_n1537 17.0005
R7436 AVSS_n1669 AVSS_n1537 17.0005
R7437 AVSS_n2766 AVSS_n1537 17.0005
R7438 AVSS_n2766 AVSS_n1535 17.0005
R7439 AVSS_n1535 AVSS_n1514 17.0005
R7440 AVSS_n1535 AVSS_n1522 17.0005
R7441 AVSS_n1535 AVSS_n1515 17.0005
R7442 AVSS_n1535 AVSS_n1521 17.0005
R7443 AVSS_n1535 AVSS_n1516 17.0005
R7444 AVSS_n1535 AVSS_n1520 17.0005
R7445 AVSS_n1535 AVSS_n1517 17.0005
R7446 AVSS_n1535 AVSS_n1519 17.0005
R7447 AVSS_n1535 AVSS_n1518 17.0005
R7448 AVSS_n2768 AVSS_n1447 17.0005
R7449 AVSS_n1453 AVSS_n1447 17.0005
R7450 AVSS_n1487 AVSS_n1447 17.0005
R7451 AVSS_n1454 AVSS_n1447 17.0005
R7452 AVSS_n2770 AVSS_n1447 17.0005
R7453 AVSS_n1455 AVSS_n1447 17.0005
R7454 AVSS_n1486 AVSS_n1447 17.0005
R7455 AVSS_n1456 AVSS_n1447 17.0005
R7456 AVSS_n1484 AVSS_n1447 17.0005
R7457 AVSS_n1457 AVSS_n1447 17.0005
R7458 AVSS_n1483 AVSS_n1447 17.0005
R7459 AVSS_n1458 AVSS_n1447 17.0005
R7460 AVSS_n1482 AVSS_n1447 17.0005
R7461 AVSS_n1459 AVSS_n1447 17.0005
R7462 AVSS_n1481 AVSS_n1447 17.0005
R7463 AVSS_n1460 AVSS_n1447 17.0005
R7464 AVSS_n1480 AVSS_n1447 17.0005
R7465 AVSS_n1461 AVSS_n1447 17.0005
R7466 AVSS_n1479 AVSS_n1447 17.0005
R7467 AVSS_n1462 AVSS_n1447 17.0005
R7468 AVSS_n1447 AVSS_n1443 17.0005
R7469 AVSS_n1463 AVSS_n1447 17.0005
R7470 AVSS_n1478 AVSS_n1447 17.0005
R7471 AVSS_n1464 AVSS_n1447 17.0005
R7472 AVSS_n1477 AVSS_n1447 17.0005
R7473 AVSS_n1465 AVSS_n1447 17.0005
R7474 AVSS_n1476 AVSS_n1447 17.0005
R7475 AVSS_n1466 AVSS_n1447 17.0005
R7476 AVSS_n1475 AVSS_n1447 17.0005
R7477 AVSS_n1467 AVSS_n1447 17.0005
R7478 AVSS_n1474 AVSS_n1447 17.0005
R7479 AVSS_n1468 AVSS_n1447 17.0005
R7480 AVSS_n1471 AVSS_n1447 17.0005
R7481 AVSS_n1469 AVSS_n1447 17.0005
R7482 AVSS_n1470 AVSS_n1447 17.0005
R7483 AVSS_n1447 AVSS_n1059 17.0005
R7484 AVSS_n2812 AVSS_n1001 17.0005
R7485 AVSS_n1007 AVSS_n1001 17.0005
R7486 AVSS_n1029 AVSS_n1001 17.0005
R7487 AVSS_n1008 AVSS_n1001 17.0005
R7488 AVSS_n1009 AVSS_n1001 17.0005
R7489 AVSS_n1026 AVSS_n1001 17.0005
R7490 AVSS_n1010 AVSS_n1001 17.0005
R7491 AVSS_n1024 AVSS_n1001 17.0005
R7492 AVSS_n1011 AVSS_n1001 17.0005
R7493 AVSS_n1018 AVSS_n1001 17.0005
R7494 AVSS_n1012 AVSS_n1001 17.0005
R7495 AVSS_n1017 AVSS_n1001 17.0005
R7496 AVSS_n1013 AVSS_n1001 17.0005
R7497 AVSS_n1015 AVSS_n1001 17.0005
R7498 AVSS_n2814 AVSS_n1001 17.0005
R7499 AVSS_n2814 AVSS_n837 17.0005
R7500 AVSS_n843 AVSS_n837 17.0005
R7501 AVSS_n952 AVSS_n837 17.0005
R7502 AVSS_n844 AVSS_n837 17.0005
R7503 AVSS_n951 AVSS_n837 17.0005
R7504 AVSS_n845 AVSS_n837 17.0005
R7505 AVSS_n950 AVSS_n837 17.0005
R7506 AVSS_n846 AVSS_n837 17.0005
R7507 AVSS_n949 AVSS_n837 17.0005
R7508 AVSS_n847 AVSS_n837 17.0005
R7509 AVSS_n837 AVSS_n778 17.0005
R7510 AVSS_n849 AVSS_n837 17.0005
R7511 AVSS_n948 AVSS_n837 17.0005
R7512 AVSS_n850 AVSS_n837 17.0005
R7513 AVSS_n946 AVSS_n837 17.0005
R7514 AVSS_n851 AVSS_n837 17.0005
R7515 AVSS_n945 AVSS_n837 17.0005
R7516 AVSS_n852 AVSS_n837 17.0005
R7517 AVSS_n837 AVSS_n782 17.0005
R7518 AVSS_n854 AVSS_n837 17.0005
R7519 AVSS_n944 AVSS_n837 17.0005
R7520 AVSS_n855 AVSS_n837 17.0005
R7521 AVSS_n943 AVSS_n837 17.0005
R7522 AVSS_n856 AVSS_n837 17.0005
R7523 AVSS_n942 AVSS_n837 17.0005
R7524 AVSS_n857 AVSS_n837 17.0005
R7525 AVSS_n941 AVSS_n837 17.0005
R7526 AVSS_n858 AVSS_n837 17.0005
R7527 AVSS_n940 AVSS_n837 17.0005
R7528 AVSS_n859 AVSS_n837 17.0005
R7529 AVSS_n939 AVSS_n837 17.0005
R7530 AVSS_n860 AVSS_n837 17.0005
R7531 AVSS_n938 AVSS_n837 17.0005
R7532 AVSS_n837 AVSS_n790 17.0005
R7533 AVSS_n937 AVSS_n837 17.0005
R7534 AVSS_n861 AVSS_n837 17.0005
R7535 AVSS_n935 AVSS_n837 17.0005
R7536 AVSS_n862 AVSS_n837 17.0005
R7537 AVSS_n837 AVSS_n793 17.0005
R7538 AVSS_n864 AVSS_n837 17.0005
R7539 AVSS_n934 AVSS_n837 17.0005
R7540 AVSS_n837 AVSS_n795 17.0005
R7541 AVSS_n933 AVSS_n837 17.0005
R7542 AVSS_n865 AVSS_n837 17.0005
R7543 AVSS_n931 AVSS_n837 17.0005
R7544 AVSS_n866 AVSS_n837 17.0005
R7545 AVSS_n930 AVSS_n837 17.0005
R7546 AVSS_n867 AVSS_n837 17.0005
R7547 AVSS_n929 AVSS_n837 17.0005
R7548 AVSS_n868 AVSS_n837 17.0005
R7549 AVSS_n928 AVSS_n837 17.0005
R7550 AVSS_n871 AVSS_n837 17.0005
R7551 AVSS_n927 AVSS_n837 17.0005
R7552 AVSS_n837 AVSS_n803 17.0005
R7553 AVSS_n873 AVSS_n837 17.0005
R7554 AVSS_n926 AVSS_n837 17.0005
R7555 AVSS_n837 AVSS_n805 17.0005
R7556 AVSS_n925 AVSS_n837 17.0005
R7557 AVSS_n874 AVSS_n837 17.0005
R7558 AVSS_n923 AVSS_n837 17.0005
R7559 AVSS_n875 AVSS_n837 17.0005
R7560 AVSS_n922 AVSS_n837 17.0005
R7561 AVSS_n876 AVSS_n837 17.0005
R7562 AVSS_n837 AVSS_n809 17.0005
R7563 AVSS_n878 AVSS_n837 17.0005
R7564 AVSS_n921 AVSS_n837 17.0005
R7565 AVSS_n879 AVSS_n837 17.0005
R7566 AVSS_n920 AVSS_n837 17.0005
R7567 AVSS_n880 AVSS_n837 17.0005
R7568 AVSS_n919 AVSS_n837 17.0005
R7569 AVSS_n837 AVSS_n813 17.0005
R7570 AVSS_n918 AVSS_n837 17.0005
R7571 AVSS_n881 AVSS_n837 17.0005
R7572 AVSS_n837 AVSS_n815 17.0005
R7573 AVSS_n883 AVSS_n837 17.0005
R7574 AVSS_n916 AVSS_n837 17.0005
R7575 AVSS_n884 AVSS_n837 17.0005
R7576 AVSS_n915 AVSS_n837 17.0005
R7577 AVSS_n885 AVSS_n837 17.0005
R7578 AVSS_n914 AVSS_n837 17.0005
R7579 AVSS_n837 AVSS_n819 17.0005
R7580 AVSS_n913 AVSS_n837 17.0005
R7581 AVSS_n886 AVSS_n837 17.0005
R7582 AVSS_n837 AVSS_n821 17.0005
R7583 AVSS_n888 AVSS_n837 17.0005
R7584 AVSS_n911 AVSS_n837 17.0005
R7585 AVSS_n889 AVSS_n837 17.0005
R7586 AVSS_n910 AVSS_n837 17.0005
R7587 AVSS_n890 AVSS_n837 17.0005
R7588 AVSS_n909 AVSS_n837 17.0005
R7589 AVSS_n837 AVSS_n825 17.0005
R7590 AVSS_n908 AVSS_n837 17.0005
R7591 AVSS_n891 AVSS_n837 17.0005
R7592 AVSS_n906 AVSS_n837 17.0005
R7593 AVSS_n892 AVSS_n837 17.0005
R7594 AVSS_n905 AVSS_n837 17.0005
R7595 AVSS_n893 AVSS_n837 17.0005
R7596 AVSS_n837 AVSS_n829 17.0005
R7597 AVSS_n895 AVSS_n837 17.0005
R7598 AVSS_n904 AVSS_n837 17.0005
R7599 AVSS_n896 AVSS_n837 17.0005
R7600 AVSS_n903 AVSS_n837 17.0005
R7601 AVSS_n897 AVSS_n837 17.0005
R7602 AVSS_n902 AVSS_n837 17.0005
R7603 AVSS_n898 AVSS_n837 17.0005
R7604 AVSS_n901 AVSS_n837 17.0005
R7605 AVSS_n899 AVSS_n837 17.0005
R7606 AVSS_n900 AVSS_n837 17.0005
R7607 AVSS_n2816 AVSS_n837 17.0005
R7608 AVSS_n2762 AVSS_n1913 17.0005
R7609 AVSS_n1916 AVSS_n1913 17.0005
R7610 AVSS_n2046 AVSS_n1913 17.0005
R7611 AVSS_n1917 AVSS_n1913 17.0005
R7612 AVSS_n2044 AVSS_n1913 17.0005
R7613 AVSS_n1918 AVSS_n1913 17.0005
R7614 AVSS_n2042 AVSS_n1913 17.0005
R7615 AVSS_n1919 AVSS_n1913 17.0005
R7616 AVSS_n2040 AVSS_n1913 17.0005
R7617 AVSS_n1920 AVSS_n1913 17.0005
R7618 AVSS_n2035 AVSS_n1913 17.0005
R7619 AVSS_n1921 AVSS_n1913 17.0005
R7620 AVSS_n2033 AVSS_n1913 17.0005
R7621 AVSS_n1922 AVSS_n1913 17.0005
R7622 AVSS_n2031 AVSS_n1913 17.0005
R7623 AVSS_n1923 AVSS_n1913 17.0005
R7624 AVSS_n2029 AVSS_n1913 17.0005
R7625 AVSS_n1924 AVSS_n1913 17.0005
R7626 AVSS_n2027 AVSS_n1913 17.0005
R7627 AVSS_n1925 AVSS_n1913 17.0005
R7628 AVSS_n2025 AVSS_n1913 17.0005
R7629 AVSS_n1926 AVSS_n1913 17.0005
R7630 AVSS_n1927 AVSS_n1913 17.0005
R7631 AVSS_n2023 AVSS_n1913 17.0005
R7632 AVSS_n1928 AVSS_n1913 17.0005
R7633 AVSS_n2021 AVSS_n1913 17.0005
R7634 AVSS_n1929 AVSS_n1913 17.0005
R7635 AVSS_n2018 AVSS_n1913 17.0005
R7636 AVSS_n1930 AVSS_n1913 17.0005
R7637 AVSS_n2016 AVSS_n1913 17.0005
R7638 AVSS_n1932 AVSS_n1913 17.0005
R7639 AVSS_n2010 AVSS_n1913 17.0005
R7640 AVSS_n1933 AVSS_n1913 17.0005
R7641 AVSS_n2008 AVSS_n1913 17.0005
R7642 AVSS_n1934 AVSS_n1913 17.0005
R7643 AVSS_n2006 AVSS_n1913 17.0005
R7644 AVSS_n1935 AVSS_n1913 17.0005
R7645 AVSS_n2004 AVSS_n1913 17.0005
R7646 AVSS_n1936 AVSS_n1913 17.0005
R7647 AVSS_n2002 AVSS_n1913 17.0005
R7648 AVSS_n1937 AVSS_n1913 17.0005
R7649 AVSS_n2000 AVSS_n1913 17.0005
R7650 AVSS_n1938 AVSS_n1913 17.0005
R7651 AVSS_n1998 AVSS_n1913 17.0005
R7652 AVSS_n1939 AVSS_n1913 17.0005
R7653 AVSS_n1996 AVSS_n1913 17.0005
R7654 AVSS_n1940 AVSS_n1913 17.0005
R7655 AVSS_n1994 AVSS_n1913 17.0005
R7656 AVSS_n1941 AVSS_n1913 17.0005
R7657 AVSS_n1991 AVSS_n1913 17.0005
R7658 AVSS_n1942 AVSS_n1913 17.0005
R7659 AVSS_n1989 AVSS_n1913 17.0005
R7660 AVSS_n1943 AVSS_n1913 17.0005
R7661 AVSS_n1987 AVSS_n1913 17.0005
R7662 AVSS_n1944 AVSS_n1913 17.0005
R7663 AVSS_n1985 AVSS_n1913 17.0005
R7664 AVSS_n1945 AVSS_n1913 17.0005
R7665 AVSS_n1983 AVSS_n1913 17.0005
R7666 AVSS_n1946 AVSS_n1913 17.0005
R7667 AVSS_n1981 AVSS_n1913 17.0005
R7668 AVSS_n1947 AVSS_n1913 17.0005
R7669 AVSS_n1979 AVSS_n1913 17.0005
R7670 AVSS_n1948 AVSS_n1913 17.0005
R7671 AVSS_n1977 AVSS_n1913 17.0005
R7672 AVSS_n1949 AVSS_n1913 17.0005
R7673 AVSS_n1974 AVSS_n1913 17.0005
R7674 AVSS_n1950 AVSS_n1913 17.0005
R7675 AVSS_n1972 AVSS_n1913 17.0005
R7676 AVSS_n1951 AVSS_n1913 17.0005
R7677 AVSS_n1970 AVSS_n1913 17.0005
R7678 AVSS_n1952 AVSS_n1913 17.0005
R7679 AVSS_n1968 AVSS_n1913 17.0005
R7680 AVSS_n1953 AVSS_n1913 17.0005
R7681 AVSS_n1966 AVSS_n1913 17.0005
R7682 AVSS_n1954 AVSS_n1913 17.0005
R7683 AVSS_n1964 AVSS_n1913 17.0005
R7684 AVSS_n1955 AVSS_n1913 17.0005
R7685 AVSS_n1962 AVSS_n1913 17.0005
R7686 AVSS_n1956 AVSS_n1913 17.0005
R7687 AVSS_n1960 AVSS_n1913 17.0005
R7688 AVSS_n1957 AVSS_n1913 17.0005
R7689 AVSS_n2764 AVSS_n1913 17.0005
R7690 AVSS_n2764 AVSS_n1540 17.0005
R7691 AVSS_n1558 AVSS_n1540 17.0005
R7692 AVSS_n1907 AVSS_n1540 17.0005
R7693 AVSS_n1559 AVSS_n1540 17.0005
R7694 AVSS_n1905 AVSS_n1540 17.0005
R7695 AVSS_n1560 AVSS_n1540 17.0005
R7696 AVSS_n1903 AVSS_n1540 17.0005
R7697 AVSS_n1561 AVSS_n1540 17.0005
R7698 AVSS_n1901 AVSS_n1540 17.0005
R7699 AVSS_n1562 AVSS_n1540 17.0005
R7700 AVSS_n1899 AVSS_n1540 17.0005
R7701 AVSS_n1563 AVSS_n1540 17.0005
R7702 AVSS_n1896 AVSS_n1540 17.0005
R7703 AVSS_n1564 AVSS_n1540 17.0005
R7704 AVSS_n1894 AVSS_n1540 17.0005
R7705 AVSS_n1565 AVSS_n1540 17.0005
R7706 AVSS_n1892 AVSS_n1540 17.0005
R7707 AVSS_n1566 AVSS_n1540 17.0005
R7708 AVSS_n1886 AVSS_n1540 17.0005
R7709 AVSS_n1567 AVSS_n1540 17.0005
R7710 AVSS_n1885 AVSS_n1540 17.0005
R7711 AVSS_n1568 AVSS_n1540 17.0005
R7712 AVSS_n1883 AVSS_n1540 17.0005
R7713 AVSS_n1881 AVSS_n1540 17.0005
R7714 AVSS_n1569 AVSS_n1540 17.0005
R7715 AVSS_n1879 AVSS_n1540 17.0005
R7716 AVSS_n1570 AVSS_n1540 17.0005
R7717 AVSS_n1877 AVSS_n1540 17.0005
R7718 AVSS_n1571 AVSS_n1540 17.0005
R7719 AVSS_n1875 AVSS_n1540 17.0005
R7720 AVSS_n1572 AVSS_n1540 17.0005
R7721 AVSS_n1873 AVSS_n1540 17.0005
R7722 AVSS_n1573 AVSS_n1540 17.0005
R7723 AVSS_n1871 AVSS_n1540 17.0005
R7724 AVSS_n1574 AVSS_n1540 17.0005
R7725 AVSS_n1869 AVSS_n1540 17.0005
R7726 AVSS_n1575 AVSS_n1540 17.0005
R7727 AVSS_n1867 AVSS_n1540 17.0005
R7728 AVSS_n1576 AVSS_n1540 17.0005
R7729 AVSS_n1865 AVSS_n1540 17.0005
R7730 AVSS_n1577 AVSS_n1540 17.0005
R7731 AVSS_n1863 AVSS_n1540 17.0005
R7732 AVSS_n1578 AVSS_n1540 17.0005
R7733 AVSS_n1860 AVSS_n1540 17.0005
R7734 AVSS_n1579 AVSS_n1540 17.0005
R7735 AVSS_n1858 AVSS_n1540 17.0005
R7736 AVSS_n1580 AVSS_n1540 17.0005
R7737 AVSS_n1856 AVSS_n1540 17.0005
R7738 AVSS_n1581 AVSS_n1540 17.0005
R7739 AVSS_n1854 AVSS_n1540 17.0005
R7740 AVSS_n1582 AVSS_n1540 17.0005
R7741 AVSS_n1852 AVSS_n1540 17.0005
R7742 AVSS_n1583 AVSS_n1540 17.0005
R7743 AVSS_n1849 AVSS_n1540 17.0005
R7744 AVSS_n1584 AVSS_n1540 17.0005
R7745 AVSS_n1847 AVSS_n1540 17.0005
R7746 AVSS_n1585 AVSS_n1540 17.0005
R7747 AVSS_n1845 AVSS_n1540 17.0005
R7748 AVSS_n1586 AVSS_n1540 17.0005
R7749 AVSS_n1843 AVSS_n1540 17.0005
R7750 AVSS_n1587 AVSS_n1540 17.0005
R7751 AVSS_n1841 AVSS_n1540 17.0005
R7752 AVSS_n1588 AVSS_n1540 17.0005
R7753 AVSS_n1838 AVSS_n1540 17.0005
R7754 AVSS_n1589 AVSS_n1540 17.0005
R7755 AVSS_n1836 AVSS_n1540 17.0005
R7756 AVSS_n1590 AVSS_n1540 17.0005
R7757 AVSS_n1834 AVSS_n1540 17.0005
R7758 AVSS_n1591 AVSS_n1540 17.0005
R7759 AVSS_n1831 AVSS_n1540 17.0005
R7760 AVSS_n1592 AVSS_n1540 17.0005
R7761 AVSS_n1829 AVSS_n1540 17.0005
R7762 AVSS_n1593 AVSS_n1540 17.0005
R7763 AVSS_n1827 AVSS_n1540 17.0005
R7764 AVSS_n1594 AVSS_n1540 17.0005
R7765 AVSS_n1825 AVSS_n1540 17.0005
R7766 AVSS_n1595 AVSS_n1540 17.0005
R7767 AVSS_n1823 AVSS_n1540 17.0005
R7768 AVSS_n1596 AVSS_n1540 17.0005
R7769 AVSS_n1821 AVSS_n1540 17.0005
R7770 AVSS_n1598 AVSS_n1540 17.0005
R7771 AVSS_n1817 AVSS_n1540 17.0005
R7772 AVSS_n1599 AVSS_n1540 17.0005
R7773 AVSS_n1815 AVSS_n1540 17.0005
R7774 AVSS_n1600 AVSS_n1540 17.0005
R7775 AVSS_n1813 AVSS_n1540 17.0005
R7776 AVSS_n1601 AVSS_n1540 17.0005
R7777 AVSS_n1810 AVSS_n1540 17.0005
R7778 AVSS_n1602 AVSS_n1540 17.0005
R7779 AVSS_n1808 AVSS_n1540 17.0005
R7780 AVSS_n1603 AVSS_n1540 17.0005
R7781 AVSS_n1806 AVSS_n1540 17.0005
R7782 AVSS_n1604 AVSS_n1540 17.0005
R7783 AVSS_n1804 AVSS_n1540 17.0005
R7784 AVSS_n1605 AVSS_n1540 17.0005
R7785 AVSS_n1802 AVSS_n1540 17.0005
R7786 AVSS_n1606 AVSS_n1540 17.0005
R7787 AVSS_n1800 AVSS_n1540 17.0005
R7788 AVSS_n1607 AVSS_n1540 17.0005
R7789 AVSS_n1798 AVSS_n1540 17.0005
R7790 AVSS_n1608 AVSS_n1540 17.0005
R7791 AVSS_n1796 AVSS_n1540 17.0005
R7792 AVSS_n1609 AVSS_n1540 17.0005
R7793 AVSS_n1794 AVSS_n1540 17.0005
R7794 AVSS_n1610 AVSS_n1540 17.0005
R7795 AVSS_n1792 AVSS_n1540 17.0005
R7796 AVSS_n1611 AVSS_n1540 17.0005
R7797 AVSS_n1790 AVSS_n1540 17.0005
R7798 AVSS_n1612 AVSS_n1540 17.0005
R7799 AVSS_n1788 AVSS_n1540 17.0005
R7800 AVSS_n1613 AVSS_n1540 17.0005
R7801 AVSS_n1786 AVSS_n1540 17.0005
R7802 AVSS_n1614 AVSS_n1540 17.0005
R7803 AVSS_n1784 AVSS_n1540 17.0005
R7804 AVSS_n1615 AVSS_n1540 17.0005
R7805 AVSS_n1781 AVSS_n1540 17.0005
R7806 AVSS_n1616 AVSS_n1540 17.0005
R7807 AVSS_n1779 AVSS_n1540 17.0005
R7808 AVSS_n1617 AVSS_n1540 17.0005
R7809 AVSS_n1777 AVSS_n1540 17.0005
R7810 AVSS_n1618 AVSS_n1540 17.0005
R7811 AVSS_n1775 AVSS_n1540 17.0005
R7812 AVSS_n1619 AVSS_n1540 17.0005
R7813 AVSS_n1773 AVSS_n1540 17.0005
R7814 AVSS_n1620 AVSS_n1540 17.0005
R7815 AVSS_n1771 AVSS_n1540 17.0005
R7816 AVSS_n1621 AVSS_n1540 17.0005
R7817 AVSS_n1769 AVSS_n1540 17.0005
R7818 AVSS_n1622 AVSS_n1540 17.0005
R7819 AVSS_n1766 AVSS_n1540 17.0005
R7820 AVSS_n1623 AVSS_n1540 17.0005
R7821 AVSS_n1764 AVSS_n1540 17.0005
R7822 AVSS_n1624 AVSS_n1540 17.0005
R7823 AVSS_n1762 AVSS_n1540 17.0005
R7824 AVSS_n1625 AVSS_n1540 17.0005
R7825 AVSS_n1760 AVSS_n1540 17.0005
R7826 AVSS_n1626 AVSS_n1540 17.0005
R7827 AVSS_n1758 AVSS_n1540 17.0005
R7828 AVSS_n1627 AVSS_n1540 17.0005
R7829 AVSS_n1756 AVSS_n1540 17.0005
R7830 AVSS_n1628 AVSS_n1540 17.0005
R7831 AVSS_n1753 AVSS_n1540 17.0005
R7832 AVSS_n1629 AVSS_n1540 17.0005
R7833 AVSS_n1751 AVSS_n1540 17.0005
R7834 AVSS_n1630 AVSS_n1540 17.0005
R7835 AVSS_n1749 AVSS_n1540 17.0005
R7836 AVSS_n1631 AVSS_n1540 17.0005
R7837 AVSS_n1747 AVSS_n1540 17.0005
R7838 AVSS_n1632 AVSS_n1540 17.0005
R7839 AVSS_n1745 AVSS_n1540 17.0005
R7840 AVSS_n1633 AVSS_n1540 17.0005
R7841 AVSS_n1743 AVSS_n1540 17.0005
R7842 AVSS_n1634 AVSS_n1540 17.0005
R7843 AVSS_n1741 AVSS_n1540 17.0005
R7844 AVSS_n1635 AVSS_n1540 17.0005
R7845 AVSS_n1739 AVSS_n1540 17.0005
R7846 AVSS_n1636 AVSS_n1540 17.0005
R7847 AVSS_n1737 AVSS_n1540 17.0005
R7848 AVSS_n1637 AVSS_n1540 17.0005
R7849 AVSS_n1735 AVSS_n1540 17.0005
R7850 AVSS_n1638 AVSS_n1540 17.0005
R7851 AVSS_n1733 AVSS_n1540 17.0005
R7852 AVSS_n1639 AVSS_n1540 17.0005
R7853 AVSS_n1731 AVSS_n1540 17.0005
R7854 AVSS_n1640 AVSS_n1540 17.0005
R7855 AVSS_n1729 AVSS_n1540 17.0005
R7856 AVSS_n1641 AVSS_n1540 17.0005
R7857 AVSS_n1727 AVSS_n1540 17.0005
R7858 AVSS_n1642 AVSS_n1540 17.0005
R7859 AVSS_n1725 AVSS_n1540 17.0005
R7860 AVSS_n1643 AVSS_n1540 17.0005
R7861 AVSS_n1723 AVSS_n1540 17.0005
R7862 AVSS_n1644 AVSS_n1540 17.0005
R7863 AVSS_n1721 AVSS_n1540 17.0005
R7864 AVSS_n1645 AVSS_n1540 17.0005
R7865 AVSS_n1719 AVSS_n1540 17.0005
R7866 AVSS_n1646 AVSS_n1540 17.0005
R7867 AVSS_n1717 AVSS_n1540 17.0005
R7868 AVSS_n1647 AVSS_n1540 17.0005
R7869 AVSS_n1715 AVSS_n1540 17.0005
R7870 AVSS_n1648 AVSS_n1540 17.0005
R7871 AVSS_n1713 AVSS_n1540 17.0005
R7872 AVSS_n1649 AVSS_n1540 17.0005
R7873 AVSS_n1711 AVSS_n1540 17.0005
R7874 AVSS_n1650 AVSS_n1540 17.0005
R7875 AVSS_n1709 AVSS_n1540 17.0005
R7876 AVSS_n1651 AVSS_n1540 17.0005
R7877 AVSS_n1707 AVSS_n1540 17.0005
R7878 AVSS_n1652 AVSS_n1540 17.0005
R7879 AVSS_n1704 AVSS_n1540 17.0005
R7880 AVSS_n1653 AVSS_n1540 17.0005
R7881 AVSS_n1702 AVSS_n1540 17.0005
R7882 AVSS_n1654 AVSS_n1540 17.0005
R7883 AVSS_n1700 AVSS_n1540 17.0005
R7884 AVSS_n1655 AVSS_n1540 17.0005
R7885 AVSS_n1698 AVSS_n1540 17.0005
R7886 AVSS_n1656 AVSS_n1540 17.0005
R7887 AVSS_n1696 AVSS_n1540 17.0005
R7888 AVSS_n1657 AVSS_n1540 17.0005
R7889 AVSS_n1694 AVSS_n1540 17.0005
R7890 AVSS_n1658 AVSS_n1540 17.0005
R7891 AVSS_n1692 AVSS_n1540 17.0005
R7892 AVSS_n1659 AVSS_n1540 17.0005
R7893 AVSS_n1690 AVSS_n1540 17.0005
R7894 AVSS_n1660 AVSS_n1540 17.0005
R7895 AVSS_n1688 AVSS_n1540 17.0005
R7896 AVSS_n1661 AVSS_n1540 17.0005
R7897 AVSS_n1686 AVSS_n1540 17.0005
R7898 AVSS_n1662 AVSS_n1540 17.0005
R7899 AVSS_n1684 AVSS_n1540 17.0005
R7900 AVSS_n1663 AVSS_n1540 17.0005
R7901 AVSS_n1682 AVSS_n1540 17.0005
R7902 AVSS_n1664 AVSS_n1540 17.0005
R7903 AVSS_n1680 AVSS_n1540 17.0005
R7904 AVSS_n1665 AVSS_n1540 17.0005
R7905 AVSS_n1678 AVSS_n1540 17.0005
R7906 AVSS_n1666 AVSS_n1540 17.0005
R7907 AVSS_n1675 AVSS_n1540 17.0005
R7908 AVSS_n1667 AVSS_n1540 17.0005
R7909 AVSS_n1673 AVSS_n1540 17.0005
R7910 AVSS_n1668 AVSS_n1540 17.0005
R7911 AVSS_n1671 AVSS_n1540 17.0005
R7912 AVSS_n1669 AVSS_n1540 17.0005
R7913 AVSS_n2766 AVSS_n1540 17.0005
R7914 AVSS_n2766 AVSS_n1524 17.0005
R7915 AVSS_n1524 AVSS_n1515 17.0005
R7916 AVSS_n1524 AVSS_n1521 17.0005
R7917 AVSS_n1524 AVSS_n1516 17.0005
R7918 AVSS_n1524 AVSS_n1520 17.0005
R7919 AVSS_n1524 AVSS_n1517 17.0005
R7920 AVSS_n1524 AVSS_n1519 17.0005
R7921 AVSS_n1524 AVSS_n1518 17.0005
R7922 AVSS_n2768 AVSS_n1450 17.0005
R7923 AVSS_n1453 AVSS_n1450 17.0005
R7924 AVSS_n1487 AVSS_n1450 17.0005
R7925 AVSS_n1454 AVSS_n1450 17.0005
R7926 AVSS_n2770 AVSS_n1450 17.0005
R7927 AVSS_n1456 AVSS_n1450 17.0005
R7928 AVSS_n1484 AVSS_n1450 17.0005
R7929 AVSS_n1457 AVSS_n1450 17.0005
R7930 AVSS_n1483 AVSS_n1450 17.0005
R7931 AVSS_n1458 AVSS_n1450 17.0005
R7932 AVSS_n1482 AVSS_n1450 17.0005
R7933 AVSS_n1459 AVSS_n1450 17.0005
R7934 AVSS_n1481 AVSS_n1450 17.0005
R7935 AVSS_n1460 AVSS_n1450 17.0005
R7936 AVSS_n1480 AVSS_n1450 17.0005
R7937 AVSS_n1461 AVSS_n1450 17.0005
R7938 AVSS_n1479 AVSS_n1450 17.0005
R7939 AVSS_n1462 AVSS_n1450 17.0005
R7940 AVSS_n1450 AVSS_n1443 17.0005
R7941 AVSS_n1463 AVSS_n1450 17.0005
R7942 AVSS_n1478 AVSS_n1450 17.0005
R7943 AVSS_n1464 AVSS_n1450 17.0005
R7944 AVSS_n1477 AVSS_n1450 17.0005
R7945 AVSS_n1465 AVSS_n1450 17.0005
R7946 AVSS_n1476 AVSS_n1450 17.0005
R7947 AVSS_n1466 AVSS_n1450 17.0005
R7948 AVSS_n1475 AVSS_n1450 17.0005
R7949 AVSS_n1467 AVSS_n1450 17.0005
R7950 AVSS_n1474 AVSS_n1450 17.0005
R7951 AVSS_n1468 AVSS_n1450 17.0005
R7952 AVSS_n1471 AVSS_n1450 17.0005
R7953 AVSS_n1469 AVSS_n1450 17.0005
R7954 AVSS_n1470 AVSS_n1450 17.0005
R7955 AVSS_n1450 AVSS_n1059 17.0005
R7956 AVSS_n1029 AVSS_n1004 17.0005
R7957 AVSS_n1008 AVSS_n1004 17.0005
R7958 AVSS_n1009 AVSS_n1004 17.0005
R7959 AVSS_n1026 AVSS_n1004 17.0005
R7960 AVSS_n1010 AVSS_n1004 17.0005
R7961 AVSS_n1024 AVSS_n1004 17.0005
R7962 AVSS_n1011 AVSS_n1004 17.0005
R7963 AVSS_n1018 AVSS_n1004 17.0005
R7964 AVSS_n1012 AVSS_n1004 17.0005
R7965 AVSS_n1017 AVSS_n1004 17.0005
R7966 AVSS_n1013 AVSS_n1004 17.0005
R7967 AVSS_n1015 AVSS_n1004 17.0005
R7968 AVSS_n2814 AVSS_n1004 17.0005
R7969 AVSS_n2814 AVSS_n840 17.0005
R7970 AVSS_n843 AVSS_n840 17.0005
R7971 AVSS_n952 AVSS_n840 17.0005
R7972 AVSS_n844 AVSS_n840 17.0005
R7973 AVSS_n951 AVSS_n840 17.0005
R7974 AVSS_n845 AVSS_n840 17.0005
R7975 AVSS_n950 AVSS_n840 17.0005
R7976 AVSS_n846 AVSS_n840 17.0005
R7977 AVSS_n949 AVSS_n840 17.0005
R7978 AVSS_n847 AVSS_n840 17.0005
R7979 AVSS_n948 AVSS_n840 17.0005
R7980 AVSS_n850 AVSS_n840 17.0005
R7981 AVSS_n946 AVSS_n840 17.0005
R7982 AVSS_n851 AVSS_n840 17.0005
R7983 AVSS_n945 AVSS_n840 17.0005
R7984 AVSS_n852 AVSS_n840 17.0005
R7985 AVSS_n840 AVSS_n782 17.0005
R7986 AVSS_n854 AVSS_n840 17.0005
R7987 AVSS_n944 AVSS_n840 17.0005
R7988 AVSS_n855 AVSS_n840 17.0005
R7989 AVSS_n943 AVSS_n840 17.0005
R7990 AVSS_n856 AVSS_n840 17.0005
R7991 AVSS_n942 AVSS_n840 17.0005
R7992 AVSS_n857 AVSS_n840 17.0005
R7993 AVSS_n941 AVSS_n840 17.0005
R7994 AVSS_n858 AVSS_n840 17.0005
R7995 AVSS_n940 AVSS_n840 17.0005
R7996 AVSS_n859 AVSS_n840 17.0005
R7997 AVSS_n939 AVSS_n840 17.0005
R7998 AVSS_n860 AVSS_n840 17.0005
R7999 AVSS_n938 AVSS_n840 17.0005
R8000 AVSS_n840 AVSS_n790 17.0005
R8001 AVSS_n937 AVSS_n840 17.0005
R8002 AVSS_n861 AVSS_n840 17.0005
R8003 AVSS_n935 AVSS_n840 17.0005
R8004 AVSS_n862 AVSS_n840 17.0005
R8005 AVSS_n840 AVSS_n793 17.0005
R8006 AVSS_n864 AVSS_n840 17.0005
R8007 AVSS_n934 AVSS_n840 17.0005
R8008 AVSS_n840 AVSS_n795 17.0005
R8009 AVSS_n933 AVSS_n840 17.0005
R8010 AVSS_n865 AVSS_n840 17.0005
R8011 AVSS_n931 AVSS_n840 17.0005
R8012 AVSS_n866 AVSS_n840 17.0005
R8013 AVSS_n930 AVSS_n840 17.0005
R8014 AVSS_n867 AVSS_n840 17.0005
R8015 AVSS_n929 AVSS_n840 17.0005
R8016 AVSS_n868 AVSS_n840 17.0005
R8017 AVSS_n928 AVSS_n840 17.0005
R8018 AVSS_n871 AVSS_n840 17.0005
R8019 AVSS_n927 AVSS_n840 17.0005
R8020 AVSS_n840 AVSS_n803 17.0005
R8021 AVSS_n873 AVSS_n840 17.0005
R8022 AVSS_n926 AVSS_n840 17.0005
R8023 AVSS_n840 AVSS_n805 17.0005
R8024 AVSS_n925 AVSS_n840 17.0005
R8025 AVSS_n874 AVSS_n840 17.0005
R8026 AVSS_n923 AVSS_n840 17.0005
R8027 AVSS_n875 AVSS_n840 17.0005
R8028 AVSS_n922 AVSS_n840 17.0005
R8029 AVSS_n876 AVSS_n840 17.0005
R8030 AVSS_n840 AVSS_n809 17.0005
R8031 AVSS_n878 AVSS_n840 17.0005
R8032 AVSS_n921 AVSS_n840 17.0005
R8033 AVSS_n879 AVSS_n840 17.0005
R8034 AVSS_n920 AVSS_n840 17.0005
R8035 AVSS_n880 AVSS_n840 17.0005
R8036 AVSS_n919 AVSS_n840 17.0005
R8037 AVSS_n840 AVSS_n813 17.0005
R8038 AVSS_n918 AVSS_n840 17.0005
R8039 AVSS_n881 AVSS_n840 17.0005
R8040 AVSS_n840 AVSS_n815 17.0005
R8041 AVSS_n883 AVSS_n840 17.0005
R8042 AVSS_n916 AVSS_n840 17.0005
R8043 AVSS_n884 AVSS_n840 17.0005
R8044 AVSS_n915 AVSS_n840 17.0005
R8045 AVSS_n885 AVSS_n840 17.0005
R8046 AVSS_n914 AVSS_n840 17.0005
R8047 AVSS_n840 AVSS_n819 17.0005
R8048 AVSS_n913 AVSS_n840 17.0005
R8049 AVSS_n886 AVSS_n840 17.0005
R8050 AVSS_n840 AVSS_n821 17.0005
R8051 AVSS_n888 AVSS_n840 17.0005
R8052 AVSS_n911 AVSS_n840 17.0005
R8053 AVSS_n889 AVSS_n840 17.0005
R8054 AVSS_n910 AVSS_n840 17.0005
R8055 AVSS_n890 AVSS_n840 17.0005
R8056 AVSS_n909 AVSS_n840 17.0005
R8057 AVSS_n840 AVSS_n825 17.0005
R8058 AVSS_n908 AVSS_n840 17.0005
R8059 AVSS_n891 AVSS_n840 17.0005
R8060 AVSS_n906 AVSS_n840 17.0005
R8061 AVSS_n892 AVSS_n840 17.0005
R8062 AVSS_n905 AVSS_n840 17.0005
R8063 AVSS_n893 AVSS_n840 17.0005
R8064 AVSS_n840 AVSS_n829 17.0005
R8065 AVSS_n895 AVSS_n840 17.0005
R8066 AVSS_n904 AVSS_n840 17.0005
R8067 AVSS_n896 AVSS_n840 17.0005
R8068 AVSS_n903 AVSS_n840 17.0005
R8069 AVSS_n897 AVSS_n840 17.0005
R8070 AVSS_n902 AVSS_n840 17.0005
R8071 AVSS_n898 AVSS_n840 17.0005
R8072 AVSS_n901 AVSS_n840 17.0005
R8073 AVSS_n899 AVSS_n840 17.0005
R8074 AVSS_n900 AVSS_n840 17.0005
R8075 AVSS_n2816 AVSS_n840 17.0005
R8076 AVSS_n2762 AVSS_n1910 17.0005
R8077 AVSS_n1916 AVSS_n1910 17.0005
R8078 AVSS_n2046 AVSS_n1910 17.0005
R8079 AVSS_n1917 AVSS_n1910 17.0005
R8080 AVSS_n2044 AVSS_n1910 17.0005
R8081 AVSS_n1918 AVSS_n1910 17.0005
R8082 AVSS_n2042 AVSS_n1910 17.0005
R8083 AVSS_n1920 AVSS_n1910 17.0005
R8084 AVSS_n2035 AVSS_n1910 17.0005
R8085 AVSS_n1921 AVSS_n1910 17.0005
R8086 AVSS_n2033 AVSS_n1910 17.0005
R8087 AVSS_n1922 AVSS_n1910 17.0005
R8088 AVSS_n2031 AVSS_n1910 17.0005
R8089 AVSS_n1923 AVSS_n1910 17.0005
R8090 AVSS_n2029 AVSS_n1910 17.0005
R8091 AVSS_n1924 AVSS_n1910 17.0005
R8092 AVSS_n2027 AVSS_n1910 17.0005
R8093 AVSS_n1925 AVSS_n1910 17.0005
R8094 AVSS_n1927 AVSS_n1910 17.0005
R8095 AVSS_n2023 AVSS_n1910 17.0005
R8096 AVSS_n1929 AVSS_n1910 17.0005
R8097 AVSS_n2013 AVSS_n1910 17.0005
R8098 AVSS_n1932 AVSS_n1910 17.0005
R8099 AVSS_n2010 AVSS_n1910 17.0005
R8100 AVSS_n1933 AVSS_n1910 17.0005
R8101 AVSS_n2008 AVSS_n1910 17.0005
R8102 AVSS_n1934 AVSS_n1910 17.0005
R8103 AVSS_n2004 AVSS_n1910 17.0005
R8104 AVSS_n1936 AVSS_n1910 17.0005
R8105 AVSS_n2002 AVSS_n1910 17.0005
R8106 AVSS_n1937 AVSS_n1910 17.0005
R8107 AVSS_n2000 AVSS_n1910 17.0005
R8108 AVSS_n1938 AVSS_n1910 17.0005
R8109 AVSS_n1998 AVSS_n1910 17.0005
R8110 AVSS_n1939 AVSS_n1910 17.0005
R8111 AVSS_n1996 AVSS_n1910 17.0005
R8112 AVSS_n1941 AVSS_n1910 17.0005
R8113 AVSS_n1991 AVSS_n1910 17.0005
R8114 AVSS_n1942 AVSS_n1910 17.0005
R8115 AVSS_n1987 AVSS_n1910 17.0005
R8116 AVSS_n1944 AVSS_n1910 17.0005
R8117 AVSS_n1985 AVSS_n1910 17.0005
R8118 AVSS_n1945 AVSS_n1910 17.0005
R8119 AVSS_n1983 AVSS_n1910 17.0005
R8120 AVSS_n1946 AVSS_n1910 17.0005
R8121 AVSS_n1981 AVSS_n1910 17.0005
R8122 AVSS_n1947 AVSS_n1910 17.0005
R8123 AVSS_n1979 AVSS_n1910 17.0005
R8124 AVSS_n1949 AVSS_n1910 17.0005
R8125 AVSS_n1974 AVSS_n1910 17.0005
R8126 AVSS_n1950 AVSS_n1910 17.0005
R8127 AVSS_n1972 AVSS_n1910 17.0005
R8128 AVSS_n1951 AVSS_n1910 17.0005
R8129 AVSS_n1968 AVSS_n1910 17.0005
R8130 AVSS_n1953 AVSS_n1910 17.0005
R8131 AVSS_n1966 AVSS_n1910 17.0005
R8132 AVSS_n1954 AVSS_n1910 17.0005
R8133 AVSS_n1964 AVSS_n1910 17.0005
R8134 AVSS_n1955 AVSS_n1910 17.0005
R8135 AVSS_n1962 AVSS_n1910 17.0005
R8136 AVSS_n1957 AVSS_n1910 17.0005
R8137 AVSS_n2764 AVSS_n1910 17.0005
R8138 AVSS_n2764 AVSS_n1538 17.0005
R8139 AVSS_n1558 AVSS_n1538 17.0005
R8140 AVSS_n1907 AVSS_n1538 17.0005
R8141 AVSS_n1559 AVSS_n1538 17.0005
R8142 AVSS_n1905 AVSS_n1538 17.0005
R8143 AVSS_n1560 AVSS_n1538 17.0005
R8144 AVSS_n1903 AVSS_n1538 17.0005
R8145 AVSS_n1561 AVSS_n1538 17.0005
R8146 AVSS_n1901 AVSS_n1538 17.0005
R8147 AVSS_n1562 AVSS_n1538 17.0005
R8148 AVSS_n1896 AVSS_n1538 17.0005
R8149 AVSS_n1564 AVSS_n1538 17.0005
R8150 AVSS_n1894 AVSS_n1538 17.0005
R8151 AVSS_n1565 AVSS_n1538 17.0005
R8152 AVSS_n1892 AVSS_n1538 17.0005
R8153 AVSS_n1566 AVSS_n1538 17.0005
R8154 AVSS_n1886 AVSS_n1538 17.0005
R8155 AVSS_n1567 AVSS_n1538 17.0005
R8156 AVSS_n1885 AVSS_n1538 17.0005
R8157 AVSS_n1568 AVSS_n1538 17.0005
R8158 AVSS_n1883 AVSS_n1538 17.0005
R8159 AVSS_n1879 AVSS_n1538 17.0005
R8160 AVSS_n1570 AVSS_n1538 17.0005
R8161 AVSS_n1877 AVSS_n1538 17.0005
R8162 AVSS_n1571 AVSS_n1538 17.0005
R8163 AVSS_n1875 AVSS_n1538 17.0005
R8164 AVSS_n1573 AVSS_n1538 17.0005
R8165 AVSS_n1871 AVSS_n1538 17.0005
R8166 AVSS_n1574 AVSS_n1538 17.0005
R8167 AVSS_n1869 AVSS_n1538 17.0005
R8168 AVSS_n1575 AVSS_n1538 17.0005
R8169 AVSS_n1867 AVSS_n1538 17.0005
R8170 AVSS_n1576 AVSS_n1538 17.0005
R8171 AVSS_n1865 AVSS_n1538 17.0005
R8172 AVSS_n1578 AVSS_n1538 17.0005
R8173 AVSS_n1860 AVSS_n1538 17.0005
R8174 AVSS_n1579 AVSS_n1538 17.0005
R8175 AVSS_n1858 AVSS_n1538 17.0005
R8176 AVSS_n1581 AVSS_n1538 17.0005
R8177 AVSS_n1854 AVSS_n1538 17.0005
R8178 AVSS_n1582 AVSS_n1538 17.0005
R8179 AVSS_n1849 AVSS_n1538 17.0005
R8180 AVSS_n1584 AVSS_n1538 17.0005
R8181 AVSS_n1847 AVSS_n1538 17.0005
R8182 AVSS_n1586 AVSS_n1538 17.0005
R8183 AVSS_n1843 AVSS_n1538 17.0005
R8184 AVSS_n1587 AVSS_n1538 17.0005
R8185 AVSS_n1838 AVSS_n1538 17.0005
R8186 AVSS_n1590 AVSS_n1538 17.0005
R8187 AVSS_n1831 AVSS_n1538 17.0005
R8188 AVSS_n1592 AVSS_n1538 17.0005
R8189 AVSS_n1829 AVSS_n1538 17.0005
R8190 AVSS_n1593 AVSS_n1538 17.0005
R8191 AVSS_n1827 AVSS_n1538 17.0005
R8192 AVSS_n1594 AVSS_n1538 17.0005
R8193 AVSS_n1825 AVSS_n1538 17.0005
R8194 AVSS_n1595 AVSS_n1538 17.0005
R8195 AVSS_n1823 AVSS_n1538 17.0005
R8196 AVSS_n1596 AVSS_n1538 17.0005
R8197 AVSS_n1819 AVSS_n1538 17.0005
R8198 AVSS_n1598 AVSS_n1538 17.0005
R8199 AVSS_n1817 AVSS_n1538 17.0005
R8200 AVSS_n1599 AVSS_n1538 17.0005
R8201 AVSS_n1815 AVSS_n1538 17.0005
R8202 AVSS_n1600 AVSS_n1538 17.0005
R8203 AVSS_n1810 AVSS_n1538 17.0005
R8204 AVSS_n1602 AVSS_n1538 17.0005
R8205 AVSS_n1808 AVSS_n1538 17.0005
R8206 AVSS_n1603 AVSS_n1538 17.0005
R8207 AVSS_n1806 AVSS_n1538 17.0005
R8208 AVSS_n1604 AVSS_n1538 17.0005
R8209 AVSS_n1804 AVSS_n1538 17.0005
R8210 AVSS_n1606 AVSS_n1538 17.0005
R8211 AVSS_n1800 AVSS_n1538 17.0005
R8212 AVSS_n1607 AVSS_n1538 17.0005
R8213 AVSS_n1798 AVSS_n1538 17.0005
R8214 AVSS_n1608 AVSS_n1538 17.0005
R8215 AVSS_n1796 AVSS_n1538 17.0005
R8216 AVSS_n1609 AVSS_n1538 17.0005
R8217 AVSS_n1794 AVSS_n1538 17.0005
R8218 AVSS_n1610 AVSS_n1538 17.0005
R8219 AVSS_n1792 AVSS_n1538 17.0005
R8220 AVSS_n1611 AVSS_n1538 17.0005
R8221 AVSS_n1790 AVSS_n1538 17.0005
R8222 AVSS_n1612 AVSS_n1538 17.0005
R8223 AVSS_n1788 AVSS_n1538 17.0005
R8224 AVSS_n1613 AVSS_n1538 17.0005
R8225 AVSS_n1786 AVSS_n1538 17.0005
R8226 AVSS_n1615 AVSS_n1538 17.0005
R8227 AVSS_n1781 AVSS_n1538 17.0005
R8228 AVSS_n1616 AVSS_n1538 17.0005
R8229 AVSS_n1779 AVSS_n1538 17.0005
R8230 AVSS_n1617 AVSS_n1538 17.0005
R8231 AVSS_n1777 AVSS_n1538 17.0005
R8232 AVSS_n1618 AVSS_n1538 17.0005
R8233 AVSS_n1775 AVSS_n1538 17.0005
R8234 AVSS_n1620 AVSS_n1538 17.0005
R8235 AVSS_n1771 AVSS_n1538 17.0005
R8236 AVSS_n1622 AVSS_n1538 17.0005
R8237 AVSS_n1766 AVSS_n1538 17.0005
R8238 AVSS_n1624 AVSS_n1538 17.0005
R8239 AVSS_n1762 AVSS_n1538 17.0005
R8240 AVSS_n1625 AVSS_n1538 17.0005
R8241 AVSS_n1760 AVSS_n1538 17.0005
R8242 AVSS_n1626 AVSS_n1538 17.0005
R8243 AVSS_n1758 AVSS_n1538 17.0005
R8244 AVSS_n1627 AVSS_n1538 17.0005
R8245 AVSS_n1753 AVSS_n1538 17.0005
R8246 AVSS_n1629 AVSS_n1538 17.0005
R8247 AVSS_n1751 AVSS_n1538 17.0005
R8248 AVSS_n1630 AVSS_n1538 17.0005
R8249 AVSS_n1749 AVSS_n1538 17.0005
R8250 AVSS_n1631 AVSS_n1538 17.0005
R8251 AVSS_n1747 AVSS_n1538 17.0005
R8252 AVSS_n1632 AVSS_n1538 17.0005
R8253 AVSS_n1745 AVSS_n1538 17.0005
R8254 AVSS_n1633 AVSS_n1538 17.0005
R8255 AVSS_n1743 AVSS_n1538 17.0005
R8256 AVSS_n1634 AVSS_n1538 17.0005
R8257 AVSS_n1741 AVSS_n1538 17.0005
R8258 AVSS_n1635 AVSS_n1538 17.0005
R8259 AVSS_n1739 AVSS_n1538 17.0005
R8260 AVSS_n1636 AVSS_n1538 17.0005
R8261 AVSS_n1737 AVSS_n1538 17.0005
R8262 AVSS_n1638 AVSS_n1538 17.0005
R8263 AVSS_n1733 AVSS_n1538 17.0005
R8264 AVSS_n1639 AVSS_n1538 17.0005
R8265 AVSS_n1731 AVSS_n1538 17.0005
R8266 AVSS_n1640 AVSS_n1538 17.0005
R8267 AVSS_n1729 AVSS_n1538 17.0005
R8268 AVSS_n1641 AVSS_n1538 17.0005
R8269 AVSS_n1727 AVSS_n1538 17.0005
R8270 AVSS_n1642 AVSS_n1538 17.0005
R8271 AVSS_n1725 AVSS_n1538 17.0005
R8272 AVSS_n1643 AVSS_n1538 17.0005
R8273 AVSS_n1723 AVSS_n1538 17.0005
R8274 AVSS_n1644 AVSS_n1538 17.0005
R8275 AVSS_n1721 AVSS_n1538 17.0005
R8276 AVSS_n1645 AVSS_n1538 17.0005
R8277 AVSS_n1719 AVSS_n1538 17.0005
R8278 AVSS_n1646 AVSS_n1538 17.0005
R8279 AVSS_n1717 AVSS_n1538 17.0005
R8280 AVSS_n1647 AVSS_n1538 17.0005
R8281 AVSS_n1715 AVSS_n1538 17.0005
R8282 AVSS_n1648 AVSS_n1538 17.0005
R8283 AVSS_n1713 AVSS_n1538 17.0005
R8284 AVSS_n1649 AVSS_n1538 17.0005
R8285 AVSS_n1711 AVSS_n1538 17.0005
R8286 AVSS_n1650 AVSS_n1538 17.0005
R8287 AVSS_n1709 AVSS_n1538 17.0005
R8288 AVSS_n1651 AVSS_n1538 17.0005
R8289 AVSS_n1704 AVSS_n1538 17.0005
R8290 AVSS_n1653 AVSS_n1538 17.0005
R8291 AVSS_n1702 AVSS_n1538 17.0005
R8292 AVSS_n1654 AVSS_n1538 17.0005
R8293 AVSS_n1700 AVSS_n1538 17.0005
R8294 AVSS_n1655 AVSS_n1538 17.0005
R8295 AVSS_n1698 AVSS_n1538 17.0005
R8296 AVSS_n1656 AVSS_n1538 17.0005
R8297 AVSS_n1696 AVSS_n1538 17.0005
R8298 AVSS_n1657 AVSS_n1538 17.0005
R8299 AVSS_n1694 AVSS_n1538 17.0005
R8300 AVSS_n1658 AVSS_n1538 17.0005
R8301 AVSS_n1692 AVSS_n1538 17.0005
R8302 AVSS_n1660 AVSS_n1538 17.0005
R8303 AVSS_n1688 AVSS_n1538 17.0005
R8304 AVSS_n1661 AVSS_n1538 17.0005
R8305 AVSS_n1686 AVSS_n1538 17.0005
R8306 AVSS_n1662 AVSS_n1538 17.0005
R8307 AVSS_n1684 AVSS_n1538 17.0005
R8308 AVSS_n1663 AVSS_n1538 17.0005
R8309 AVSS_n1682 AVSS_n1538 17.0005
R8310 AVSS_n1664 AVSS_n1538 17.0005
R8311 AVSS_n1680 AVSS_n1538 17.0005
R8312 AVSS_n1665 AVSS_n1538 17.0005
R8313 AVSS_n1675 AVSS_n1538 17.0005
R8314 AVSS_n1667 AVSS_n1538 17.0005
R8315 AVSS_n1673 AVSS_n1538 17.0005
R8316 AVSS_n1668 AVSS_n1538 17.0005
R8317 AVSS_n1671 AVSS_n1538 17.0005
R8318 AVSS_n1669 AVSS_n1538 17.0005
R8319 AVSS_n2766 AVSS_n1538 17.0005
R8320 AVSS_n1544 AVSS_n1522 17.0005
R8321 AVSS_n1544 AVSS_n1515 17.0005
R8322 AVSS_n1544 AVSS_n1521 17.0005
R8323 AVSS_n1544 AVSS_n1516 17.0005
R8324 AVSS_n1544 AVSS_n1520 17.0005
R8325 AVSS_n1544 AVSS_n1517 17.0005
R8326 AVSS_n1544 AVSS_n1519 17.0005
R8327 AVSS_n1544 AVSS_n1518 17.0005
R8328 AVSS_n2768 AVSS_n1491 17.0005
R8329 AVSS_n1491 AVSS_n1453 17.0005
R8330 AVSS_n1491 AVSS_n1487 17.0005
R8331 AVSS_n1491 AVSS_n1454 17.0005
R8332 AVSS_n1491 AVSS_n1486 17.0005
R8333 AVSS_n1491 AVSS_n1456 17.0005
R8334 AVSS_n1491 AVSS_n1484 17.0005
R8335 AVSS_n1491 AVSS_n1457 17.0005
R8336 AVSS_n1491 AVSS_n1483 17.0005
R8337 AVSS_n1491 AVSS_n1458 17.0005
R8338 AVSS_n1491 AVSS_n1482 17.0005
R8339 AVSS_n1491 AVSS_n1459 17.0005
R8340 AVSS_n1491 AVSS_n1481 17.0005
R8341 AVSS_n1491 AVSS_n1460 17.0005
R8342 AVSS_n1491 AVSS_n1480 17.0005
R8343 AVSS_n1491 AVSS_n1461 17.0005
R8344 AVSS_n1491 AVSS_n1479 17.0005
R8345 AVSS_n1491 AVSS_n1462 17.0005
R8346 AVSS_n1491 AVSS_n1478 17.0005
R8347 AVSS_n1491 AVSS_n1464 17.0005
R8348 AVSS_n1491 AVSS_n1477 17.0005
R8349 AVSS_n1491 AVSS_n1465 17.0005
R8350 AVSS_n1491 AVSS_n1476 17.0005
R8351 AVSS_n1491 AVSS_n1466 17.0005
R8352 AVSS_n1491 AVSS_n1475 17.0005
R8353 AVSS_n1491 AVSS_n1467 17.0005
R8354 AVSS_n1491 AVSS_n1474 17.0005
R8355 AVSS_n1491 AVSS_n1468 17.0005
R8356 AVSS_n1491 AVSS_n1471 17.0005
R8357 AVSS_n1491 AVSS_n1469 17.0005
R8358 AVSS_n1491 AVSS_n1470 17.0005
R8359 AVSS_n1491 AVSS_n1059 17.0005
R8360 AVSS_n2812 AVSS_n1002 17.0005
R8361 AVSS_n1008 AVSS_n1002 17.0005
R8362 AVSS_n1009 AVSS_n1002 17.0005
R8363 AVSS_n1026 AVSS_n1002 17.0005
R8364 AVSS_n1010 AVSS_n1002 17.0005
R8365 AVSS_n1024 AVSS_n1002 17.0005
R8366 AVSS_n1011 AVSS_n1002 17.0005
R8367 AVSS_n1018 AVSS_n1002 17.0005
R8368 AVSS_n1012 AVSS_n1002 17.0005
R8369 AVSS_n1017 AVSS_n1002 17.0005
R8370 AVSS_n1013 AVSS_n1002 17.0005
R8371 AVSS_n1015 AVSS_n1002 17.0005
R8372 AVSS_n2814 AVSS_n1002 17.0005
R8373 AVSS_n2814 AVSS_n838 17.0005
R8374 AVSS_n843 AVSS_n838 17.0005
R8375 AVSS_n952 AVSS_n838 17.0005
R8376 AVSS_n844 AVSS_n838 17.0005
R8377 AVSS_n951 AVSS_n838 17.0005
R8378 AVSS_n845 AVSS_n838 17.0005
R8379 AVSS_n950 AVSS_n838 17.0005
R8380 AVSS_n846 AVSS_n838 17.0005
R8381 AVSS_n949 AVSS_n838 17.0005
R8382 AVSS_n847 AVSS_n838 17.0005
R8383 AVSS_n838 AVSS_n778 17.0005
R8384 AVSS_n850 AVSS_n838 17.0005
R8385 AVSS_n946 AVSS_n838 17.0005
R8386 AVSS_n851 AVSS_n838 17.0005
R8387 AVSS_n945 AVSS_n838 17.0005
R8388 AVSS_n852 AVSS_n838 17.0005
R8389 AVSS_n944 AVSS_n838 17.0005
R8390 AVSS_n855 AVSS_n838 17.0005
R8391 AVSS_n943 AVSS_n838 17.0005
R8392 AVSS_n856 AVSS_n838 17.0005
R8393 AVSS_n942 AVSS_n838 17.0005
R8394 AVSS_n857 AVSS_n838 17.0005
R8395 AVSS_n941 AVSS_n838 17.0005
R8396 AVSS_n858 AVSS_n838 17.0005
R8397 AVSS_n940 AVSS_n838 17.0005
R8398 AVSS_n859 AVSS_n838 17.0005
R8399 AVSS_n939 AVSS_n838 17.0005
R8400 AVSS_n860 AVSS_n838 17.0005
R8401 AVSS_n938 AVSS_n838 17.0005
R8402 AVSS_n861 AVSS_n838 17.0005
R8403 AVSS_n935 AVSS_n838 17.0005
R8404 AVSS_n862 AVSS_n838 17.0005
R8405 AVSS_n934 AVSS_n838 17.0005
R8406 AVSS_n865 AVSS_n838 17.0005
R8407 AVSS_n931 AVSS_n838 17.0005
R8408 AVSS_n866 AVSS_n838 17.0005
R8409 AVSS_n930 AVSS_n838 17.0005
R8410 AVSS_n867 AVSS_n838 17.0005
R8411 AVSS_n929 AVSS_n838 17.0005
R8412 AVSS_n868 AVSS_n838 17.0005
R8413 AVSS_n928 AVSS_n838 17.0005
R8414 AVSS_n871 AVSS_n838 17.0005
R8415 AVSS_n927 AVSS_n838 17.0005
R8416 AVSS_n926 AVSS_n838 17.0005
R8417 AVSS_n874 AVSS_n838 17.0005
R8418 AVSS_n923 AVSS_n838 17.0005
R8419 AVSS_n875 AVSS_n838 17.0005
R8420 AVSS_n922 AVSS_n838 17.0005
R8421 AVSS_n876 AVSS_n838 17.0005
R8422 AVSS_n921 AVSS_n838 17.0005
R8423 AVSS_n879 AVSS_n838 17.0005
R8424 AVSS_n920 AVSS_n838 17.0005
R8425 AVSS_n880 AVSS_n838 17.0005
R8426 AVSS_n919 AVSS_n838 17.0005
R8427 AVSS_n881 AVSS_n838 17.0005
R8428 AVSS_n916 AVSS_n838 17.0005
R8429 AVSS_n884 AVSS_n838 17.0005
R8430 AVSS_n915 AVSS_n838 17.0005
R8431 AVSS_n885 AVSS_n838 17.0005
R8432 AVSS_n914 AVSS_n838 17.0005
R8433 AVSS_n886 AVSS_n838 17.0005
R8434 AVSS_n911 AVSS_n838 17.0005
R8435 AVSS_n889 AVSS_n838 17.0005
R8436 AVSS_n910 AVSS_n838 17.0005
R8437 AVSS_n890 AVSS_n838 17.0005
R8438 AVSS_n909 AVSS_n838 17.0005
R8439 AVSS_n891 AVSS_n838 17.0005
R8440 AVSS_n906 AVSS_n838 17.0005
R8441 AVSS_n892 AVSS_n838 17.0005
R8442 AVSS_n905 AVSS_n838 17.0005
R8443 AVSS_n893 AVSS_n838 17.0005
R8444 AVSS_n904 AVSS_n838 17.0005
R8445 AVSS_n896 AVSS_n838 17.0005
R8446 AVSS_n903 AVSS_n838 17.0005
R8447 AVSS_n897 AVSS_n838 17.0005
R8448 AVSS_n902 AVSS_n838 17.0005
R8449 AVSS_n898 AVSS_n838 17.0005
R8450 AVSS_n901 AVSS_n838 17.0005
R8451 AVSS_n899 AVSS_n838 17.0005
R8452 AVSS_n900 AVSS_n838 17.0005
R8453 AVSS_n2816 AVSS_n838 17.0005
R8454 AVSS_n2762 AVSS_n2100 17.0005
R8455 AVSS_n2100 AVSS_n1919 17.0005
R8456 AVSS_n2100 AVSS_n1926 17.0005
R8457 AVSS_n2100 AVSS_n2021 17.0005
R8458 AVSS_n2100 AVSS_n1930 17.0005
R8459 AVSS_n2100 AVSS_n2016 17.0005
R8460 AVSS_n2100 AVSS_n2013 17.0005
R8461 AVSS_n2100 AVSS_n1935 17.0005
R8462 AVSS_n2100 AVSS_n1994 17.0005
R8463 AVSS_n2100 AVSS_n1943 17.0005
R8464 AVSS_n2100 AVSS_n1977 17.0005
R8465 AVSS_n2100 AVSS_n1952 17.0005
R8466 AVSS_n2100 AVSS_n1960 17.0005
R8467 AVSS_n2764 AVSS_n1539 17.0005
R8468 AVSS_n1563 AVSS_n1539 17.0005
R8469 AVSS_n1569 AVSS_n1539 17.0005
R8470 AVSS_n1873 AVSS_n1539 17.0005
R8471 AVSS_n1577 AVSS_n1539 17.0005
R8472 AVSS_n1856 AVSS_n1539 17.0005
R8473 AVSS_n1583 AVSS_n1539 17.0005
R8474 AVSS_n1845 AVSS_n1539 17.0005
R8475 AVSS_n1588 AVSS_n1539 17.0005
R8476 AVSS_n1836 AVSS_n1539 17.0005
R8477 AVSS_n1591 AVSS_n1539 17.0005
R8478 AVSS_n1821 AVSS_n1539 17.0005
R8479 AVSS_n1819 AVSS_n1539 17.0005
R8480 AVSS_n1601 AVSS_n1539 17.0005
R8481 AVSS_n1802 AVSS_n1539 17.0005
R8482 AVSS_n1614 AVSS_n1539 17.0005
R8483 AVSS_n1773 AVSS_n1539 17.0005
R8484 AVSS_n1621 AVSS_n1539 17.0005
R8485 AVSS_n1764 AVSS_n1539 17.0005
R8486 AVSS_n1628 AVSS_n1539 17.0005
R8487 AVSS_n1735 AVSS_n1539 17.0005
R8488 AVSS_n1652 AVSS_n1539 17.0005
R8489 AVSS_n1690 AVSS_n1539 17.0005
R8490 AVSS_n1666 AVSS_n1539 17.0005
R8491 AVSS_n2766 AVSS_n1539 17.0005
R8492 AVSS_n2766 AVSS_n1528 17.0005
R8493 AVSS_n1528 AVSS_n1522 17.0005
R8494 AVSS_n2768 AVSS_n1507 17.0005
R8495 AVSS_n1507 AVSS_n1486 17.0005
R8496 AVSS_n1507 AVSS_n1463 17.0005
R8497 AVSS_n1507 AVSS_n1059 17.0005
R8498 AVSS_n2812 AVSS_n1003 17.0005
R8499 AVSS_n2814 AVSS_n1003 17.0005
R8500 AVSS_n2814 AVSS_n999 17.0005
R8501 AVSS_n999 AVSS_n948 17.0005
R8502 AVSS_n999 AVSS_n854 17.0005
R8503 AVSS_n999 AVSS_n937 17.0005
R8504 AVSS_n999 AVSS_n864 17.0005
R8505 AVSS_n999 AVSS_n933 17.0005
R8506 AVSS_n999 AVSS_n873 17.0005
R8507 AVSS_n999 AVSS_n925 17.0005
R8508 AVSS_n999 AVSS_n878 17.0005
R8509 AVSS_n999 AVSS_n918 17.0005
R8510 AVSS_n999 AVSS_n883 17.0005
R8511 AVSS_n999 AVSS_n913 17.0005
R8512 AVSS_n999 AVSS_n888 17.0005
R8513 AVSS_n999 AVSS_n908 17.0005
R8514 AVSS_n999 AVSS_n895 17.0005
R8515 AVSS_n2040 AVSS_n1911 17.0005
R8516 AVSS_n2025 AVSS_n1911 17.0005
R8517 AVSS_n1928 AVSS_n1911 17.0005
R8518 AVSS_n2018 AVSS_n1911 17.0005
R8519 AVSS_n2006 AVSS_n1911 17.0005
R8520 AVSS_n1940 AVSS_n1911 17.0005
R8521 AVSS_n1989 AVSS_n1911 17.0005
R8522 AVSS_n1948 AVSS_n1911 17.0005
R8523 AVSS_n1970 AVSS_n1911 17.0005
R8524 AVSS_n1956 AVSS_n1911 17.0005
R8525 AVSS_n2764 AVSS_n1911 17.0005
R8526 AVSS_n2546 AVSS_n1899 17.0005
R8527 AVSS_n2546 AVSS_n1881 17.0005
R8528 AVSS_n2546 AVSS_n1572 17.0005
R8529 AVSS_n2546 AVSS_n1863 17.0005
R8530 AVSS_n2546 AVSS_n1580 17.0005
R8531 AVSS_n2546 AVSS_n1852 17.0005
R8532 AVSS_n2546 AVSS_n1585 17.0005
R8533 AVSS_n2546 AVSS_n1841 17.0005
R8534 AVSS_n2546 AVSS_n1589 17.0005
R8535 AVSS_n2546 AVSS_n1834 17.0005
R8536 AVSS_n2546 AVSS_n1813 17.0005
R8537 AVSS_n2546 AVSS_n1605 17.0005
R8538 AVSS_n2546 AVSS_n1784 17.0005
R8539 AVSS_n2546 AVSS_n1619 17.0005
R8540 AVSS_n2546 AVSS_n1769 17.0005
R8541 AVSS_n2546 AVSS_n1623 17.0005
R8542 AVSS_n2546 AVSS_n1756 17.0005
R8543 AVSS_n2546 AVSS_n1637 17.0005
R8544 AVSS_n2546 AVSS_n1707 17.0005
R8545 AVSS_n2546 AVSS_n1659 17.0005
R8546 AVSS_n2546 AVSS_n1678 17.0005
R8547 AVSS_n2766 AVSS_n1533 17.0005
R8548 AVSS_n2771 AVSS_n2770 17.0005
R8549 AVSS_n2771 AVSS_n1443 17.0005
R8550 AVSS_n2812 AVSS_n1037 17.0005
R8551 AVSS_n1037 AVSS_n1029 17.0005
R8552 AVSS_n2818 AVSS_n778 17.0005
R8553 AVSS_n2818 AVSS_n782 17.0005
R8554 AVSS_n2818 AVSS_n790 17.0005
R8555 AVSS_n2818 AVSS_n793 17.0005
R8556 AVSS_n2818 AVSS_n795 17.0005
R8557 AVSS_n2818 AVSS_n803 17.0005
R8558 AVSS_n2818 AVSS_n805 17.0005
R8559 AVSS_n2818 AVSS_n809 17.0005
R8560 AVSS_n2818 AVSS_n813 17.0005
R8561 AVSS_n2818 AVSS_n815 17.0005
R8562 AVSS_n2818 AVSS_n819 17.0005
R8563 AVSS_n2818 AVSS_n821 17.0005
R8564 AVSS_n2818 AVSS_n825 17.0005
R8565 AVSS_n2818 AVSS_n829 17.0005
R8566 AVSS_n1240 AVSS_n1159 17.0005
R8567 AVSS_n1240 AVSS_n1155 17.0005
R8568 AVSS_n1240 AVSS_n1200 17.0005
R8569 AVSS_n1240 AVSS_n1198 17.0005
R8570 AVSS_n1240 AVSS_n1197 17.0005
R8571 AVSS_n1240 AVSS_n1195 17.0005
R8572 AVSS_n2791 AVSS_n1159 17.0005
R8573 AVSS_n2791 AVSS_n1155 17.0005
R8574 AVSS_n2791 AVSS_n1200 17.0005
R8575 AVSS_n2791 AVSS_n1198 17.0005
R8576 AVSS_n2791 AVSS_n1197 17.0005
R8577 AVSS_n2791 AVSS_n1195 17.0005
R8578 AVSS_n2805 AVSS_n2804 17.0005
R8579 AVSS_n2805 AVSS_n1069 17.0005
R8580 AVSS_n2805 AVSS_n1063 17.0005
R8581 AVSS_n2805 AVSS_n1068 17.0005
R8582 AVSS_n2805 AVSS_n1065 17.0005
R8583 AVSS_n2805 AVSS_n1067 17.0005
R8584 AVSS_n2804 AVSS_n1061 17.0005
R8585 AVSS_n1069 AVSS_n1061 17.0005
R8586 AVSS_n1063 AVSS_n1061 17.0005
R8587 AVSS_n1068 AVSS_n1061 17.0005
R8588 AVSS_n1065 AVSS_n1061 17.0005
R8589 AVSS_n1067 AVSS_n1061 17.0005
R8590 AVSS_n1225 AVSS_n1223 17.0005
R8591 AVSS_n1225 AVSS_n1221 17.0005
R8592 AVSS_n1225 AVSS_n1219 17.0005
R8593 AVSS_n1225 AVSS_n1218 17.0005
R8594 AVSS_n1225 AVSS_n1216 17.0005
R8595 AVSS_n1225 AVSS_n1214 17.0005
R8596 AVSS_n1231 AVSS_n1223 17.0005
R8597 AVSS_n1231 AVSS_n1221 17.0005
R8598 AVSS_n1231 AVSS_n1219 17.0005
R8599 AVSS_n1231 AVSS_n1218 17.0005
R8600 AVSS_n1231 AVSS_n1216 17.0005
R8601 AVSS_n1231 AVSS_n1214 17.0005
R8602 AVSS_n2799 AVSS_n2798 17.0005
R8603 AVSS_n2799 AVSS_n1113 17.0005
R8604 AVSS_n2799 AVSS_n1104 17.0005
R8605 AVSS_n2799 AVSS_n1112 17.0005
R8606 AVSS_n2800 AVSS_n2799 17.0005
R8607 AVSS_n2799 AVSS_n1109 17.0005
R8608 AVSS_n2799 AVSS_n1105 17.0005
R8609 AVSS_n2799 AVSS_n1108 17.0005
R8610 AVSS_n2799 AVSS_n1106 17.0005
R8611 AVSS_n2798 AVSS_n1101 17.0005
R8612 AVSS_n1113 AVSS_n1101 17.0005
R8613 AVSS_n1104 AVSS_n1101 17.0005
R8614 AVSS_n1112 AVSS_n1101 17.0005
R8615 AVSS_n2800 AVSS_n1101 17.0005
R8616 AVSS_n1109 AVSS_n1101 17.0005
R8617 AVSS_n1105 AVSS_n1101 17.0005
R8618 AVSS_n1108 AVSS_n1101 17.0005
R8619 AVSS_n1106 AVSS_n1101 17.0005
R8620 AVSS_n1279 AVSS_n1277 17.0005
R8621 AVSS_n1279 AVSS_n1276 17.0005
R8622 AVSS_n1279 AVSS_n1275 17.0005
R8623 AVSS_n1279 AVSS_n1274 17.0005
R8624 AVSS_n1279 AVSS_n1273 17.0005
R8625 AVSS_n1279 AVSS_n1272 17.0005
R8626 AVSS_n1279 AVSS_n1271 17.0005
R8627 AVSS_n1279 AVSS_n1269 17.0005
R8628 AVSS_n1279 AVSS_n1268 17.0005
R8629 AVSS_n1279 AVSS_n1267 17.0005
R8630 AVSS_n1279 AVSS_n1266 17.0005
R8631 AVSS_n1279 AVSS_n1265 17.0005
R8632 AVSS_n1279 AVSS_n1264 17.0005
R8633 AVSS_n1279 AVSS_n1263 17.0005
R8634 AVSS_n1279 AVSS_n1261 17.0005
R8635 AVSS_n1279 AVSS_n1259 17.0005
R8636 AVSS_n1279 AVSS_n1258 17.0005
R8637 AVSS_n1279 AVSS_n1257 17.0005
R8638 AVSS_n1279 AVSS_n1256 17.0005
R8639 AVSS_n1279 AVSS_n1255 17.0005
R8640 AVSS_n1279 AVSS_n1254 17.0005
R8641 AVSS_n1279 AVSS_n1253 17.0005
R8642 AVSS_n1279 AVSS_n1252 17.0005
R8643 AVSS_n1279 AVSS_n1250 17.0005
R8644 AVSS_n1279 AVSS_n1249 17.0005
R8645 AVSS_n1279 AVSS_n1248 17.0005
R8646 AVSS_n1279 AVSS_n1247 17.0005
R8647 AVSS_n1279 AVSS_n1246 17.0005
R8648 AVSS_n2786 AVSS_n1277 17.0005
R8649 AVSS_n2786 AVSS_n1276 17.0005
R8650 AVSS_n2786 AVSS_n1275 17.0005
R8651 AVSS_n2786 AVSS_n1274 17.0005
R8652 AVSS_n2786 AVSS_n1273 17.0005
R8653 AVSS_n2786 AVSS_n1272 17.0005
R8654 AVSS_n2786 AVSS_n1271 17.0005
R8655 AVSS_n2786 AVSS_n1269 17.0005
R8656 AVSS_n2786 AVSS_n1268 17.0005
R8657 AVSS_n2786 AVSS_n1267 17.0005
R8658 AVSS_n2786 AVSS_n1266 17.0005
R8659 AVSS_n2786 AVSS_n1265 17.0005
R8660 AVSS_n2786 AVSS_n1264 17.0005
R8661 AVSS_n2786 AVSS_n1263 17.0005
R8662 AVSS_n2786 AVSS_n1261 17.0005
R8663 AVSS_n2786 AVSS_n1259 17.0005
R8664 AVSS_n2786 AVSS_n1258 17.0005
R8665 AVSS_n2786 AVSS_n1257 17.0005
R8666 AVSS_n2786 AVSS_n1256 17.0005
R8667 AVSS_n2786 AVSS_n1255 17.0005
R8668 AVSS_n2786 AVSS_n1254 17.0005
R8669 AVSS_n2786 AVSS_n1253 17.0005
R8670 AVSS_n2786 AVSS_n1252 17.0005
R8671 AVSS_n2786 AVSS_n1250 17.0005
R8672 AVSS_n2786 AVSS_n1249 17.0005
R8673 AVSS_n2786 AVSS_n1248 17.0005
R8674 AVSS_n2786 AVSS_n1247 17.0005
R8675 AVSS_n2786 AVSS_n1246 17.0005
R8676 AVSS_n1343 AVSS_n1342 17.0005
R8677 AVSS_n1343 AVSS_n1337 17.0005
R8678 AVSS_n1343 AVSS_n1327 17.0005
R8679 AVSS_n1343 AVSS_n1335 17.0005
R8680 AVSS_n1343 AVSS_n1329 17.0005
R8681 AVSS_n1343 AVSS_n1333 17.0005
R8682 AVSS_n1342 AVSS_n1341 17.0005
R8683 AVSS_n1341 AVSS_n1337 17.0005
R8684 AVSS_n1341 AVSS_n1327 17.0005
R8685 AVSS_n1341 AVSS_n1335 17.0005
R8686 AVSS_n1341 AVSS_n1329 17.0005
R8687 AVSS_n1341 AVSS_n1333 17.0005
R8688 AVSS_n1385 AVSS_n1384 17.0005
R8689 AVSS_n1385 AVSS_n1375 17.0005
R8690 AVSS_n1385 AVSS_n1361 17.0005
R8691 AVSS_n1385 AVSS_n1373 17.0005
R8692 AVSS_n1385 AVSS_n1363 17.0005
R8693 AVSS_n1385 AVSS_n1371 17.0005
R8694 AVSS_n1385 AVSS_n1365 17.0005
R8695 AVSS_n1385 AVSS_n1369 17.0005
R8696 AVSS_n1382 AVSS_n1356 17.0005
R8697 AVSS_n1384 AVSS_n1382 17.0005
R8698 AVSS_n1382 AVSS_n1375 17.0005
R8699 AVSS_n1382 AVSS_n1361 17.0005
R8700 AVSS_n1382 AVSS_n1373 17.0005
R8701 AVSS_n1382 AVSS_n1363 17.0005
R8702 AVSS_n1382 AVSS_n1371 17.0005
R8703 AVSS_n1382 AVSS_n1365 17.0005
R8704 AVSS_n1382 AVSS_n1369 17.0005
R8705 AVSS_n2802 AVSS_n2801 17.0005
R8706 AVSS_n2802 AVSS_n1098 17.0005
R8707 AVSS_n2802 AVSS_n1075 17.0005
R8708 AVSS_n2802 AVSS_n1097 17.0005
R8709 AVSS_n2802 AVSS_n1076 17.0005
R8710 AVSS_n2802 AVSS_n1096 17.0005
R8711 AVSS_n2802 AVSS_n1077 17.0005
R8712 AVSS_n2802 AVSS_n1095 17.0005
R8713 AVSS_n2802 AVSS_n1078 17.0005
R8714 AVSS_n2802 AVSS_n1094 17.0005
R8715 AVSS_n2802 AVSS_n1079 17.0005
R8716 AVSS_n2802 AVSS_n1093 17.0005
R8717 AVSS_n2802 AVSS_n1080 17.0005
R8718 AVSS_n2802 AVSS_n1092 17.0005
R8719 AVSS_n2802 AVSS_n1081 17.0005
R8720 AVSS_n2802 AVSS_n1091 17.0005
R8721 AVSS_n2802 AVSS_n1082 17.0005
R8722 AVSS_n2802 AVSS_n1090 17.0005
R8723 AVSS_n2802 AVSS_n1083 17.0005
R8724 AVSS_n2803 AVSS_n2802 17.0005
R8725 AVSS_n2802 AVSS_n1087 17.0005
R8726 AVSS_n2801 AVSS_n1072 17.0005
R8727 AVSS_n1098 AVSS_n1072 17.0005
R8728 AVSS_n1075 AVSS_n1072 17.0005
R8729 AVSS_n1097 AVSS_n1072 17.0005
R8730 AVSS_n1076 AVSS_n1072 17.0005
R8731 AVSS_n1096 AVSS_n1072 17.0005
R8732 AVSS_n1077 AVSS_n1072 17.0005
R8733 AVSS_n1095 AVSS_n1072 17.0005
R8734 AVSS_n1078 AVSS_n1072 17.0005
R8735 AVSS_n1094 AVSS_n1072 17.0005
R8736 AVSS_n1079 AVSS_n1072 17.0005
R8737 AVSS_n1093 AVSS_n1072 17.0005
R8738 AVSS_n1080 AVSS_n1072 17.0005
R8739 AVSS_n1092 AVSS_n1072 17.0005
R8740 AVSS_n1081 AVSS_n1072 17.0005
R8741 AVSS_n1091 AVSS_n1072 17.0005
R8742 AVSS_n1082 AVSS_n1072 17.0005
R8743 AVSS_n1090 AVSS_n1072 17.0005
R8744 AVSS_n1083 AVSS_n1072 17.0005
R8745 AVSS_n2803 AVSS_n1072 17.0005
R8746 AVSS_n1087 AVSS_n1072 17.0005
R8747 AVSS_n2233 AVSS_n2220 17.0005
R8748 AVSS_n2231 AVSS_n2220 17.0005
R8749 AVSS_n2220 AVSS_n1073 17.0005
R8750 AVSS_n2230 AVSS_n2220 17.0005
R8751 AVSS_n2228 AVSS_n2220 17.0005
R8752 AVSS_n2227 AVSS_n2220 17.0005
R8753 AVSS_n2225 AVSS_n2220 17.0005
R8754 AVSS_n2223 AVSS_n2220 17.0005
R8755 AVSS_n2240 AVSS_n2233 17.0005
R8756 AVSS_n2240 AVSS_n2231 17.0005
R8757 AVSS_n2240 AVSS_n1073 17.0005
R8758 AVSS_n2240 AVSS_n2230 17.0005
R8759 AVSS_n2240 AVSS_n2228 17.0005
R8760 AVSS_n2240 AVSS_n2227 17.0005
R8761 AVSS_n2240 AVSS_n2225 17.0005
R8762 AVSS_n2240 AVSS_n2223 17.0005
R8763 AVSS_n1410 AVSS_n1395 17.0005
R8764 AVSS_n1410 AVSS_n1397 17.0005
R8765 AVSS_n1410 AVSS_n1399 17.0005
R8766 AVSS_n1410 AVSS_n1401 17.0005
R8767 AVSS_n1410 AVSS_n1403 17.0005
R8768 AVSS_n1410 AVSS_n1405 17.0005
R8769 AVSS_n1410 AVSS_n1407 17.0005
R8770 AVSS_n1410 AVSS_n1409 17.0005
R8771 AVSS_n1418 AVSS_n1389 17.0005
R8772 AVSS_n1418 AVSS_n1395 17.0005
R8773 AVSS_n1418 AVSS_n1397 17.0005
R8774 AVSS_n1418 AVSS_n1399 17.0005
R8775 AVSS_n1418 AVSS_n1401 17.0005
R8776 AVSS_n1418 AVSS_n1403 17.0005
R8777 AVSS_n1418 AVSS_n1405 17.0005
R8778 AVSS_n1418 AVSS_n1407 17.0005
R8779 AVSS_n1418 AVSS_n1409 17.0005
R8780 AVSS_n2780 AVSS_n2779 17.0005
R8781 AVSS_n2780 AVSS_n1318 17.0005
R8782 AVSS_n2780 AVSS_n1286 17.0005
R8783 AVSS_n2780 AVSS_n1316 17.0005
R8784 AVSS_n2780 AVSS_n1287 17.0005
R8785 AVSS_n2780 AVSS_n1313 17.0005
R8786 AVSS_n2780 AVSS_n1288 17.0005
R8787 AVSS_n2780 AVSS_n1310 17.0005
R8788 AVSS_n2780 AVSS_n1289 17.0005
R8789 AVSS_n2780 AVSS_n1307 17.0005
R8790 AVSS_n2780 AVSS_n1290 17.0005
R8791 AVSS_n2780 AVSS_n1304 17.0005
R8792 AVSS_n2780 AVSS_n1291 17.0005
R8793 AVSS_n2780 AVSS_n1301 17.0005
R8794 AVSS_n2780 AVSS_n1292 17.0005
R8795 AVSS_n2780 AVSS_n1300 17.0005
R8796 AVSS_n2780 AVSS_n1293 17.0005
R8797 AVSS_n2780 AVSS_n1299 17.0005
R8798 AVSS_n2780 AVSS_n1294 17.0005
R8799 AVSS_n2780 AVSS_n1297 17.0005
R8800 AVSS_n2780 AVSS_n1295 17.0005
R8801 AVSS_n2780 AVSS_n1296 17.0005
R8802 AVSS_n2779 AVSS_n1284 17.0005
R8803 AVSS_n1318 AVSS_n1284 17.0005
R8804 AVSS_n1286 AVSS_n1284 17.0005
R8805 AVSS_n1316 AVSS_n1284 17.0005
R8806 AVSS_n1287 AVSS_n1284 17.0005
R8807 AVSS_n1313 AVSS_n1284 17.0005
R8808 AVSS_n1288 AVSS_n1284 17.0005
R8809 AVSS_n1310 AVSS_n1284 17.0005
R8810 AVSS_n1289 AVSS_n1284 17.0005
R8811 AVSS_n1307 AVSS_n1284 17.0005
R8812 AVSS_n1290 AVSS_n1284 17.0005
R8813 AVSS_n1304 AVSS_n1284 17.0005
R8814 AVSS_n1291 AVSS_n1284 17.0005
R8815 AVSS_n1301 AVSS_n1284 17.0005
R8816 AVSS_n1292 AVSS_n1284 17.0005
R8817 AVSS_n1300 AVSS_n1284 17.0005
R8818 AVSS_n1293 AVSS_n1284 17.0005
R8819 AVSS_n1299 AVSS_n1284 17.0005
R8820 AVSS_n1294 AVSS_n1284 17.0005
R8821 AVSS_n1297 AVSS_n1284 17.0005
R8822 AVSS_n1295 AVSS_n1284 17.0005
R8823 AVSS_n1296 AVSS_n1284 17.0005
R8824 AVSS_n630 AVSS_n454 17.0005
R8825 AVSS_n629 AVSS_n454 17.0005
R8826 AVSS_n628 AVSS_n454 17.0005
R8827 AVSS_n627 AVSS_n454 17.0005
R8828 AVSS_n625 AVSS_n454 17.0005
R8829 AVSS_n624 AVSS_n454 17.0005
R8830 AVSS_n544 AVSS_n454 17.0005
R8831 AVSS_n543 AVSS_n454 17.0005
R8832 AVSS_n542 AVSS_n454 17.0005
R8833 AVSS_n541 AVSS_n454 17.0005
R8834 AVSS_n540 AVSS_n454 17.0005
R8835 AVSS_n539 AVSS_n454 17.0005
R8836 AVSS_n538 AVSS_n454 17.0005
R8837 AVSS_n537 AVSS_n454 17.0005
R8838 AVSS_n536 AVSS_n454 17.0005
R8839 AVSS_n535 AVSS_n454 17.0005
R8840 AVSS_n534 AVSS_n454 17.0005
R8841 AVSS_n533 AVSS_n454 17.0005
R8842 AVSS_n532 AVSS_n454 17.0005
R8843 AVSS_n531 AVSS_n454 17.0005
R8844 AVSS_n530 AVSS_n454 17.0005
R8845 AVSS_n529 AVSS_n454 17.0005
R8846 AVSS_n528 AVSS_n454 17.0005
R8847 AVSS_n527 AVSS_n454 17.0005
R8848 AVSS_n526 AVSS_n454 17.0005
R8849 AVSS_n525 AVSS_n454 17.0005
R8850 AVSS_n524 AVSS_n454 17.0005
R8851 AVSS_n523 AVSS_n454 17.0005
R8852 AVSS_n522 AVSS_n454 17.0005
R8853 AVSS_n521 AVSS_n454 17.0005
R8854 AVSS_n520 AVSS_n454 17.0005
R8855 AVSS_n763 AVSS_n762 17.0005
R8856 AVSS_n762 AVSS_n363 17.0005
R8857 AVSS_n762 AVSS_n356 17.0005
R8858 AVSS_n762 AVSS_n362 17.0005
R8859 AVSS_n762 AVSS_n357 17.0005
R8860 AVSS_n762 AVSS_n361 17.0005
R8861 AVSS_n763 AVSS_n352 17.0005
R8862 AVSS_n363 AVSS_n352 17.0005
R8863 AVSS_n356 AVSS_n352 17.0005
R8864 AVSS_n362 AVSS_n352 17.0005
R8865 AVSS_n357 AVSS_n352 17.0005
R8866 AVSS_n361 AVSS_n352 17.0005
R8867 AVSS_n443 AVSS_n395 17.0005
R8868 AVSS_n443 AVSS_n394 17.0005
R8869 AVSS_n443 AVSS_n393 17.0005
R8870 AVSS_n443 AVSS_n441 17.0005
R8871 AVSS_n443 AVSS_n437 17.0005
R8872 AVSS_n443 AVSS_n391 17.0005
R8873 AVSS_n443 AVSS_n390 17.0005
R8874 AVSS_n443 AVSS_n389 17.0005
R8875 AVSS_n443 AVSS_n388 17.0005
R8876 AVSS_n443 AVSS_n387 17.0005
R8877 AVSS_n443 AVSS_n386 17.0005
R8878 AVSS_n444 AVSS_n443 17.0005
R8879 AVSS_n443 AVSS_n383 17.0005
R8880 AVSS_n443 AVSS_n382 17.0005
R8881 AVSS_n443 AVSS_n381 17.0005
R8882 AVSS_n443 AVSS_n380 17.0005
R8883 AVSS_n443 AVSS_n379 17.0005
R8884 AVSS_n443 AVSS_n440 17.0005
R8885 AVSS_n443 AVSS_n439 17.0005
R8886 AVSS_n443 AVSS_n377 17.0005
R8887 AVSS_n443 AVSS_n376 17.0005
R8888 AVSS_n443 AVSS_n375 17.0005
R8889 AVSS_n443 AVSS_n374 17.0005
R8890 AVSS_n443 AVSS_n373 17.0005
R8891 AVSS_n755 AVSS_n395 17.0005
R8892 AVSS_n755 AVSS_n394 17.0005
R8893 AVSS_n755 AVSS_n393 17.0005
R8894 AVSS_n755 AVSS_n391 17.0005
R8895 AVSS_n755 AVSS_n390 17.0005
R8896 AVSS_n755 AVSS_n389 17.0005
R8897 AVSS_n755 AVSS_n388 17.0005
R8898 AVSS_n755 AVSS_n387 17.0005
R8899 AVSS_n755 AVSS_n386 17.0005
R8900 AVSS_n755 AVSS_n385 17.0005
R8901 AVSS_n755 AVSS_n383 17.0005
R8902 AVSS_n755 AVSS_n382 17.0005
R8903 AVSS_n755 AVSS_n381 17.0005
R8904 AVSS_n755 AVSS_n380 17.0005
R8905 AVSS_n755 AVSS_n379 17.0005
R8906 AVSS_n755 AVSS_n377 17.0005
R8907 AVSS_n755 AVSS_n376 17.0005
R8908 AVSS_n755 AVSS_n375 17.0005
R8909 AVSS_n755 AVSS_n374 17.0005
R8910 AVSS_n755 AVSS_n373 17.0005
R8911 AVSS_n565 AVSS_n564 17.0005
R8912 AVSS_n565 AVSS_n563 17.0005
R8913 AVSS_n609 AVSS_n564 17.0005
R8914 AVSS_n609 AVSS_n563 17.0005
R8915 AVSS_n618 AVSS_n615 17.0005
R8916 AVSS_n618 AVSS_n614 17.0005
R8917 AVSS_n618 AVSS_n554 17.0005
R8918 AVSS_n618 AVSS_n553 17.0005
R8919 AVSS_n618 AVSS_n552 17.0005
R8920 AVSS_n618 AVSS_n550 17.0005
R8921 AVSS_n618 AVSS_n549 17.0005
R8922 AVSS_n618 AVSS_n548 17.0005
R8923 AVSS_n618 AVSS_n547 17.0005
R8924 AVSS_n622 AVSS_n615 17.0005
R8925 AVSS_n622 AVSS_n614 17.0005
R8926 AVSS_n622 AVSS_n554 17.0005
R8927 AVSS_n622 AVSS_n553 17.0005
R8928 AVSS_n622 AVSS_n552 17.0005
R8929 AVSS_n622 AVSS_n550 17.0005
R8930 AVSS_n622 AVSS_n549 17.0005
R8931 AVSS_n622 AVSS_n548 17.0005
R8932 AVSS_n622 AVSS_n547 17.0005
R8933 AVSS_n605 AVSS_n604 17.0005
R8934 AVSS_n605 AVSS_n576 17.0005
R8935 AVSS_n606 AVSS_n605 17.0005
R8936 AVSS_n605 AVSS_n575 17.0005
R8937 AVSS_n604 AVSS_n570 17.0005
R8938 AVSS_n576 AVSS_n570 17.0005
R8939 AVSS_n606 AVSS_n570 17.0005
R8940 AVSS_n575 AVSS_n570 17.0005
R8941 AVSS_n765 AVSS_n764 17.0005
R8942 AVSS_n765 AVSS_n333 17.0005
R8943 AVSS_n765 AVSS_n313 17.0005
R8944 AVSS_n765 AVSS_n332 17.0005
R8945 AVSS_n765 AVSS_n314 17.0005
R8946 AVSS_n765 AVSS_n331 17.0005
R8947 AVSS_n765 AVSS_n315 17.0005
R8948 AVSS_n765 AVSS_n330 17.0005
R8949 AVSS_n765 AVSS_n316 17.0005
R8950 AVSS_n765 AVSS_n329 17.0005
R8951 AVSS_n765 AVSS_n318 17.0005
R8952 AVSS_n765 AVSS_n327 17.0005
R8953 AVSS_n765 AVSS_n319 17.0005
R8954 AVSS_n765 AVSS_n325 17.0005
R8955 AVSS_n765 AVSS_n321 17.0005
R8956 AVSS_n765 AVSS_n324 17.0005
R8957 AVSS_n764 AVSS_n311 17.0005
R8958 AVSS_n333 AVSS_n311 17.0005
R8959 AVSS_n313 AVSS_n311 17.0005
R8960 AVSS_n332 AVSS_n311 17.0005
R8961 AVSS_n314 AVSS_n311 17.0005
R8962 AVSS_n331 AVSS_n311 17.0005
R8963 AVSS_n315 AVSS_n311 17.0005
R8964 AVSS_n330 AVSS_n311 17.0005
R8965 AVSS_n316 AVSS_n311 17.0005
R8966 AVSS_n348 AVSS_n311 17.0005
R8967 AVSS_n344 AVSS_n311 17.0005
R8968 AVSS_n339 AVSS_n311 17.0005
R8969 AVSS_n448 AVSS_n447 17.0005
R8970 AVSS_n448 AVSS_n433 17.0005
R8971 AVSS_n448 AVSS_n425 17.0005
R8972 AVSS_n448 AVSS_n432 17.0005
R8973 AVSS_n448 AVSS_n426 17.0005
R8974 AVSS_n448 AVSS_n431 17.0005
R8975 AVSS_n448 AVSS_n427 17.0005
R8976 AVSS_n448 AVSS_n430 17.0005
R8977 AVSS_n447 AVSS_n446 17.0005
R8978 AVSS_n446 AVSS_n433 17.0005
R8979 AVSS_n446 AVSS_n425 17.0005
R8980 AVSS_n446 AVSS_n432 17.0005
R8981 AVSS_n446 AVSS_n426 17.0005
R8982 AVSS_n446 AVSS_n431 17.0005
R8983 AVSS_n446 AVSS_n427 17.0005
R8984 AVSS_n446 AVSS_n430 17.0005
R8985 AVSS_n753 AVSS_n752 17.0005
R8986 AVSS_n752 AVSS_n413 17.0005
R8987 AVSS_n752 AVSS_n403 17.0005
R8988 AVSS_n752 AVSS_n410 17.0005
R8989 AVSS_n752 AVSS_n404 17.0005
R8990 AVSS_n752 AVSS_n409 17.0005
R8991 AVSS_n752 AVSS_n405 17.0005
R8992 AVSS_n752 AVSS_n408 17.0005
R8993 AVSS_n414 AVSS_n401 17.0005
R8994 AVSS_n753 AVSS_n401 17.0005
R8995 AVSS_n413 AVSS_n401 17.0005
R8996 AVSS_n403 AVSS_n401 17.0005
R8997 AVSS_n410 AVSS_n401 17.0005
R8998 AVSS_n404 AVSS_n401 17.0005
R8999 AVSS_n409 AVSS_n401 17.0005
R9000 AVSS_n405 AVSS_n401 17.0005
R9001 AVSS_n408 AVSS_n401 17.0005
R9002 AVSS_n639 AVSS_n637 17.0005
R9003 AVSS_n639 AVSS_n636 17.0005
R9004 AVSS_n639 AVSS_n635 17.0005
R9005 AVSS_n639 AVSS_n518 17.0005
R9006 AVSS_n639 AVSS_n517 17.0005
R9007 AVSS_n639 AVSS_n516 17.0005
R9008 AVSS_n643 AVSS_n637 17.0005
R9009 AVSS_n643 AVSS_n636 17.0005
R9010 AVSS_n643 AVSS_n635 17.0005
R9011 AVSS_n643 AVSS_n518 17.0005
R9012 AVSS_n643 AVSS_n517 17.0005
R9013 AVSS_n643 AVSS_n516 17.0005
R9014 AVSS_n731 AVSS_n730 17.0005
R9015 AVSS_n731 AVSS_n509 17.0005
R9016 AVSS_n731 AVSS_n500 17.0005
R9017 AVSS_n731 AVSS_n493 17.0005
R9018 AVSS_n732 AVSS_n731 17.0005
R9019 AVSS_n731 AVSS_n506 17.0005
R9020 AVSS_n730 AVSS_n495 17.0005
R9021 AVSS_n509 AVSS_n495 17.0005
R9022 AVSS_n500 AVSS_n495 17.0005
R9023 AVSS_n495 AVSS_n493 17.0005
R9024 AVSS_n732 AVSS_n495 17.0005
R9025 AVSS_n506 AVSS_n495 17.0005
R9026 AVSS_n602 AVSS_n601 17.0005
R9027 AVSS_n602 AVSS_n592 17.0005
R9028 AVSS_n603 AVSS_n602 17.0005
R9029 AVSS_n602 AVSS_n590 17.0005
R9030 AVSS_n602 AVSS_n588 17.0005
R9031 AVSS_n601 AVSS_n585 17.0005
R9032 AVSS_n592 AVSS_n585 17.0005
R9033 AVSS_n603 AVSS_n585 17.0005
R9034 AVSS_n590 AVSS_n585 17.0005
R9035 AVSS_n588 AVSS_n585 17.0005
R9036 AVSS_n734 AVSS_n733 17.0005
R9037 AVSS_n734 AVSS_n492 17.0005
R9038 AVSS_n734 AVSS_n465 17.0005
R9039 AVSS_n734 AVSS_n491 17.0005
R9040 AVSS_n734 AVSS_n466 17.0005
R9041 AVSS_n734 AVSS_n483 17.0005
R9042 AVSS_n734 AVSS_n467 17.0005
R9043 AVSS_n734 AVSS_n482 17.0005
R9044 AVSS_n734 AVSS_n468 17.0005
R9045 AVSS_n734 AVSS_n481 17.0005
R9046 AVSS_n734 AVSS_n469 17.0005
R9047 AVSS_n734 AVSS_n480 17.0005
R9048 AVSS_n734 AVSS_n470 17.0005
R9049 AVSS_n734 AVSS_n479 17.0005
R9050 AVSS_n734 AVSS_n471 17.0005
R9051 AVSS_n734 AVSS_n478 17.0005
R9052 AVSS_n734 AVSS_n472 17.0005
R9053 AVSS_n734 AVSS_n477 17.0005
R9054 AVSS_n734 AVSS_n473 17.0005
R9055 AVSS_n734 AVSS_n476 17.0005
R9056 AVSS_n734 AVSS_n474 17.0005
R9057 AVSS_n733 AVSS_n494 17.0005
R9058 AVSS_n494 AVSS_n492 17.0005
R9059 AVSS_n494 AVSS_n465 17.0005
R9060 AVSS_n494 AVSS_n491 17.0005
R9061 AVSS_n494 AVSS_n466 17.0005
R9062 AVSS_n494 AVSS_n483 17.0005
R9063 AVSS_n494 AVSS_n467 17.0005
R9064 AVSS_n494 AVSS_n482 17.0005
R9065 AVSS_n494 AVSS_n468 17.0005
R9066 AVSS_n494 AVSS_n481 17.0005
R9067 AVSS_n494 AVSS_n469 17.0005
R9068 AVSS_n494 AVSS_n480 17.0005
R9069 AVSS_n494 AVSS_n470 17.0005
R9070 AVSS_n494 AVSS_n479 17.0005
R9071 AVSS_n494 AVSS_n471 17.0005
R9072 AVSS_n494 AVSS_n478 17.0005
R9073 AVSS_n494 AVSS_n472 17.0005
R9074 AVSS_n494 AVSS_n477 17.0005
R9075 AVSS_n494 AVSS_n473 17.0005
R9076 AVSS_n494 AVSS_n476 17.0005
R9077 AVSS_n494 AVSS_n474 17.0005
R9078 AVSS_n633 AVSS_n630 17.0005
R9079 AVSS_n633 AVSS_n629 17.0005
R9080 AVSS_n633 AVSS_n628 17.0005
R9081 AVSS_n633 AVSS_n627 17.0005
R9082 AVSS_n633 AVSS_n625 17.0005
R9083 AVSS_n633 AVSS_n624 17.0005
R9084 AVSS_n633 AVSS_n544 17.0005
R9085 AVSS_n633 AVSS_n543 17.0005
R9086 AVSS_n633 AVSS_n542 17.0005
R9087 AVSS_n633 AVSS_n541 17.0005
R9088 AVSS_n633 AVSS_n540 17.0005
R9089 AVSS_n633 AVSS_n539 17.0005
R9090 AVSS_n633 AVSS_n538 17.0005
R9091 AVSS_n633 AVSS_n537 17.0005
R9092 AVSS_n633 AVSS_n536 17.0005
R9093 AVSS_n633 AVSS_n535 17.0005
R9094 AVSS_n633 AVSS_n534 17.0005
R9095 AVSS_n633 AVSS_n533 17.0005
R9096 AVSS_n633 AVSS_n532 17.0005
R9097 AVSS_n633 AVSS_n531 17.0005
R9098 AVSS_n633 AVSS_n530 17.0005
R9099 AVSS_n633 AVSS_n529 17.0005
R9100 AVSS_n633 AVSS_n528 17.0005
R9101 AVSS_n633 AVSS_n527 17.0005
R9102 AVSS_n633 AVSS_n526 17.0005
R9103 AVSS_n633 AVSS_n525 17.0005
R9104 AVSS_n633 AVSS_n524 17.0005
R9105 AVSS_n633 AVSS_n523 17.0005
R9106 AVSS_n633 AVSS_n522 17.0005
R9107 AVSS_n633 AVSS_n521 17.0005
R9108 AVSS_n633 AVSS_n520 17.0005
R9109 AVSS_n2222 AVSS_n1065 16.7447
R9110 AVSS_n1123 AVSS_n1077 16.7447
R9111 AVSS_n1169 AVSS_n1143 16.7447
R9112 AVSS_n1172 AVSS_n1144 16.7447
R9113 AVSS_n1175 AVSS_n1145 16.7447
R9114 AVSS_n1177 AVSS_n1146 16.7447
R9115 AVSS_n1180 AVSS_n1147 16.7447
R9116 AVSS_n1198 AVSS_n1152 16.7447
R9117 AVSS_n1200 AVSS_n1153 16.7447
R9118 AVSS_n1357 AVSS_n1256 16.7447
R9119 AVSS_n1402 AVSS_n1272 16.7447
R9120 AVSS_n1311 AVSS_n1287 16.7447
R9121 AVSS_n1315 AVSS_n1287 16.7447
R9122 AVSS_n491 AVSS_n490 16.6779
R9123 AVSS_n484 AVSS_n465 16.6779
R9124 AVSS_n400 AVSS_n386 16.0364
R9125 AVSS_n399 AVSS_n387 16.0364
R9126 AVSS_n406 AVSS_n388 16.0364
R9127 AVSS_n408 AVSS_n389 16.0364
R9128 AVSS_n405 AVSS_n390 16.0364
R9129 AVSS_n409 AVSS_n391 16.0364
R9130 AVSS_n437 AVSS_n404 16.0364
R9131 AVSS_n634 AVSS_n481 16.0364
R9132 AVSS_n733 AVSS_n493 16.0364
R9133 AVSS_n1141 AVSS_n1140 15.8145
R9134 AVSS_n1394 AVSS_n1393 15.8145
R9135 AVSS_n1333 AVSS_n1332 15.8145
R9136 AVSS_n1328 AVSS_n1295 15.8145
R9137 AVSS_n2224 AVSS_n1068 14.8842
R9138 AVSS_n1221 AVSS_n1118 14.8842
R9139 AVSS_n1165 AVSS_n1142 14.8842
R9140 AVSS_n1167 AVSS_n1143 14.8842
R9141 AVSS_n1191 AVSS_n1148 14.8842
R9142 AVSS_n1195 AVSS_n1149 14.8842
R9143 AVSS_n1197 AVSS_n1150 14.8842
R9144 AVSS_n1198 AVSS_n1151 14.8842
R9145 AVSS_n1374 AVSS_n1255 14.8842
R9146 AVSS_n1400 AVSS_n1273 14.8842
R9147 AVSS_n1337 AVSS_n1293 14.8842
R9148 AVSS_n1324 AVSS_n1300 14.8842
R9149 AVSS_n1342 AVSS_n1292 14.8842
R9150 AVSS_n1340 AVSS_n1301 14.8842
R9151 AVSS_n1313 AVSS_n1311 14.8842
R9152 AVSS_n1316 AVSS_n1315 14.8842
R9153 AVSS_n3231 AVSS_n187 14.818
R9154 AVSS_n191 AVSS_n188 14.818
R9155 AVSS_n210 AVSS_n209 14.818
R9156 AVSS_n199 AVSS_n187 14.818
R9157 AVSS_n3233 AVSS_n191 14.818
R9158 AVSS_n215 AVSS_n210 14.818
R9159 AVSS_n1535 AVSS_n1513 14.818
R9160 AVSS_n1545 AVSS_n1544 14.818
R9161 AVSS_n1530 AVSS_n1528 14.818
R9162 AVSS_n2767 AVSS_n1513 14.818
R9163 AVSS_n1545 AVSS_n1524 14.818
R9164 AVSS_n1533 AVSS_n1530 14.818
R9165 AVSS_n2809 AVSS_n2808 14.739
R9166 AVSS_n1021 AVSS_n1003 14.7097
R9167 AVSS_n508 AVSS_n500 14.1121
R9168 AVSS_n727 AVSS_n509 14.1121
R9169 AVSS_n729 AVSS_n728 14.1121
R9170 AVSS_n730 AVSS_n726 14.1121
R9171 AVSS_n1006 AVSS_n1001 14.0764
R9172 AVSS_n1052 AVSS_n1002 14.0764
R9173 AVSS_n1033 AVSS_n1003 14.0764
R9174 AVSS_n2813 AVSS_n1006 14.0764
R9175 AVSS_n1052 AVSS_n1004 14.0764
R9176 AVSS_n1037 AVSS_n1033 14.0764
R9177 AVSS_n2403 AVSS_n2248 14.0432
R9178 AVSS_n737 AVSS_n1 14.0432
R9179 AVSS_n1119 AVSS_n1094 13.954
R9180 AVSS_n1120 AVSS_n1078 13.954
R9181 AVSS_n1121 AVSS_n1095 13.954
R9182 AVSS_n1230 AVSS_n1229 13.954
R9183 AVSS_n1122 AVSS_n1077 13.954
R9184 AVSS_n1124 AVSS_n1096 13.954
R9185 AVSS_n1139 AVSS_n1138 13.954
R9186 AVSS_n2798 AVSS_n2797 13.954
R9187 AVSS_n1166 AVSS_n1142 13.954
R9188 AVSS_n1363 AVSS_n1362 13.954
R9189 AVSS_n1394 AVSS_n1264 13.954
R9190 AVSS_n1352 AVSS_n1351 13.954
R9191 AVSS_n1352 AVSS_n1265 13.954
R9192 AVSS_n1391 AVSS_n1266 13.954
R9193 AVSS_n1409 AVSS_n1267 13.954
R9194 AVSS_n1407 AVSS_n1268 13.954
R9195 AVSS_n1405 AVSS_n1269 13.954
R9196 AVSS_n1403 AVSS_n1271 13.954
R9197 AVSS_n1401 AVSS_n1272 13.954
R9198 AVSS_n1399 AVSS_n1273 13.954
R9199 AVSS_n1397 AVSS_n1274 13.954
R9200 AVSS_n1412 AVSS_n1275 13.954
R9201 AVSS_n1395 AVSS_n1276 13.954
R9202 AVSS_n1417 AVSS_n1416 13.954
R9203 AVSS_n1332 AVSS_n1296 13.954
R9204 AVSS_n1329 AVSS_n1328 13.954
R9205 AVSS_n1340 AVSS_n1339 13.954
R9206 AVSS_n2792 AVSS_n1162 13.7998
R9207 AVSS_n722 AVSS_n721 13.34
R9208 AVSS_n2416 AVSS_n771 13.3393
R9209 AVSS_n438 AVSS_n384 13.2879
R9210 AVSS_n2226 AVSS_n1063 13.0238
R9211 AVSS_n1139 AVSS_n1112 13.0238
R9212 AVSS_n1141 AVSS_n1104 13.0238
R9213 AVSS_n2794 AVSS_n1113 13.0238
R9214 AVSS_n1168 AVSS_n1144 13.0238
R9215 AVSS_n1200 AVSS_n1199 13.0238
R9216 AVSS_n1360 AVSS_n1254 13.0238
R9217 AVSS_n1270 AVSS_n1269 13.0238
R9218 AVSS_n1398 AVSS_n1274 13.0238
R9219 AVSS_n1312 AVSS_n1288 13.0238
R9220 AVSS_n1314 AVSS_n1286 13.0238
R9221 AVSS_n548 AVSS_n536 12.8292
R9222 AVSS_n549 AVSS_n537 12.8292
R9223 AVSS_n550 AVSS_n538 12.8292
R9224 AVSS_n500 AVSS_n499 12.4758
R9225 AVSS_n655 AVSS_n651 12.4175
R9226 AVSS_n2417 AVSS_n2414 12.4165
R9227 AVSS_n435 AVSS_n434 12.1878
R9228 AVSS_n428 AVSS_n373 12.1878
R9229 AVSS_n430 AVSS_n374 12.1878
R9230 AVSS_n427 AVSS_n375 12.1878
R9231 AVSS_n431 AVSS_n376 12.1878
R9232 AVSS_n426 AVSS_n377 12.1878
R9233 AVSS_n432 AVSS_n379 12.1878
R9234 AVSS_n425 AVSS_n380 12.1878
R9235 AVSS_n433 AVSS_n381 12.1878
R9236 AVSS_n423 AVSS_n382 12.1878
R9237 AVSS_n447 AVSS_n383 12.1878
R9238 AVSS_n548 AVSS_n535 12.1878
R9239 AVSS_n539 AVSS_n474 12.1878
R9240 AVSS_n540 AVSS_n476 12.1878
R9241 AVSS_n541 AVSS_n473 12.1878
R9242 AVSS_n542 AVSS_n477 12.1878
R9243 AVSS_n543 AVSS_n472 12.1878
R9244 AVSS_n544 AVSS_n478 12.1878
R9245 AVSS_n624 AVSS_n471 12.1878
R9246 AVSS_n625 AVSS_n479 12.1878
R9247 AVSS_n1223 AVSS_n1222 12.0935
R9248 AVSS_n1126 AVSS_n1125 12.0935
R9249 AVSS_n1110 AVSS_n1100 12.0935
R9250 AVSS_n1373 AVSS_n1372 12.0935
R9251 AVSS_n1391 AVSS_n1390 12.0935
R9252 AVSS_n1417 AVSS_n1414 12.0935
R9253 AVSS_n2782 AVSS_n1282 12.0935
R9254 AVSS_n1335 AVSS_n1334 12.0935
R9255 AVSS_n1342 AVSS_n1338 12.0935
R9256 AVSS_n2773 AVSS_n2772 12.0935
R9257 AVSS_n665 AVSS_n661 11.8702
R9258 AVSS_n1452 AVSS_n1447 11.7799
R9259 AVSS_n2394 AVSS_n1491 11.7799
R9260 AVSS_n1507 AVSS_n1435 11.7799
R9261 AVSS_n2769 AVSS_n1452 11.7799
R9262 AVSS_n2394 AVSS_n1450 11.7799
R9263 AVSS_n2771 AVSS_n1435 11.7799
R9264 AVSS_n359 AVSS_n316 11.5464
R9265 AVSS_n361 AVSS_n330 11.5464
R9266 AVSS_n357 AVSS_n315 11.5464
R9267 AVSS_n362 AVSS_n331 11.5464
R9268 AVSS_n558 AVSS_n523 11.5464
R9269 AVSS_n563 AVSS_n524 11.5464
R9270 AVSS_n588 AVSS_n529 11.5464
R9271 AVSS_n590 AVSS_n530 11.5464
R9272 AVSS_n603 AVSS_n531 11.5464
R9273 AVSS_n592 AVSS_n532 11.5464
R9274 AVSS_n586 AVSS_n533 11.5464
R9275 AVSS_n627 AVSS_n626 11.5464
R9276 AVSS_n628 AVSS_n516 11.5464
R9277 AVSS_n629 AVSS_n517 11.5464
R9278 AVSS_n631 AVSS_n518 11.5464
R9279 AVSS_n699 AVSS_n684 11.4203
R9280 AVSS_n2419 AVSS_n2412 11.4203
R9281 AVSS_n698 AVSS_n685 11.3363
R9282 AVSS_n2433 AVSS_n2408 11.3363
R9283 AVSS_n3477 AVSS_n37 11.2172
R9284 AVSS_n126 AVSS_n37 11.2172
R9285 AVSS_n38 AVSS_n34 11.2172
R9286 AVSS_n125 AVSS_n118 11.2172
R9287 AVSS_n3473 AVSS_n94 11.2172
R9288 AVSS_n126 AVSS_n10 11.2172
R9289 AVSS_n3477 AVSS_n3476 11.2172
R9290 AVSS_n3476 AVSS_n38 11.2172
R9291 AVSS_n125 AVSS_n34 11.2172
R9292 AVSS_n118 AVSS_n94 11.2172
R9293 AVSS_n2807 AVSS_n1060 11.1633
R9294 AVSS_n2223 AVSS_n1067 11.1633
R9295 AVSS_n2225 AVSS_n1065 11.1633
R9296 AVSS_n2227 AVSS_n1068 11.1633
R9297 AVSS_n2228 AVSS_n1063 11.1633
R9298 AVSS_n1084 AVSS_n1073 11.1633
R9299 AVSS_n1372 AVSS_n1253 11.1633
R9300 AVSS_n1404 AVSS_n1268 11.1633
R9301 AVSS_n1396 AVSS_n1275 11.1633
R9302 AVSS_n1310 AVSS_n1308 11.1633
R9303 AVSS_n1318 AVSS_n1317 11.1633
R9304 AVSS_n718 AVSS_n717 10.9538
R9305 AVSS_n502 AVSS_n501 10.9049
R9306 AVSS_n506 AVSS_n505 10.9049
R9307 AVSS_n732 AVSS_n496 10.9049
R9308 AVSS_n359 AVSS_n330 10.2635
R9309 AVSS_n361 AVSS_n315 10.2635
R9310 AVSS_n357 AVSS_n331 10.2635
R9311 AVSS_n362 AVSS_n314 10.2635
R9312 AVSS_n558 AVSS_n524 10.2635
R9313 AVSS_n563 AVSS_n525 10.2635
R9314 AVSS_n572 AVSS_n526 10.2635
R9315 AVSS_n564 AVSS_n527 10.2635
R9316 AVSS_n608 AVSS_n528 10.2635
R9317 AVSS_n586 AVSS_n532 10.2635
R9318 AVSS_n601 AVSS_n533 10.2635
R9319 AVSS_n584 AVSS_n534 10.2635
R9320 AVSS_n630 AVSS_n518 10.2635
R9321 AVSS_n24 AVSS_n11 10.2371
R9322 AVSS_n2059 AVSS_n26 10.2371
R9323 AVSS_n2058 AVSS_n2050 10.2371
R9324 AVSS_n3493 AVSS_n11 10.2371
R9325 AVSS_n2059 AVSS_n31 10.2371
R9326 AVSS_n2062 AVSS_n2050 10.2371
R9327 AVSS_n1227 AVSS_n1226 10.2331
R9328 AVSS_n1128 AVSS_n1106 10.2331
R9329 AVSS_n1137 AVSS_n1102 10.2331
R9330 AVSS_n1361 AVSS_n1360 10.2331
R9331 AVSS_n1409 AVSS_n1408 10.2331
R9332 AVSS_n1415 AVSS_n1395 10.2331
R9333 AVSS_n1327 AVSS_n1326 10.2331
R9334 AVSS_n1298 AVSS_n1293 10.2331
R9335 AVSS_n1324 AVSS_n1323 10.2331
R9336 AVSS_n2100 AVSS_n2099 9.77327
R9337 AVSS_n436 AVSS_n435 9.62205
R9338 AVSS_n434 AVSS_n373 9.62205
R9339 AVSS_n428 AVSS_n374 9.62205
R9340 AVSS_n430 AVSS_n375 9.62205
R9341 AVSS_n427 AVSS_n376 9.62205
R9342 AVSS_n431 AVSS_n377 9.62205
R9343 AVSS_n439 AVSS_n426 9.62205
R9344 AVSS_n440 AVSS_n432 9.62205
R9345 AVSS_n425 AVSS_n379 9.62205
R9346 AVSS_n433 AVSS_n380 9.62205
R9347 AVSS_n423 AVSS_n381 9.62205
R9348 AVSS_n447 AVSS_n382 9.62205
R9349 AVSS_n445 AVSS_n383 9.62205
R9350 AVSS_n600 AVSS_n534 9.62205
R9351 AVSS_n547 AVSS_n535 9.62205
R9352 AVSS_n551 AVSS_n539 9.62205
R9353 AVSS_n625 AVSS_n471 9.62205
R9354 AVSS_n627 AVSS_n479 9.62205
R9355 AVSS_n628 AVSS_n470 9.62205
R9356 AVSS_n629 AVSS_n480 9.62205
R9357 AVSS_n631 AVSS_n469 9.62205
R9358 AVSS_n3497 AVSS_n5 9.41029
R9359 AVSS_n347 AVSS_n346 9.36493
R9360 AVSS_n346 AVSS_n329 9.36493
R9361 AVSS_n2229 AVSS_n2228 9.30283
R9362 AVSS_n2231 AVSS_n1071 9.30283
R9363 AVSS_n1209 AVSS_n1081 9.30283
R9364 AVSS_n1195 AVSS_n1194 9.30283
R9365 AVSS_n1197 AVSS_n1196 9.30283
R9366 AVSS_n1164 AVSS_n1159 9.30283
R9367 AVSS_n1362 AVSS_n1252 9.30283
R9368 AVSS_n1261 AVSS_n1260 9.30283
R9369 AVSS_n1406 AVSS_n1267 9.30283
R9370 AVSS_n1411 AVSS_n1276 9.30283
R9371 AVSS_n1309 AVSS_n1289 9.30283
R9372 AVSS_n2777 AVSS_n2776 9.30283
R9373 AVSS_n3280 AVSS_n140 9.05841
R9374 AVSS_n3369 AVSS_n3368 9.05841
R9375 AVSS_n3327 AVSS_n3312 9.05841
R9376 AVSS_n3418 AVSS_n140 9.05841
R9377 AVSS_n3369 AVSS_n3315 9.05841
R9378 AVSS_n3358 AVSS_n3327 9.05841
R9379 AVSS_n549 AVSS_n536 8.98061
R9380 AVSS_n550 AVSS_n537 8.98061
R9381 AVSS_n552 AVSS_n538 8.98061
R9382 AVSS_n553 AVSS_n540 8.98061
R9383 AVSS_n554 AVSS_n541 8.98061
R9384 AVSS_n614 AVSS_n542 8.98061
R9385 AVSS_n616 AVSS_n543 8.98061
R9386 AVSS_n615 AVSS_n544 8.98061
R9387 AVSS_n624 AVSS_n623 8.98061
R9388 AVSS_n670 AVSS_n669 8.81614
R9389 AVSS_n669 AVSS_n668 8.81614
R9390 AVSS_n1915 AVSS_n1909 8.55956
R9391 AVSS_n2128 AVSS_n1910 8.55956
R9392 AVSS_n2064 AVSS_n1911 8.55956
R9393 AVSS_n2763 AVSS_n1915 8.55956
R9394 AVSS_n2128 AVSS_n1913 8.55956
R9395 AVSS_n2100 AVSS_n2064 8.55956
R9396 AVSS_n681 AVSS_n680 8.50175
R9397 AVSS_n31 AVSS_n29 8.501
R9398 AVSS_n3476 AVSS_n42 8.501
R9399 AVSS_n3233 AVSS_n194 8.501
R9400 AVSS_n26 AVSS_n25 8.501
R9401 AVSS_n3474 AVSS_n34 8.501
R9402 AVSS_n82 AVSS_n34 8.501
R9403 AVSS_n77 AVSS_n34 8.501
R9404 AVSS_n74 AVSS_n34 8.501
R9405 AVSS_n71 AVSS_n34 8.501
R9406 AVSS_n65 AVSS_n34 8.501
R9407 AVSS_n62 AVSS_n34 8.501
R9408 AVSS_n60 AVSS_n34 8.501
R9409 AVSS_n3368 AVSS_n3313 8.501
R9410 AVSS_n3368 AVSS_n3360 8.501
R9411 AVSS_n3368 AVSS_n3367 8.501
R9412 AVSS_n3368 AVSS_n3361 8.501
R9413 AVSS_n3368 AVSS_n3366 8.501
R9414 AVSS_n3368 AVSS_n3362 8.501
R9415 AVSS_n3368 AVSS_n3365 8.501
R9416 AVSS_n3368 AVSS_n3363 8.501
R9417 AVSS_n3368 AVSS_n3364 8.501
R9418 AVSS_n202 AVSS_n188 8.501
R9419 AVSS_n2909 AVSS_n223 8.501
R9420 AVSS_n2902 AVSS_n223 8.501
R9421 AVSS_n2896 AVSS_n223 8.501
R9422 AVSS_n2892 AVSS_n223 8.501
R9423 AVSS_n2887 AVSS_n223 8.501
R9424 AVSS_n2880 AVSS_n223 8.501
R9425 AVSS_n2874 AVSS_n223 8.501
R9426 AVSS_n2867 AVSS_n223 8.501
R9427 AVSS_n2861 AVSS_n223 8.501
R9428 AVSS_n2854 AVSS_n223 8.501
R9429 AVSS_n2848 AVSS_n223 8.501
R9430 AVSS_n2844 AVSS_n223 8.501
R9431 AVSS_n2838 AVSS_n223 8.501
R9432 AVSS_n2831 AVSS_n223 8.501
R9433 AVSS_n2825 AVSS_n223 8.501
R9434 AVSS_n2058 AVSS_n28 8.501
R9435 AVSS_n2058 AVSS_n2053 8.501
R9436 AVSS_n2058 AVSS_n2057 8.501
R9437 AVSS_n2058 AVSS_n2055 8.501
R9438 AVSS_n2058 AVSS_n2054 8.501
R9439 AVSS_n118 AVSS_n36 8.501
R9440 AVSS_n118 AVSS_n117 8.501
R9441 AVSS_n118 AVSS_n116 8.501
R9442 AVSS_n118 AVSS_n103 8.501
R9443 AVSS_n118 AVSS_n104 8.501
R9444 AVSS_n118 AVSS_n105 8.501
R9445 AVSS_n118 AVSS_n106 8.501
R9446 AVSS_n118 AVSS_n115 8.501
R9447 AVSS_n118 AVSS_n107 8.501
R9448 AVSS_n118 AVSS_n108 8.501
R9449 AVSS_n3449 AVSS_n118 8.501
R9450 AVSS_n118 AVSS_n114 8.501
R9451 AVSS_n118 AVSS_n113 8.501
R9452 AVSS_n118 AVSS_n112 8.501
R9453 AVSS_n118 AVSS_n111 8.501
R9454 AVSS_n118 AVSS_n109 8.501
R9455 AVSS_n118 AVSS_n110 8.501
R9456 AVSS_n3358 AVSS_n3314 8.501
R9457 AVSS_n3358 AVSS_n3357 8.501
R9458 AVSS_n3358 AVSS_n3356 8.501
R9459 AVSS_n3358 AVSS_n3328 8.501
R9460 AVSS_n3358 AVSS_n3329 8.501
R9461 AVSS_n3358 AVSS_n3330 8.501
R9462 AVSS_n3358 AVSS_n3331 8.501
R9463 AVSS_n3358 AVSS_n3332 8.501
R9464 AVSS_n3358 AVSS_n3355 8.501
R9465 AVSS_n3358 AVSS_n3354 8.501
R9466 AVSS_n3358 AVSS_n3353 8.501
R9467 AVSS_n3358 AVSS_n3352 8.501
R9468 AVSS_n3358 AVSS_n3351 8.501
R9469 AVSS_n3358 AVSS_n3333 8.501
R9470 AVSS_n3358 AVSS_n3334 8.501
R9471 AVSS_n3358 AVSS_n3335 8.501
R9472 AVSS_n3358 AVSS_n3336 8.501
R9473 AVSS_n3358 AVSS_n3337 8.501
R9474 AVSS_n3358 AVSS_n3350 8.501
R9475 AVSS_n3358 AVSS_n3349 8.501
R9476 AVSS_n3359 AVSS_n3358 8.501
R9477 AVSS_n3358 AVSS_n3338 8.501
R9478 AVSS_n3358 AVSS_n3339 8.501
R9479 AVSS_n3358 AVSS_n3340 8.501
R9480 AVSS_n3358 AVSS_n3341 8.501
R9481 AVSS_n3358 AVSS_n3348 8.501
R9482 AVSS_n3358 AVSS_n3347 8.501
R9483 AVSS_n3358 AVSS_n3346 8.501
R9484 AVSS_n3358 AVSS_n3345 8.501
R9485 AVSS_n3358 AVSS_n3342 8.501
R9486 AVSS_n3358 AVSS_n3343 8.501
R9487 AVSS_n3358 AVSS_n3344 8.501
R9488 AVSS_n215 AVSS_n190 8.501
R9489 AVSS_n215 AVSS_n211 8.501
R9490 AVSS_n215 AVSS_n212 8.501
R9491 AVSS_n215 AVSS_n213 8.501
R9492 AVSS_n3217 AVSS_n224 8.501
R9493 AVSS_n3217 AVSS_n2985 8.501
R9494 AVSS_n3217 AVSS_n2986 8.501
R9495 AVSS_n3217 AVSS_n2987 8.501
R9496 AVSS_n3217 AVSS_n2988 8.501
R9497 AVSS_n3217 AVSS_n3216 8.501
R9498 AVSS_n3217 AVSS_n3215 8.501
R9499 AVSS_n3217 AVSS_n3214 8.501
R9500 AVSS_n3217 AVSS_n3213 8.501
R9501 AVSS_n3217 AVSS_n3212 8.501
R9502 AVSS_n3217 AVSS_n2989 8.501
R9503 AVSS_n3217 AVSS_n2990 8.501
R9504 AVSS_n3217 AVSS_n2991 8.501
R9505 AVSS_n3217 AVSS_n2992 8.501
R9506 AVSS_n3217 AVSS_n2993 8.501
R9507 AVSS_n3217 AVSS_n3211 8.501
R9508 AVSS_n3217 AVSS_n3210 8.501
R9509 AVSS_n3217 AVSS_n2995 8.501
R9510 AVSS_n3217 AVSS_n2996 8.501
R9511 AVSS_n3217 AVSS_n2997 8.501
R9512 AVSS_n3217 AVSS_n2998 8.501
R9513 AVSS_n3217 AVSS_n3209 8.501
R9514 AVSS_n3217 AVSS_n3208 8.501
R9515 AVSS_n3217 AVSS_n3207 8.501
R9516 AVSS_n3217 AVSS_n3206 8.501
R9517 AVSS_n3217 AVSS_n3205 8.501
R9518 AVSS_n3217 AVSS_n2999 8.501
R9519 AVSS_n3217 AVSS_n3000 8.501
R9520 AVSS_n3217 AVSS_n3001 8.501
R9521 AVSS_n3217 AVSS_n3002 8.501
R9522 AVSS_n3217 AVSS_n3003 8.501
R9523 AVSS_n3217 AVSS_n3204 8.501
R9524 AVSS_n3217 AVSS_n3203 8.501
R9525 AVSS_n3217 AVSS_n3202 8.501
R9526 AVSS_n3217 AVSS_n3201 8.501
R9527 AVSS_n3217 AVSS_n3200 8.501
R9528 AVSS_n3217 AVSS_n3004 8.501
R9529 AVSS_n3217 AVSS_n3005 8.501
R9530 AVSS_n3217 AVSS_n3006 8.501
R9531 AVSS_n3217 AVSS_n3007 8.501
R9532 AVSS_n3217 AVSS_n3008 8.501
R9533 AVSS_n3217 AVSS_n3199 8.501
R9534 AVSS_n3217 AVSS_n3198 8.501
R9535 AVSS_n3217 AVSS_n3197 8.501
R9536 AVSS_n3217 AVSS_n3196 8.501
R9537 AVSS_n3217 AVSS_n3195 8.501
R9538 AVSS_n3217 AVSS_n3009 8.501
R9539 AVSS_n3217 AVSS_n3010 8.501
R9540 AVSS_n3217 AVSS_n3011 8.501
R9541 AVSS_n3217 AVSS_n3012 8.501
R9542 AVSS_n3217 AVSS_n3013 8.501
R9543 AVSS_n3217 AVSS_n3194 8.501
R9544 AVSS_n3217 AVSS_n3193 8.501
R9545 AVSS_n3217 AVSS_n3174 8.501
R9546 AVSS_n3217 AVSS_n3175 8.501
R9547 AVSS_n3217 AVSS_n3176 8.501
R9548 AVSS_n3217 AVSS_n3177 8.501
R9549 AVSS_n3217 AVSS_n3178 8.501
R9550 AVSS_n3217 AVSS_n3192 8.501
R9551 AVSS_n3217 AVSS_n3191 8.501
R9552 AVSS_n3217 AVSS_n3190 8.501
R9553 AVSS_n3217 AVSS_n3189 8.501
R9554 AVSS_n3217 AVSS_n3188 8.501
R9555 AVSS_n3217 AVSS_n3179 8.501
R9556 AVSS_n3217 AVSS_n3180 8.501
R9557 AVSS_n3217 AVSS_n3181 8.501
R9558 AVSS_n3217 AVSS_n3182 8.501
R9559 AVSS_n3217 AVSS_n3183 8.501
R9560 AVSS_n3217 AVSS_n3187 8.501
R9561 AVSS_n3217 AVSS_n3186 8.501
R9562 AVSS_n3217 AVSS_n3185 8.501
R9563 AVSS_n3217 AVSS_n3184 8.501
R9564 AVSS_n2062 AVSS_n2061 8.501
R9565 AVSS_n2062 AVSS_n27 8.501
R9566 AVSS_n2062 AVSS_n2052 8.501
R9567 AVSS_n2062 AVSS_n2048 8.501
R9568 AVSS_n2062 AVSS_n2049 8.501
R9569 AVSS_n2062 AVSS_n2051 8.501
R9570 AVSS_n3473 AVSS_n35 8.501
R9571 AVSS_n3473 AVSS_n3472 8.501
R9572 AVSS_n3473 AVSS_n86 8.501
R9573 AVSS_n3473 AVSS_n87 8.501
R9574 AVSS_n3473 AVSS_n3471 8.501
R9575 AVSS_n3473 AVSS_n102 8.501
R9576 AVSS_n3473 AVSS_n88 8.501
R9577 AVSS_n3473 AVSS_n101 8.501
R9578 AVSS_n3473 AVSS_n100 8.501
R9579 AVSS_n3473 AVSS_n89 8.501
R9580 AVSS_n3473 AVSS_n99 8.501
R9581 AVSS_n3473 AVSS_n98 8.501
R9582 AVSS_n3473 AVSS_n90 8.501
R9583 AVSS_n3473 AVSS_n91 8.501
R9584 AVSS_n3473 AVSS_n97 8.501
R9585 AVSS_n3473 AVSS_n92 8.501
R9586 AVSS_n3473 AVSS_n93 8.501
R9587 AVSS_n3473 AVSS_n96 8.501
R9588 AVSS_n3473 AVSS_n95 8.501
R9589 AVSS_n3312 AVSS_n3311 8.501
R9590 AVSS_n3312 AVSS_n3310 8.501
R9591 AVSS_n3312 AVSS_n3281 8.501
R9592 AVSS_n3312 AVSS_n3282 8.501
R9593 AVSS_n3312 AVSS_n3309 8.501
R9594 AVSS_n3312 AVSS_n3308 8.501
R9595 AVSS_n3312 AVSS_n3283 8.501
R9596 AVSS_n3312 AVSS_n3307 8.501
R9597 AVSS_n3312 AVSS_n3306 8.501
R9598 AVSS_n3312 AVSS_n3284 8.501
R9599 AVSS_n3312 AVSS_n3285 8.501
R9600 AVSS_n3312 AVSS_n3305 8.501
R9601 AVSS_n3312 AVSS_n3286 8.501
R9602 AVSS_n3312 AVSS_n3287 8.501
R9603 AVSS_n3312 AVSS_n3304 8.501
R9604 AVSS_n3312 AVSS_n3303 8.501
R9605 AVSS_n3312 AVSS_n3288 8.501
R9606 AVSS_n3312 AVSS_n3302 8.501
R9607 AVSS_n3312 AVSS_n3301 8.501
R9608 AVSS_n3312 AVSS_n3289 8.501
R9609 AVSS_n3326 AVSS_n3312 8.501
R9610 AVSS_n3312 AVSS_n3300 8.501
R9611 AVSS_n3312 AVSS_n3299 8.501
R9612 AVSS_n3312 AVSS_n3290 8.501
R9613 AVSS_n3312 AVSS_n3298 8.501
R9614 AVSS_n3312 AVSS_n138 8.501
R9615 AVSS_n3312 AVSS_n137 8.501
R9616 AVSS_n3312 AVSS_n3291 8.501
R9617 AVSS_n3312 AVSS_n3297 8.501
R9618 AVSS_n3312 AVSS_n3292 8.501
R9619 AVSS_n3312 AVSS_n3293 8.501
R9620 AVSS_n3312 AVSS_n3296 8.501
R9621 AVSS_n3312 AVSS_n3295 8.501
R9622 AVSS_n3312 AVSS_n3294 8.501
R9623 AVSS_n209 AVSS_n189 8.501
R9624 AVSS_n209 AVSS_n200 8.501
R9625 AVSS_n209 AVSS_n208 8.501
R9626 AVSS_n209 AVSS_n206 8.501
R9627 AVSS_n209 AVSS_n207 8.501
R9628 AVSS_n3219 AVSS_n221 8.501
R9629 AVSS_n3220 AVSS_n3219 8.501
R9630 AVSS_n3219 AVSS_n2914 8.501
R9631 AVSS_n3219 AVSS_n2915 8.501
R9632 AVSS_n3219 AVSS_n2916 8.501
R9633 AVSS_n3219 AVSS_n2917 8.501
R9634 AVSS_n3219 AVSS_n2918 8.501
R9635 AVSS_n3219 AVSS_n2919 8.501
R9636 AVSS_n3219 AVSS_n2920 8.501
R9637 AVSS_n3219 AVSS_n2921 8.501
R9638 AVSS_n3219 AVSS_n2922 8.501
R9639 AVSS_n3219 AVSS_n2923 8.501
R9640 AVSS_n3219 AVSS_n2924 8.501
R9641 AVSS_n3219 AVSS_n2925 8.501
R9642 AVSS_n3219 AVSS_n2926 8.501
R9643 AVSS_n3219 AVSS_n2927 8.501
R9644 AVSS_n3219 AVSS_n2928 8.501
R9645 AVSS_n3219 AVSS_n2929 8.501
R9646 AVSS_n3219 AVSS_n2930 8.501
R9647 AVSS_n3219 AVSS_n2931 8.501
R9648 AVSS_n3219 AVSS_n2932 8.501
R9649 AVSS_n3219 AVSS_n2933 8.501
R9650 AVSS_n3219 AVSS_n2934 8.501
R9651 AVSS_n3219 AVSS_n2935 8.501
R9652 AVSS_n3219 AVSS_n2936 8.501
R9653 AVSS_n3219 AVSS_n2937 8.501
R9654 AVSS_n3219 AVSS_n2938 8.501
R9655 AVSS_n3219 AVSS_n2939 8.501
R9656 AVSS_n3219 AVSS_n2940 8.501
R9657 AVSS_n3219 AVSS_n2941 8.501
R9658 AVSS_n3219 AVSS_n2942 8.501
R9659 AVSS_n3219 AVSS_n2943 8.501
R9660 AVSS_n3219 AVSS_n2944 8.501
R9661 AVSS_n3219 AVSS_n2945 8.501
R9662 AVSS_n3219 AVSS_n2946 8.501
R9663 AVSS_n3219 AVSS_n2947 8.501
R9664 AVSS_n3219 AVSS_n2948 8.501
R9665 AVSS_n3219 AVSS_n2949 8.501
R9666 AVSS_n3219 AVSS_n2950 8.501
R9667 AVSS_n3219 AVSS_n2951 8.501
R9668 AVSS_n3219 AVSS_n2952 8.501
R9669 AVSS_n3219 AVSS_n2953 8.501
R9670 AVSS_n3219 AVSS_n2954 8.501
R9671 AVSS_n3219 AVSS_n2955 8.501
R9672 AVSS_n3219 AVSS_n2956 8.501
R9673 AVSS_n3219 AVSS_n2957 8.501
R9674 AVSS_n3219 AVSS_n2958 8.501
R9675 AVSS_n3219 AVSS_n2959 8.501
R9676 AVSS_n3219 AVSS_n2960 8.501
R9677 AVSS_n3219 AVSS_n2961 8.501
R9678 AVSS_n3219 AVSS_n2962 8.501
R9679 AVSS_n3219 AVSS_n2963 8.501
R9680 AVSS_n3219 AVSS_n2964 8.501
R9681 AVSS_n3219 AVSS_n2965 8.501
R9682 AVSS_n3219 AVSS_n2966 8.501
R9683 AVSS_n3219 AVSS_n2967 8.501
R9684 AVSS_n3219 AVSS_n2968 8.501
R9685 AVSS_n3219 AVSS_n2969 8.501
R9686 AVSS_n3219 AVSS_n2970 8.501
R9687 AVSS_n3219 AVSS_n2971 8.501
R9688 AVSS_n3219 AVSS_n2972 8.501
R9689 AVSS_n3219 AVSS_n2973 8.501
R9690 AVSS_n3219 AVSS_n2974 8.501
R9691 AVSS_n3219 AVSS_n2975 8.501
R9692 AVSS_n3219 AVSS_n2976 8.501
R9693 AVSS_n3219 AVSS_n2977 8.501
R9694 AVSS_n3219 AVSS_n2978 8.501
R9695 AVSS_n3219 AVSS_n2979 8.501
R9696 AVSS_n3219 AVSS_n2980 8.501
R9697 AVSS_n3219 AVSS_n2981 8.501
R9698 AVSS_n3219 AVSS_n2982 8.501
R9699 AVSS_n3219 AVSS_n2983 8.501
R9700 AVSS_n3219 AVSS_n2984 8.501
R9701 AVSS_n681 AVSS_n659 8.501
R9702 AVSS_n680 AVSS_n660 8.501
R9703 AVSS_n2012 AVSS_n1913 8.501
R9704 AVSS_n1818 AVSS_n1540 8.501
R9705 AVSS_n1524 AVSS_n1523 8.501
R9706 AVSS_n1485 AVSS_n1450 8.501
R9707 AVSS_n1030 AVSS_n1004 8.501
R9708 AVSS_n848 AVSS_n840 8.501
R9709 AVSS_n2039 AVSS_n1910 8.501
R9710 AVSS_n2024 AVSS_n1910 8.501
R9711 AVSS_n2019 AVSS_n1910 8.501
R9712 AVSS_n2017 AVSS_n1910 8.501
R9713 AVSS_n2015 AVSS_n1910 8.501
R9714 AVSS_n2005 AVSS_n1910 8.501
R9715 AVSS_n1992 AVSS_n1910 8.501
R9716 AVSS_n1988 AVSS_n1910 8.501
R9717 AVSS_n1975 AVSS_n1910 8.501
R9718 AVSS_n1969 AVSS_n1910 8.501
R9719 AVSS_n1958 AVSS_n1910 8.501
R9720 AVSS_n1897 AVSS_n1538 8.501
R9721 AVSS_n1880 AVSS_n1538 8.501
R9722 AVSS_n1872 AVSS_n1538 8.501
R9723 AVSS_n1861 AVSS_n1538 8.501
R9724 AVSS_n1855 AVSS_n1538 8.501
R9725 AVSS_n1850 AVSS_n1538 8.501
R9726 AVSS_n1844 AVSS_n1538 8.501
R9727 AVSS_n1839 AVSS_n1538 8.501
R9728 AVSS_n1835 AVSS_n1538 8.501
R9729 AVSS_n1832 AVSS_n1538 8.501
R9730 AVSS_n1820 AVSS_n1538 8.501
R9731 AVSS_n1811 AVSS_n1538 8.501
R9732 AVSS_n1801 AVSS_n1538 8.501
R9733 AVSS_n1782 AVSS_n1538 8.501
R9734 AVSS_n1772 AVSS_n1538 8.501
R9735 AVSS_n1767 AVSS_n1538 8.501
R9736 AVSS_n1763 AVSS_n1538 8.501
R9737 AVSS_n1754 AVSS_n1538 8.501
R9738 AVSS_n1734 AVSS_n1538 8.501
R9739 AVSS_n1705 AVSS_n1538 8.501
R9740 AVSS_n1689 AVSS_n1538 8.501
R9741 AVSS_n1677 AVSS_n1538 8.501
R9742 AVSS_n1544 AVSS_n1534 8.501
R9743 AVSS_n1491 AVSS_n1448 8.501
R9744 AVSS_n1491 AVSS_n1490 8.501
R9745 AVSS_n1027 AVSS_n1002 8.501
R9746 AVSS_n947 AVSS_n838 8.501
R9747 AVSS_n853 AVSS_n838 8.501
R9748 AVSS_n936 AVSS_n838 8.501
R9749 AVSS_n863 AVSS_n838 8.501
R9750 AVSS_n932 AVSS_n838 8.501
R9751 AVSS_n872 AVSS_n838 8.501
R9752 AVSS_n924 AVSS_n838 8.501
R9753 AVSS_n877 AVSS_n838 8.501
R9754 AVSS_n917 AVSS_n838 8.501
R9755 AVSS_n882 AVSS_n838 8.501
R9756 AVSS_n912 AVSS_n838 8.501
R9757 AVSS_n887 AVSS_n838 8.501
R9758 AVSS_n907 AVSS_n838 8.501
R9759 AVSS_n894 AVSS_n838 8.501
R9760 AVSS_n2100 AVSS_n2065 8.501
R9761 AVSS_n2100 AVSS_n2066 8.501
R9762 AVSS_n2100 AVSS_n2067 8.501
R9763 AVSS_n2100 AVSS_n2068 8.501
R9764 AVSS_n2100 AVSS_n2098 8.501
R9765 AVSS_n2100 AVSS_n2069 8.501
R9766 AVSS_n2100 AVSS_n2070 8.501
R9767 AVSS_n2100 AVSS_n2071 8.501
R9768 AVSS_n2100 AVSS_n2097 8.501
R9769 AVSS_n2100 AVSS_n2072 8.501
R9770 AVSS_n2127 AVSS_n2100 8.501
R9771 AVSS_n2100 AVSS_n2096 8.501
R9772 AVSS_n2100 AVSS_n2073 8.501
R9773 AVSS_n2100 AVSS_n2074 8.501
R9774 AVSS_n2100 AVSS_n2075 8.501
R9775 AVSS_n2100 AVSS_n2076 8.501
R9776 AVSS_n2100 AVSS_n2095 8.501
R9777 AVSS_n2100 AVSS_n2094 8.501
R9778 AVSS_n2100 AVSS_n2093 8.501
R9779 AVSS_n2100 AVSS_n2092 8.501
R9780 AVSS_n2100 AVSS_n2091 8.501
R9781 AVSS_n2100 AVSS_n2077 8.501
R9782 AVSS_n2100 AVSS_n2078 8.501
R9783 AVSS_n2100 AVSS_n2090 8.501
R9784 AVSS_n2100 AVSS_n2089 8.501
R9785 AVSS_n2100 AVSS_n2088 8.501
R9786 AVSS_n2100 AVSS_n2087 8.501
R9787 AVSS_n2100 AVSS_n2086 8.501
R9788 AVSS_n2100 AVSS_n2079 8.501
R9789 AVSS_n2100 AVSS_n2080 8.501
R9790 AVSS_n2100 AVSS_n2081 8.501
R9791 AVSS_n2100 AVSS_n2085 8.501
R9792 AVSS_n2100 AVSS_n2084 8.501
R9793 AVSS_n2100 AVSS_n2083 8.501
R9794 AVSS_n2100 AVSS_n2082 8.501
R9795 AVSS_n2100 AVSS_n1912 8.501
R9796 AVSS_n1906 AVSS_n1539 8.501
R9797 AVSS_n1904 AVSS_n1539 8.501
R9798 AVSS_n1902 AVSS_n1539 8.501
R9799 AVSS_n1900 AVSS_n1539 8.501
R9800 AVSS_n1898 AVSS_n1539 8.501
R9801 AVSS_n1895 AVSS_n1539 8.501
R9802 AVSS_n1893 AVSS_n1539 8.501
R9803 AVSS_n1891 AVSS_n1539 8.501
R9804 AVSS_n1888 AVSS_n1539 8.501
R9805 AVSS_n1884 AVSS_n1539 8.501
R9806 AVSS_n1882 AVSS_n1539 8.501
R9807 AVSS_n2548 AVSS_n1539 8.501
R9808 AVSS_n1878 AVSS_n1539 8.501
R9809 AVSS_n1876 AVSS_n1539 8.501
R9810 AVSS_n1874 AVSS_n1539 8.501
R9811 AVSS_n1870 AVSS_n1539 8.501
R9812 AVSS_n1868 AVSS_n1539 8.501
R9813 AVSS_n1866 AVSS_n1539 8.501
R9814 AVSS_n1864 AVSS_n1539 8.501
R9815 AVSS_n1862 AVSS_n1539 8.501
R9816 AVSS_n1859 AVSS_n1539 8.501
R9817 AVSS_n1857 AVSS_n1539 8.501
R9818 AVSS_n1853 AVSS_n1539 8.501
R9819 AVSS_n1851 AVSS_n1539 8.501
R9820 AVSS_n1848 AVSS_n1539 8.501
R9821 AVSS_n1846 AVSS_n1539 8.501
R9822 AVSS_n1842 AVSS_n1539 8.501
R9823 AVSS_n1840 AVSS_n1539 8.501
R9824 AVSS_n1837 AVSS_n1539 8.501
R9825 AVSS_n1833 AVSS_n1539 8.501
R9826 AVSS_n1830 AVSS_n1539 8.501
R9827 AVSS_n1828 AVSS_n1539 8.501
R9828 AVSS_n1826 AVSS_n1539 8.501
R9829 AVSS_n1824 AVSS_n1539 8.501
R9830 AVSS_n1822 AVSS_n1539 8.501
R9831 AVSS_n1816 AVSS_n1539 8.501
R9832 AVSS_n1814 AVSS_n1539 8.501
R9833 AVSS_n1812 AVSS_n1539 8.501
R9834 AVSS_n1809 AVSS_n1539 8.501
R9835 AVSS_n1807 AVSS_n1539 8.501
R9836 AVSS_n1805 AVSS_n1539 8.501
R9837 AVSS_n1803 AVSS_n1539 8.501
R9838 AVSS_n1799 AVSS_n1539 8.501
R9839 AVSS_n1797 AVSS_n1539 8.501
R9840 AVSS_n1795 AVSS_n1539 8.501
R9841 AVSS_n1793 AVSS_n1539 8.501
R9842 AVSS_n1791 AVSS_n1539 8.501
R9843 AVSS_n1789 AVSS_n1539 8.501
R9844 AVSS_n1787 AVSS_n1539 8.501
R9845 AVSS_n1785 AVSS_n1539 8.501
R9846 AVSS_n1783 AVSS_n1539 8.501
R9847 AVSS_n1780 AVSS_n1539 8.501
R9848 AVSS_n1778 AVSS_n1539 8.501
R9849 AVSS_n1776 AVSS_n1539 8.501
R9850 AVSS_n1774 AVSS_n1539 8.501
R9851 AVSS_n1770 AVSS_n1539 8.501
R9852 AVSS_n1768 AVSS_n1539 8.501
R9853 AVSS_n1765 AVSS_n1539 8.501
R9854 AVSS_n1761 AVSS_n1539 8.501
R9855 AVSS_n1759 AVSS_n1539 8.501
R9856 AVSS_n1757 AVSS_n1539 8.501
R9857 AVSS_n1755 AVSS_n1539 8.501
R9858 AVSS_n1752 AVSS_n1539 8.501
R9859 AVSS_n1750 AVSS_n1539 8.501
R9860 AVSS_n1748 AVSS_n1539 8.501
R9861 AVSS_n1746 AVSS_n1539 8.501
R9862 AVSS_n1744 AVSS_n1539 8.501
R9863 AVSS_n1742 AVSS_n1539 8.501
R9864 AVSS_n1740 AVSS_n1539 8.501
R9865 AVSS_n1738 AVSS_n1539 8.501
R9866 AVSS_n1736 AVSS_n1539 8.501
R9867 AVSS_n1732 AVSS_n1539 8.501
R9868 AVSS_n1730 AVSS_n1539 8.501
R9869 AVSS_n1728 AVSS_n1539 8.501
R9870 AVSS_n1726 AVSS_n1539 8.501
R9871 AVSS_n1724 AVSS_n1539 8.501
R9872 AVSS_n1722 AVSS_n1539 8.501
R9873 AVSS_n1720 AVSS_n1539 8.501
R9874 AVSS_n1718 AVSS_n1539 8.501
R9875 AVSS_n1716 AVSS_n1539 8.501
R9876 AVSS_n1714 AVSS_n1539 8.501
R9877 AVSS_n1712 AVSS_n1539 8.501
R9878 AVSS_n1710 AVSS_n1539 8.501
R9879 AVSS_n1708 AVSS_n1539 8.501
R9880 AVSS_n1706 AVSS_n1539 8.501
R9881 AVSS_n1703 AVSS_n1539 8.501
R9882 AVSS_n1701 AVSS_n1539 8.501
R9883 AVSS_n1699 AVSS_n1539 8.501
R9884 AVSS_n1697 AVSS_n1539 8.501
R9885 AVSS_n1695 AVSS_n1539 8.501
R9886 AVSS_n1693 AVSS_n1539 8.501
R9887 AVSS_n1691 AVSS_n1539 8.501
R9888 AVSS_n1687 AVSS_n1539 8.501
R9889 AVSS_n1685 AVSS_n1539 8.501
R9890 AVSS_n1683 AVSS_n1539 8.501
R9891 AVSS_n1681 AVSS_n1539 8.501
R9892 AVSS_n1679 AVSS_n1539 8.501
R9893 AVSS_n1676 AVSS_n1539 8.501
R9894 AVSS_n1674 AVSS_n1539 8.501
R9895 AVSS_n1672 AVSS_n1539 8.501
R9896 AVSS_n1670 AVSS_n1539 8.501
R9897 AVSS_n1528 AVSS_n1527 8.501
R9898 AVSS_n1528 AVSS_n1525 8.501
R9899 AVSS_n1528 AVSS_n1526 8.501
R9900 AVSS_n1543 AVSS_n1528 8.501
R9901 AVSS_n1507 AVSS_n1492 8.501
R9902 AVSS_n1507 AVSS_n1449 8.501
R9903 AVSS_n1507 AVSS_n1493 8.501
R9904 AVSS_n1507 AVSS_n1494 8.501
R9905 AVSS_n1507 AVSS_n1495 8.501
R9906 AVSS_n1507 AVSS_n1496 8.501
R9907 AVSS_n1507 AVSS_n1506 8.501
R9908 AVSS_n1507 AVSS_n1505 8.501
R9909 AVSS_n1507 AVSS_n1497 8.501
R9910 AVSS_n1507 AVSS_n1504 8.501
R9911 AVSS_n1507 AVSS_n1503 8.501
R9912 AVSS_n1507 AVSS_n1502 8.501
R9913 AVSS_n1507 AVSS_n1501 8.501
R9914 AVSS_n1507 AVSS_n1498 8.501
R9915 AVSS_n1507 AVSS_n1499 8.501
R9916 AVSS_n2393 AVSS_n1507 8.501
R9917 AVSS_n1028 AVSS_n1003 8.501
R9918 AVSS_n1051 AVSS_n1003 8.501
R9919 AVSS_n1025 AVSS_n1003 8.501
R9920 AVSS_n1023 AVSS_n1003 8.501
R9921 AVSS_n1020 AVSS_n1003 8.501
R9922 AVSS_n1016 AVSS_n1003 8.501
R9923 AVSS_n1014 AVSS_n1003 8.501
R9924 AVSS_n999 AVSS_n953 8.501
R9925 AVSS_n999 AVSS_n954 8.501
R9926 AVSS_n999 AVSS_n955 8.501
R9927 AVSS_n999 AVSS_n956 8.501
R9928 AVSS_n999 AVSS_n957 8.501
R9929 AVSS_n999 AVSS_n958 8.501
R9930 AVSS_n999 AVSS_n959 8.501
R9931 AVSS_n999 AVSS_n998 8.501
R9932 AVSS_n999 AVSS_n997 8.501
R9933 AVSS_n999 AVSS_n996 8.501
R9934 AVSS_n999 AVSS_n995 8.501
R9935 AVSS_n999 AVSS_n994 8.501
R9936 AVSS_n999 AVSS_n993 8.501
R9937 AVSS_n999 AVSS_n992 8.501
R9938 AVSS_n999 AVSS_n960 8.501
R9939 AVSS_n999 AVSS_n991 8.501
R9940 AVSS_n999 AVSS_n961 8.501
R9941 AVSS_n999 AVSS_n990 8.501
R9942 AVSS_n999 AVSS_n962 8.501
R9943 AVSS_n999 AVSS_n989 8.501
R9944 AVSS_n999 AVSS_n963 8.501
R9945 AVSS_n999 AVSS_n988 8.501
R9946 AVSS_n999 AVSS_n987 8.501
R9947 AVSS_n2302 AVSS_n999 8.501
R9948 AVSS_n999 AVSS_n986 8.501
R9949 AVSS_n999 AVSS_n965 8.501
R9950 AVSS_n999 AVSS_n985 8.501
R9951 AVSS_n999 AVSS_n966 8.501
R9952 AVSS_n999 AVSS_n984 8.501
R9953 AVSS_n999 AVSS_n967 8.501
R9954 AVSS_n999 AVSS_n983 8.501
R9955 AVSS_n999 AVSS_n968 8.501
R9956 AVSS_n999 AVSS_n982 8.501
R9957 AVSS_n999 AVSS_n969 8.501
R9958 AVSS_n999 AVSS_n981 8.501
R9959 AVSS_n999 AVSS_n970 8.501
R9960 AVSS_n999 AVSS_n980 8.501
R9961 AVSS_n999 AVSS_n971 8.501
R9962 AVSS_n999 AVSS_n979 8.501
R9963 AVSS_n999 AVSS_n972 8.501
R9964 AVSS_n999 AVSS_n978 8.501
R9965 AVSS_n999 AVSS_n973 8.501
R9966 AVSS_n999 AVSS_n977 8.501
R9967 AVSS_n999 AVSS_n974 8.501
R9968 AVSS_n999 AVSS_n976 8.501
R9969 AVSS_n999 AVSS_n975 8.501
R9970 AVSS_n999 AVSS_n839 8.501
R9971 AVSS_n2101 AVSS_n1911 8.501
R9972 AVSS_n2045 AVSS_n1911 8.501
R9973 AVSS_n2043 AVSS_n1911 8.501
R9974 AVSS_n2041 AVSS_n1911 8.501
R9975 AVSS_n2034 AVSS_n1911 8.501
R9976 AVSS_n2032 AVSS_n1911 8.501
R9977 AVSS_n2030 AVSS_n1911 8.501
R9978 AVSS_n2028 AVSS_n1911 8.501
R9979 AVSS_n2026 AVSS_n1911 8.501
R9980 AVSS_n2126 AVSS_n1911 8.501
R9981 AVSS_n2022 AVSS_n1911 8.501
R9982 AVSS_n2020 AVSS_n1911 8.501
R9983 AVSS_n2014 AVSS_n1911 8.501
R9984 AVSS_n2011 AVSS_n1911 8.501
R9985 AVSS_n2009 AVSS_n1911 8.501
R9986 AVSS_n2007 AVSS_n1911 8.501
R9987 AVSS_n2003 AVSS_n1911 8.501
R9988 AVSS_n2001 AVSS_n1911 8.501
R9989 AVSS_n1999 AVSS_n1911 8.501
R9990 AVSS_n1997 AVSS_n1911 8.501
R9991 AVSS_n1995 AVSS_n1911 8.501
R9992 AVSS_n1993 AVSS_n1911 8.501
R9993 AVSS_n1990 AVSS_n1911 8.501
R9994 AVSS_n1986 AVSS_n1911 8.501
R9995 AVSS_n1984 AVSS_n1911 8.501
R9996 AVSS_n1982 AVSS_n1911 8.501
R9997 AVSS_n1980 AVSS_n1911 8.501
R9998 AVSS_n1978 AVSS_n1911 8.501
R9999 AVSS_n1976 AVSS_n1911 8.501
R10000 AVSS_n1973 AVSS_n1911 8.501
R10001 AVSS_n1971 AVSS_n1911 8.501
R10002 AVSS_n1967 AVSS_n1911 8.501
R10003 AVSS_n1965 AVSS_n1911 8.501
R10004 AVSS_n1963 AVSS_n1911 8.501
R10005 AVSS_n1961 AVSS_n1911 8.501
R10006 AVSS_n1959 AVSS_n1911 8.501
R10007 AVSS_n2546 AVSS_n1908 8.501
R10008 AVSS_n2546 AVSS_n2545 8.501
R10009 AVSS_n2546 AVSS_n2445 8.501
R10010 AVSS_n2546 AVSS_n2446 8.501
R10011 AVSS_n2546 AVSS_n2447 8.501
R10012 AVSS_n2546 AVSS_n2544 8.501
R10013 AVSS_n2546 AVSS_n2543 8.501
R10014 AVSS_n2546 AVSS_n2542 8.501
R10015 AVSS_n2546 AVSS_n2448 8.501
R10016 AVSS_n2546 AVSS_n2449 8.501
R10017 AVSS_n2547 AVSS_n2546 8.501
R10018 AVSS_n2546 AVSS_n2540 8.501
R10019 AVSS_n2546 AVSS_n2539 8.501
R10020 AVSS_n2546 AVSS_n2538 8.501
R10021 AVSS_n2546 AVSS_n2450 8.501
R10022 AVSS_n2546 AVSS_n2451 8.501
R10023 AVSS_n2546 AVSS_n2452 8.501
R10024 AVSS_n2546 AVSS_n2453 8.501
R10025 AVSS_n2546 AVSS_n2537 8.501
R10026 AVSS_n2546 AVSS_n2536 8.501
R10027 AVSS_n2546 AVSS_n2454 8.501
R10028 AVSS_n2546 AVSS_n2455 8.501
R10029 AVSS_n2546 AVSS_n2456 8.501
R10030 AVSS_n2546 AVSS_n2535 8.501
R10031 AVSS_n2546 AVSS_n2534 8.501
R10032 AVSS_n2546 AVSS_n2457 8.501
R10033 AVSS_n2546 AVSS_n2458 8.501
R10034 AVSS_n2546 AVSS_n2533 8.501
R10035 AVSS_n2546 AVSS_n2459 8.501
R10036 AVSS_n2546 AVSS_n2532 8.501
R10037 AVSS_n2546 AVSS_n2531 8.501
R10038 AVSS_n2546 AVSS_n2530 8.501
R10039 AVSS_n2546 AVSS_n2529 8.501
R10040 AVSS_n2546 AVSS_n2460 8.501
R10041 AVSS_n2546 AVSS_n2528 8.501
R10042 AVSS_n2546 AVSS_n2462 8.501
R10043 AVSS_n2546 AVSS_n2527 8.501
R10044 AVSS_n2546 AVSS_n2526 8.501
R10045 AVSS_n2546 AVSS_n2525 8.501
R10046 AVSS_n2546 AVSS_n2524 8.501
R10047 AVSS_n2546 AVSS_n2463 8.501
R10048 AVSS_n2546 AVSS_n2523 8.501
R10049 AVSS_n2546 AVSS_n2464 8.501
R10050 AVSS_n2546 AVSS_n2465 8.501
R10051 AVSS_n2546 AVSS_n2466 8.501
R10052 AVSS_n2546 AVSS_n2522 8.501
R10053 AVSS_n2546 AVSS_n2467 8.501
R10054 AVSS_n2546 AVSS_n2468 8.501
R10055 AVSS_n2546 AVSS_n2469 8.501
R10056 AVSS_n2546 AVSS_n2470 8.501
R10057 AVSS_n2546 AVSS_n2521 8.501
R10058 AVSS_n2546 AVSS_n2520 8.501
R10059 AVSS_n2546 AVSS_n2519 8.501
R10060 AVSS_n2546 AVSS_n2471 8.501
R10061 AVSS_n2546 AVSS_n2518 8.501
R10062 AVSS_n2546 AVSS_n2472 8.501
R10063 AVSS_n2546 AVSS_n2517 8.501
R10064 AVSS_n2546 AVSS_n2516 8.501
R10065 AVSS_n2546 AVSS_n2473 8.501
R10066 AVSS_n2546 AVSS_n2474 8.501
R10067 AVSS_n2546 AVSS_n2475 8.501
R10068 AVSS_n2546 AVSS_n2476 8.501
R10069 AVSS_n2546 AVSS_n2515 8.501
R10070 AVSS_n2546 AVSS_n2514 8.501
R10071 AVSS_n2546 AVSS_n2513 8.501
R10072 AVSS_n2546 AVSS_n2512 8.501
R10073 AVSS_n2546 AVSS_n2477 8.501
R10074 AVSS_n2546 AVSS_n2511 8.501
R10075 AVSS_n2546 AVSS_n2510 8.501
R10076 AVSS_n2546 AVSS_n2478 8.501
R10077 AVSS_n2546 AVSS_n2479 8.501
R10078 AVSS_n2546 AVSS_n2480 8.501
R10079 AVSS_n2546 AVSS_n2481 8.501
R10080 AVSS_n2546 AVSS_n2482 8.501
R10081 AVSS_n2546 AVSS_n2483 8.501
R10082 AVSS_n2546 AVSS_n2484 8.501
R10083 AVSS_n2546 AVSS_n2485 8.501
R10084 AVSS_n2546 AVSS_n2509 8.501
R10085 AVSS_n2546 AVSS_n2486 8.501
R10086 AVSS_n2546 AVSS_n2508 8.501
R10087 AVSS_n2546 AVSS_n2487 8.501
R10088 AVSS_n2546 AVSS_n2488 8.501
R10089 AVSS_n2546 AVSS_n2507 8.501
R10090 AVSS_n2546 AVSS_n2506 8.501
R10091 AVSS_n2546 AVSS_n2505 8.501
R10092 AVSS_n2546 AVSS_n2504 8.501
R10093 AVSS_n2546 AVSS_n2503 8.501
R10094 AVSS_n2546 AVSS_n2502 8.501
R10095 AVSS_n2546 AVSS_n2501 8.501
R10096 AVSS_n2546 AVSS_n2489 8.501
R10097 AVSS_n2546 AVSS_n2490 8.501
R10098 AVSS_n2546 AVSS_n2491 8.501
R10099 AVSS_n2546 AVSS_n2492 8.501
R10100 AVSS_n2546 AVSS_n2493 8.501
R10101 AVSS_n2546 AVSS_n2494 8.501
R10102 AVSS_n2546 AVSS_n2495 8.501
R10103 AVSS_n2546 AVSS_n2500 8.501
R10104 AVSS_n2546 AVSS_n2499 8.501
R10105 AVSS_n2546 AVSS_n2498 8.501
R10106 AVSS_n2546 AVSS_n2497 8.501
R10107 AVSS_n2546 AVSS_n2496 8.501
R10108 AVSS_n2546 AVSS_n1536 8.501
R10109 AVSS_n1533 AVSS_n1532 8.501
R10110 AVSS_n1533 AVSS_n1529 8.501
R10111 AVSS_n1533 AVSS_n1531 8.501
R10112 AVSS_n1542 AVSS_n1533 8.501
R10113 AVSS_n2771 AVSS_n1427 8.501
R10114 AVSS_n2771 AVSS_n1428 8.501
R10115 AVSS_n2771 AVSS_n1429 8.501
R10116 AVSS_n2771 AVSS_n1430 8.501
R10117 AVSS_n2771 AVSS_n1431 8.501
R10118 AVSS_n2771 AVSS_n1432 8.501
R10119 AVSS_n2771 AVSS_n1446 8.501
R10120 AVSS_n2771 AVSS_n1445 8.501
R10121 AVSS_n2771 AVSS_n1444 8.501
R10122 AVSS_n2771 AVSS_n1442 8.501
R10123 AVSS_n2771 AVSS_n1441 8.501
R10124 AVSS_n2771 AVSS_n1440 8.501
R10125 AVSS_n2771 AVSS_n1439 8.501
R10126 AVSS_n2771 AVSS_n1433 8.501
R10127 AVSS_n2771 AVSS_n1438 8.501
R10128 AVSS_n2771 AVSS_n1434 8.501
R10129 AVSS_n2771 AVSS_n1437 8.501
R10130 AVSS_n2771 AVSS_n1436 8.501
R10131 AVSS_n2810 AVSS_n1038 8.501
R10132 AVSS_n1050 AVSS_n1037 8.501
R10133 AVSS_n1037 AVSS_n1036 8.501
R10134 AVSS_n1037 AVSS_n1035 8.501
R10135 AVSS_n1037 AVSS_n1031 8.501
R10136 AVSS_n1037 AVSS_n1032 8.501
R10137 AVSS_n1037 AVSS_n1000 8.501
R10138 AVSS_n2818 AVSS_n773 8.501
R10139 AVSS_n2818 AVSS_n774 8.501
R10140 AVSS_n2818 AVSS_n775 8.501
R10141 AVSS_n2818 AVSS_n776 8.501
R10142 AVSS_n2818 AVSS_n777 8.501
R10143 AVSS_n2818 AVSS_n779 8.501
R10144 AVSS_n2818 AVSS_n780 8.501
R10145 AVSS_n2818 AVSS_n781 8.501
R10146 AVSS_n2818 AVSS_n783 8.501
R10147 AVSS_n2818 AVSS_n784 8.501
R10148 AVSS_n2818 AVSS_n785 8.501
R10149 AVSS_n2818 AVSS_n786 8.501
R10150 AVSS_n2818 AVSS_n787 8.501
R10151 AVSS_n2818 AVSS_n788 8.501
R10152 AVSS_n2818 AVSS_n789 8.501
R10153 AVSS_n2818 AVSS_n791 8.501
R10154 AVSS_n2818 AVSS_n792 8.501
R10155 AVSS_n2818 AVSS_n794 8.501
R10156 AVSS_n2818 AVSS_n796 8.501
R10157 AVSS_n2818 AVSS_n797 8.501
R10158 AVSS_n2818 AVSS_n798 8.501
R10159 AVSS_n2818 AVSS_n799 8.501
R10160 AVSS_n2818 AVSS_n800 8.501
R10161 AVSS_n2818 AVSS_n801 8.501
R10162 AVSS_n2818 AVSS_n802 8.501
R10163 AVSS_n2818 AVSS_n804 8.501
R10164 AVSS_n2818 AVSS_n806 8.501
R10165 AVSS_n2818 AVSS_n807 8.501
R10166 AVSS_n2818 AVSS_n808 8.501
R10167 AVSS_n2818 AVSS_n810 8.501
R10168 AVSS_n2818 AVSS_n811 8.501
R10169 AVSS_n2818 AVSS_n812 8.501
R10170 AVSS_n2818 AVSS_n814 8.501
R10171 AVSS_n2818 AVSS_n816 8.501
R10172 AVSS_n2818 AVSS_n817 8.501
R10173 AVSS_n2818 AVSS_n818 8.501
R10174 AVSS_n2818 AVSS_n820 8.501
R10175 AVSS_n2818 AVSS_n822 8.501
R10176 AVSS_n2818 AVSS_n823 8.501
R10177 AVSS_n2818 AVSS_n824 8.501
R10178 AVSS_n2818 AVSS_n826 8.501
R10179 AVSS_n2818 AVSS_n827 8.501
R10180 AVSS_n2818 AVSS_n828 8.501
R10181 AVSS_n2818 AVSS_n830 8.501
R10182 AVSS_n2818 AVSS_n831 8.501
R10183 AVSS_n2818 AVSS_n832 8.501
R10184 AVSS_n2818 AVSS_n833 8.501
R10185 AVSS_n2818 AVSS_n834 8.501
R10186 AVSS_n1202 AVSS_n1157 8.501
R10187 AVSS_n1085 AVSS_n1062 8.501
R10188 AVSS_n1228 AVSS_n1227 8.501
R10189 AVSS_n2796 AVSS_n1103 8.501
R10190 AVSS_n1416 AVSS_n1278 8.501
R10191 AVSS_n1325 AVSS_n1324 8.501
R10192 AVSS_n1359 AVSS_n1358 8.501
R10193 AVSS_n1367 AVSS_n1366 8.501
R10194 AVSS_n1136 AVSS_n1074 8.501
R10195 AVSS_n2237 AVSS_n2236 8.501
R10196 AVSS_n1413 AVSS_n1412 8.501
R10197 AVSS_n1392 AVSS_n1391 8.501
R10198 AVSS_n2777 AVSS_n1285 8.501
R10199 AVSS_n2426 AVSS_n2425 8.501
R10200 AVSS_n490 AVSS_n485 8.501
R10201 AVSS_n490 AVSS_n486 8.501
R10202 AVSS_n490 AVSS_n488 8.501
R10203 AVSS_n355 AVSS_n354 8.501
R10204 AVSS_n412 AVSS_n396 8.501
R10205 AVSS_n435 AVSS_n372 8.501
R10206 AVSS_n572 AVSS_n566 8.501
R10207 AVSS_n559 AVSS_n558 8.501
R10208 AVSS_n617 AVSS_n616 8.501
R10209 AVSS_n589 AVSS_n571 8.501
R10210 AVSS_n574 AVSS_n573 8.501
R10211 AVSS_n353 AVSS_n312 8.501
R10212 AVSS_n424 AVSS_n423 8.501
R10213 AVSS_n429 AVSS_n428 8.501
R10214 AVSS_n411 AVSS_n402 8.501
R10215 AVSS_n407 AVSS_n406 8.501
R10216 AVSS_n641 AVSS_n640 8.501
R10217 AVSS_n728 AVSS_n497 8.501
R10218 AVSS_n587 AVSS_n586 8.501
R10219 AVSS_n607 AVSS_n567 8.501
R10220 AVSS_n504 AVSS_n464 8.501
R10221 AVSS_n632 AVSS_n631 8.501
R10222 AVSS_n3493 AVSS_n21 8.5005
R10223 AVSS_n3419 AVSS_n3418 8.5005
R10224 AVSS_n3231 AVSS_n201 8.5005
R10225 AVSS_n3222 AVSS_n246 8.5005
R10226 AVSS_n3222 AVSS_n306 8.5005
R10227 AVSS_n306 AVSS_n222 8.5005
R10228 AVSS_n306 AVSS_n225 8.5005
R10229 AVSS_n306 AVSS_n223 8.5005
R10230 AVSS_n674 AVSS_n673 8.5005
R10231 AVSS_n674 AVSS_n307 8.5005
R10232 AVSS_n711 AVSS_n308 8.5005
R10233 AVSS_n711 AVSS_n710 8.5005
R10234 AVSS_n671 AVSS_n670 8.5005
R10235 AVSS_n671 AVSS_n668 8.5005
R10236 AVSS_n670 AVSS_n667 8.5005
R10237 AVSS_n668 AVSS_n667 8.5005
R10238 AVSS_n716 AVSS_n715 8.5005
R10239 AVSS_n715 AVSS_n714 8.5005
R10240 AVSS_n716 AVSS_n704 8.5005
R10241 AVSS_n714 AVSS_n704 8.5005
R10242 AVSS_n2763 AVSS_n2038 8.5005
R10243 AVSS_n2765 AVSS_n1890 8.5005
R10244 AVSS_n2768 AVSS_n2767 8.5005
R10245 AVSS_n2769 AVSS_n1473 8.5005
R10246 AVSS_n2813 AVSS_n1022 8.5005
R10247 AVSS_n2815 AVSS_n870 8.5005
R10248 AVSS_n2815 AVSS_n836 8.5005
R10249 AVSS_n837 AVSS_n836 8.5005
R10250 AVSS_n840 AVSS_n836 8.5005
R10251 AVSS_n838 AVSS_n836 8.5005
R10252 AVSS_n999 AVSS_n836 8.5005
R10253 AVSS_n1163 AVSS_n1159 8.5005
R10254 AVSS_n1163 AVSS_n1157 8.5005
R10255 AVSS_n1163 AVSS_n1155 8.5005
R10256 AVSS_n1163 AVSS_n1153 8.5005
R10257 AVSS_n1163 AVSS_n1152 8.5005
R10258 AVSS_n1196 AVSS_n1163 8.5005
R10259 AVSS_n1194 AVSS_n1163 8.5005
R10260 AVSS_n1189 AVSS_n1163 8.5005
R10261 AVSS_n1179 AVSS_n1163 8.5005
R10262 AVSS_n1176 AVSS_n1163 8.5005
R10263 AVSS_n1173 AVSS_n1163 8.5005
R10264 AVSS_n1382 AVSS_n1376 8.5005
R10265 AVSS_n1187 AVSS_n1159 8.5005
R10266 AVSS_n1187 AVSS_n1157 8.5005
R10267 AVSS_n1187 AVSS_n1155 8.5005
R10268 AVSS_n1187 AVSS_n1153 8.5005
R10269 AVSS_n1187 AVSS_n1152 8.5005
R10270 AVSS_n1187 AVSS_n1151 8.5005
R10271 AVSS_n1187 AVSS_n1150 8.5005
R10272 AVSS_n1190 AVSS_n1187 8.5005
R10273 AVSS_n1187 AVSS_n1180 8.5005
R10274 AVSS_n1187 AVSS_n1177 8.5005
R10275 AVSS_n1187 AVSS_n1175 8.5005
R10276 AVSS_n1187 AVSS_n1172 8.5005
R10277 AVSS_n1187 AVSS_n1169 8.5005
R10278 AVSS_n1187 AVSS_n1167 8.5005
R10279 AVSS_n2793 AVSS_n1159 8.5005
R10280 AVSS_n2793 AVSS_n1157 8.5005
R10281 AVSS_n2793 AVSS_n1155 8.5005
R10282 AVSS_n2793 AVSS_n1153 8.5005
R10283 AVSS_n2793 AVSS_n1152 8.5005
R10284 AVSS_n2793 AVSS_n1151 8.5005
R10285 AVSS_n2793 AVSS_n1150 8.5005
R10286 AVSS_n2793 AVSS_n1149 8.5005
R10287 AVSS_n2793 AVSS_n1148 8.5005
R10288 AVSS_n2793 AVSS_n1147 8.5005
R10289 AVSS_n2793 AVSS_n1146 8.5005
R10290 AVSS_n2793 AVSS_n1145 8.5005
R10291 AVSS_n2793 AVSS_n1144 8.5005
R10292 AVSS_n2793 AVSS_n1143 8.5005
R10293 AVSS_n2793 AVSS_n1142 8.5005
R10294 AVSS_n2797 AVSS_n2793 8.5005
R10295 AVSS_n2794 AVSS_n2793 8.5005
R10296 AVSS_n2793 AVSS_n1141 8.5005
R10297 AVSS_n2793 AVSS_n1139 8.5005
R10298 AVSS_n2793 AVSS_n1100 8.5005
R10299 AVSS_n2793 AVSS_n1137 8.5005
R10300 AVSS_n2793 AVSS_n1135 8.5005
R10301 AVSS_n2793 AVSS_n1133 8.5005
R10302 AVSS_n2793 AVSS_n1131 8.5005
R10303 AVSS_n2793 AVSS_n1129 8.5005
R10304 AVSS_n2793 AVSS_n1127 8.5005
R10305 AVSS_n2793 AVSS_n1124 8.5005
R10306 AVSS_n2793 AVSS_n1122 8.5005
R10307 AVSS_n2793 AVSS_n1121 8.5005
R10308 AVSS_n2793 AVSS_n1120 8.5005
R10309 AVSS_n2793 AVSS_n1119 8.5005
R10310 AVSS_n2793 AVSS_n1118 8.5005
R10311 AVSS_n1418 AVSS_n1352 8.5005
R10312 AVSS_n2779 AVSS_n1283 8.5005
R10313 AVSS_n2777 AVSS_n1283 8.5005
R10314 AVSS_n1318 AVSS_n1283 8.5005
R10315 AVSS_n1286 AVSS_n1283 8.5005
R10316 AVSS_n1316 AVSS_n1283 8.5005
R10317 AVSS_n1287 AVSS_n1283 8.5005
R10318 AVSS_n1313 AVSS_n1283 8.5005
R10319 AVSS_n1288 AVSS_n1283 8.5005
R10320 AVSS_n1310 AVSS_n1283 8.5005
R10321 AVSS_n1289 AVSS_n1283 8.5005
R10322 AVSS_n1307 AVSS_n1283 8.5005
R10323 AVSS_n1291 AVSS_n1283 8.5005
R10324 AVSS_n1301 AVSS_n1283 8.5005
R10325 AVSS_n1292 AVSS_n1283 8.5005
R10326 AVSS_n1300 AVSS_n1283 8.5005
R10327 AVSS_n1293 AVSS_n1283 8.5005
R10328 AVSS_n1299 AVSS_n1283 8.5005
R10329 AVSS_n1294 AVSS_n1283 8.5005
R10330 AVSS_n1297 AVSS_n1283 8.5005
R10331 AVSS_n1295 AVSS_n1283 8.5005
R10332 AVSS_n1296 AVSS_n1283 8.5005
R10333 AVSS_n729 AVSS_n457 8.5005
R10334 AVSS_n727 AVSS_n457 8.5005
R10335 AVSS_n508 AVSS_n457 8.5005
R10336 AVSS_n496 AVSS_n457 8.5005
R10337 AVSS_n505 AVSS_n457 8.5005
R10338 AVSS_n501 AVSS_n457 8.5005
R10339 AVSS_n484 AVSS_n457 8.5005
R10340 AVSS_n609 AVSS_n522 8.5005
R10341 AVSS_n609 AVSS_n521 8.5005
R10342 AVSS_n609 AVSS_n520 8.5005
R10343 AVSS_n570 AVSS_n524 8.5005
R10344 AVSS_n570 AVSS_n523 8.5005
R10345 AVSS_n446 AVSS_n434 8.5005
R10346 AVSS_n764 AVSS_n351 8.5005
R10347 AVSS_n353 AVSS_n351 8.5005
R10348 AVSS_n351 AVSS_n333 8.5005
R10349 AVSS_n351 AVSS_n313 8.5005
R10350 AVSS_n351 AVSS_n331 8.5005
R10351 AVSS_n351 AVSS_n315 8.5005
R10352 AVSS_n351 AVSS_n330 8.5005
R10353 AVSS_n351 AVSS_n347 8.5005
R10354 AVSS_n351 AVSS_n343 8.5005
R10355 AVSS_n351 AVSS_n338 8.5005
R10356 AVSS_n401 AVSS_n399 8.5005
R10357 AVSS_n585 AVSS_n526 8.5005
R10358 AVSS_n585 AVSS_n525 8.5005
R10359 AVSS_n585 AVSS_n524 8.5005
R10360 AVSS_n1231 AVSS_n1212 8.48362
R10361 AVSS_n1203 AVSS_n1101 8.48362
R10362 AVSS_n2786 AVSS_n1243 8.48362
R10363 AVSS_n1341 AVSS_n1322 8.48362
R10364 AVSS_n1182 AVSS_n1072 8.48362
R10365 AVSS_n622 AVSS_n546 8.48362
R10366 AVSS_n643 AVSS_n515 8.48362
R10367 AVSS_n511 AVSS_n495 8.48362
R10368 AVSS_n494 AVSS_n463 8.48362
R10369 AVSS_n666 AVSS_n660 8.48284
R10370 AVSS_n2423 AVSS_n2422 8.47161
R10371 AVSS_n2421 AVSS_n2420 8.47111
R10372 AVSS_n741 AVSS_n461 8.46995
R10373 AVSS_n744 AVSS_n458 8.46995
R10374 AVSS_n745 AVSS_n457 8.46995
R10375 AVSS_n743 AVSS_n459 8.44274
R10376 AVSS_n2230 AVSS_n1069 8.37259
R10377 AVSS_n1087 AVSS_n1085 8.37259
R10378 AVSS_n2804 AVSS_n2803 8.37259
R10379 AVSS_n2234 AVSS_n1083 8.37259
R10380 AVSS_n2235 AVSS_n2234 8.37259
R10381 AVSS_n1118 AVSS_n1079 8.37259
R10382 AVSS_n1221 AVSS_n1220 8.37259
R10383 AVSS_n1220 AVSS_n1119 8.37259
R10384 AVSS_n1130 AVSS_n1108 8.37259
R10385 AVSS_n1135 AVSS_n1134 8.37259
R10386 AVSS_n1363 AVSS_n1253 8.37259
R10387 AVSS_n1373 AVSS_n1254 8.37259
R10388 AVSS_n1361 AVSS_n1255 8.37259
R10389 AVSS_n1375 AVSS_n1374 8.37259
R10390 AVSS_n1375 AVSS_n1256 8.37259
R10391 AVSS_n1358 AVSS_n1257 8.37259
R10392 AVSS_n1384 AVSS_n1258 8.37259
R10393 AVSS_n1381 AVSS_n1259 8.37259
R10394 AVSS_n1407 AVSS_n1406 8.37259
R10395 AVSS_n1412 AVSS_n1411 8.37259
R10396 AVSS_n1337 AVSS_n1336 8.37259
R10397 AVSS_n1336 AVSS_n1300 8.37259
R10398 AVSS_n675 AVSS_n674 7.95017
R10399 AVSS_n712 AVSS_n711 7.95016
R10400 AVSS_n3233 AVSS_n192 7.91867
R10401 AVSS_n214 AVSS_n188 7.91867
R10402 AVSS_n1528 AVSS_n1488 7.91867
R10403 AVSS_n1535 AVSS_n1489 7.91867
R10404 AVSS_n199 AVSS_n192 7.91796
R10405 AVSS_n215 AVSS_n214 7.91796
R10406 AVSS_n1524 AVSS_n1489 7.91796
R10407 AVSS_n1544 AVSS_n1488 7.91796
R10408 AVSS_n3497 AVSS_n3496 7.88432
R10409 AVSS_n2760 AVSS_n2063 7.82533
R10410 AVSS_n2761 AVSS_n2760 7.70554
R10411 AVSS_n1019 AVSS_n1004 7.70193
R10412 AVSS_n1019 AVSS_n1001 7.70122
R10413 AVSS_n509 AVSS_n508 7.69774
R10414 AVSS_n728 AVSS_n727 7.69774
R10415 AVSS_n730 AVSS_n729 7.69774
R10416 AVSS_n726 AVSS_n725 7.69774
R10417 AVSS_n2227 AVSS_n2226 7.44236
R10418 AVSS_n2803 AVSS_n1073 7.44236
R10419 AVSS_n2231 AVSS_n1083 7.44236
R10420 AVSS_n2236 AVSS_n2235 7.44236
R10421 AVSS_n2236 AVSS_n1090 7.44236
R10422 AVSS_n2233 AVSS_n1082 7.44236
R10423 AVSS_n2239 AVSS_n1091 7.44236
R10424 AVSS_n1213 AVSS_n1092 7.44236
R10425 AVSS_n1170 AVSS_n1145 7.44236
R10426 AVSS_n1173 AVSS_n1146 7.44236
R10427 AVSS_n1177 AVSS_n1176 7.44236
R10428 AVSS_n1176 AVSS_n1147 7.44236
R10429 AVSS_n1180 AVSS_n1179 7.44236
R10430 AVSS_n1190 AVSS_n1189 7.44236
R10431 AVSS_n1196 AVSS_n1151 7.44236
R10432 AVSS_n1158 AVSS_n1157 7.44236
R10433 AVSS_n1251 AVSS_n1250 7.44236
R10434 AVSS_n1263 AVSS_n1262 7.44236
R10435 AVSS_n1408 AVSS_n1266 7.44236
R10436 AVSS_n1416 AVSS_n1415 7.44236
R10437 AVSS_n1307 AVSS_n1305 7.44236
R10438 AVSS_n2779 AVSS_n2778 7.44236
R10439 AVSS_n842 AVSS_n837 7.41556
R10440 AVSS_n2303 AVSS_n838 7.41556
R10441 AVSS_n999 AVSS_n835 7.41556
R10442 AVSS_n2815 AVSS_n842 7.41556
R10443 AVSS_n2303 AVSS_n840 7.41556
R10444 AVSS_n2818 AVSS_n835 7.41556
R10445 AVSS_n1021 AVSS_n1002 7.35504
R10446 AVSS_n3218 AVSS_n3217 7.13551
R10447 AVSS_n1507 AVSS_n1500 6.9598
R10448 AVSS_n1472 AVSS_n1447 6.9598
R10449 AVSS_n1472 AVSS_n1450 6.95914
R10450 AVSS_n1500 AVSS_n1491 6.95914
R10451 AVSS_n438 AVSS_n385 6.64422
R10452 AVSS_n441 AVSS_n392 6.64422
R10453 AVSS_n440 AVSS_n378 6.64422
R10454 AVSS_n348 AVSS_n317 6.64422
R10455 AVSS_n344 AVSS_n328 6.64422
R10456 AVSS_n339 AVSS_n320 6.64422
R10457 AVSS_n343 AVSS_n342 6.64422
R10458 AVSS_n327 AVSS_n326 6.64422
R10459 AVSS_n338 AVSS_n337 6.64422
R10460 AVSS_n323 AVSS_n321 6.64422
R10461 AVSS_n324 AVSS_n323 6.64422
R10462 AVSS_n337 AVSS_n325 6.64422
R10463 AVSS_n338 AVSS_n320 6.64422
R10464 AVSS_n326 AVSS_n319 6.64422
R10465 AVSS_n342 AVSS_n318 6.64422
R10466 AVSS_n343 AVSS_n328 6.64422
R10467 AVSS_n347 AVSS_n317 6.64422
R10468 AVSS_n439 AVSS_n378 6.64422
R10469 AVSS_n444 AVSS_n384 6.64422
R10470 AVSS_n437 AVSS_n392 6.64422
R10471 AVSS_n700 AVSS_n698 6.61458
R10472 AVSS_n2418 AVSS_n2408 6.61424
R10473 AVSS_n2804 AVSS_n1071 6.51213
R10474 AVSS_n1226 AVSS_n1120 6.51213
R10475 AVSS_n1133 AVSS_n1132 6.51213
R10476 AVSS_n1132 AVSS_n1105 6.51213
R10477 AVSS_n1358 AVSS_n1357 6.51213
R10478 AVSS_n1405 AVSS_n1404 6.51213
R10479 AVSS_n1397 AVSS_n1396 6.51213
R10480 AVSS_n1323 AVSS_n1292 6.51213
R10481 AVSS_n3503 AVSS_n5 6.44561
R10482 AVSS_n573 AVSS_n572 6.41487
R10483 AVSS_n575 AVSS_n564 6.41487
R10484 AVSS_n31 AVSS_n30 6.39096
R10485 AVSS_n2058 AVSS_n2056 6.39096
R10486 AVSS_n30 AVSS_n24 6.39033
R10487 AVSS_n2056 AVSS_n26 6.39033
R10488 AVSS_n675 AVSS_n672 6.33137
R10489 AVSS_n712 AVSS_n709 6.33137
R10490 AVSS_n663 AVSS_n6 6.19801
R10491 AVSS_n2550 AVSS_n1557 6.14054
R10492 AVSS_n2550 AVSS_n2549 6.14054
R10493 AVSS_n2461 AVSS_n1597 6.14054
R10494 AVSS_n226 AVSS_n222 5.9791
R10495 AVSS_n3014 AVSS_n223 5.9791
R10496 AVSS_n3222 AVSS_n226 5.9791
R10497 AVSS_n3014 AVSS_n225 5.9791
R10498 AVSS_n3358 AVSS_n136 5.911
R10499 AVSS_n3280 AVSS_n139 5.911
R10500 AVSS_n3315 AVSS_n139 5.9104
R10501 AVSS_n3368 AVSS_n136 5.9104
R10502 AVSS_n324 AVSS_n310 5.86423
R10503 AVSS_n716 AVSS_n703 5.80602
R10504 AVSS_n714 AVSS_n703 5.80602
R10505 AVSS_n400 AVSS_n385 5.77343
R10506 AVSS_n399 AVSS_n386 5.77343
R10507 AVSS_n406 AVSS_n387 5.77343
R10508 AVSS_n408 AVSS_n388 5.77343
R10509 AVSS_n405 AVSS_n389 5.77343
R10510 AVSS_n409 AVSS_n390 5.77343
R10511 AVSS_n404 AVSS_n391 5.77343
R10512 AVSS_n630 AVSS_n481 5.77343
R10513 AVSS_n502 AVSS_n492 5.77343
R10514 AVSS_n506 AVSS_n504 5.77343
R10515 AVSS_n733 AVSS_n732 5.77343
R10516 AVSS_n498 AVSS_n493 5.77343
R10517 AVSS_n1889 AVSS_n1539 5.7629
R10518 AVSS_n568 AVSS_n520 5.7584
R10519 AVSS_n2036 AVSS_n1913 5.69454
R10520 AVSS_n2036 AVSS_n1909 5.69395
R10521 AVSS_n2037 AVSS_n1911 5.66778
R10522 AVSS_n2546 AVSS_n2541 5.66778
R10523 AVSS_n1533 AVSS_n1508 5.66778
R10524 AVSS_n1037 AVSS_n1034 5.66778
R10525 AVSS_n490 AVSS_n487 5.66778
R10526 AVSS_n2818 AVSS_n2817 5.66767
R10527 AVSS_n2425 AVSS_n2422 5.66767
R10528 AVSS_n701 AVSS_n700 5.64701
R10529 AVSS_n693 AVSS_n692 5.64701
R10530 AVSS_n697 AVSS_n696 5.64701
R10531 AVSS_n657 AVSS_n656 5.64701
R10532 AVSS_n723 AVSS_n722 5.64701
R10533 AVSS_n2438 AVSS_n2218 5.64701
R10534 AVSS_n2436 AVSS_n2435 5.64701
R10535 AVSS_n2418 AVSS_n2409 5.64701
R10536 AVSS_n2430 AVSS_n2429 5.64701
R10537 AVSS_n2416 AVSS_n2415 5.64701
R10538 AVSS_n610 AVSS_n609 5.62486
R10539 AVSS_n2805 AVSS_n1070 5.61281
R10540 AVSS_n742 AVSS_n460 5.61281
R10541 AVSS_n609 AVSS_n557 5.61281
R10542 AVSS_n2811 AVSS_n2810 5.61102
R10543 AVSS_n3503 AVSS_n6 5.5928
R10544 AVSS_n2225 AVSS_n2224 5.5819
R10545 AVSS_n2233 AVSS_n2232 5.5819
R10546 AVSS_n1215 AVSS_n1080 5.5819
R10547 AVSS_n1175 AVSS_n1174 5.5819
R10548 AVSS_n1178 AVSS_n1148 5.5819
R10549 AVSS_n1194 AVSS_n1193 5.5819
R10550 AVSS_n1156 AVSS_n1155 5.5819
R10551 AVSS_n1370 AVSS_n1249 5.5819
R10552 AVSS_n1390 AVSS_n1265 5.5819
R10553 AVSS_n1414 AVSS_n1277 5.5819
R10554 AVSS_n2775 AVSS_n2774 5.5819
R10555 AVSS_n707 AVSS_n703 5.57958
R10556 AVSS_n1302 AVSS_n1290 5.52945
R10557 AVSS_n1304 AVSS_n1302 5.52945
R10558 AVSS_n3173 AVSS_n226 5.51195
R10559 AVSS_n3173 AVSS_n3014 5.51195
R10560 AVSS_n3505 AVSS_n3504 5.38883
R10561 AVSS_n705 AVSS_n654 5.37239
R10562 AVSS_n665 AVSS_n664 5.36993
R10563 AVSS_n443 AVSS_n438 5.17939
R10564 AVSS_n755 AVSS_n392 5.17939
R10565 AVSS_n755 AVSS_n384 5.17939
R10566 AVSS_n755 AVSS_n378 5.17939
R10567 AVSS_n765 AVSS_n317 5.17939
R10568 AVSS_n765 AVSS_n328 5.17939
R10569 AVSS_n765 AVSS_n320 5.17939
R10570 AVSS_n342 AVSS_n311 5.17939
R10571 AVSS_n326 AVSS_n311 5.17939
R10572 AVSS_n337 AVSS_n311 5.17939
R10573 AVSS_n323 AVSS_n311 5.17939
R10574 AVSS_n999 AVSS_n964 5.16471
R10575 AVSS_n869 AVSS_n837 5.16471
R10576 AVSS_n869 AVSS_n840 5.16416
R10577 AVSS_n964 AVSS_n838 5.16416
R10578 AVSS_n573 AVSS_n525 5.13199
R10579 AVSS_n575 AVSS_n526 5.13199
R10580 AVSS_n606 AVSS_n527 5.13199
R10581 AVSS_n607 AVSS_n606 5.13199
R10582 AVSS_n576 AVSS_n528 5.13199
R10583 AVSS_n588 AVSS_n576 5.13199
R10584 AVSS_n589 AVSS_n529 5.13199
R10585 AVSS_n590 AVSS_n589 5.13199
R10586 AVSS_n604 AVSS_n530 5.13199
R10587 AVSS_n604 AVSS_n603 5.13199
R10588 AVSS_n591 AVSS_n531 5.13199
R10589 AVSS_n592 AVSS_n591 5.13199
R10590 AVSS_n490 AVSS_n466 5.13199
R10591 AVSS_n491 AVSS_n484 5.13199
R10592 AVSS_n501 AVSS_n465 5.13199
R10593 AVSS_n505 AVSS_n492 5.13199
R10594 AVSS_n504 AVSS_n496 5.13199
R10595 AVSS_n706 AVSS_n682 4.95659
R10596 AVSS_n2099 AVSS_n1910 4.88692
R10597 AVSS_n2304 AVSS_n842 4.79372
R10598 AVSS_n2304 AVSS_n2303 4.79372
R10599 AVSS_n849 AVSS_n835 4.79372
R10600 AVSS_n499 AVSS_n498 4.77801
R10601 AVSS_n569 AVSS_n522 4.77762
R10602 AVSS_n350 AVSS_n332 4.77762
R10603 AVSS_n349 AVSS_n316 4.77762
R10604 AVSS_n345 AVSS_n329 4.77762
R10605 AVSS_n341 AVSS_n318 4.77762
R10606 AVSS_n340 AVSS_n339 4.77762
R10607 AVSS_n336 AVSS_n325 4.77762
R10608 AVSS_n583 AVSS_n522 4.77762
R10609 AVSS_n582 AVSS_n521 4.77762
R10610 AVSS_n336 AVSS_n321 4.77762
R10611 AVSS_n340 AVSS_n319 4.77762
R10612 AVSS_n341 AVSS_n327 4.77762
R10613 AVSS_n345 AVSS_n344 4.77762
R10614 AVSS_n349 AVSS_n348 4.77762
R10615 AVSS_n350 AVSS_n314 4.77762
R10616 AVSS_n582 AVSS_n520 4.77762
R10617 AVSS_n569 AVSS_n521 4.77762
R10618 AVSS_n583 AVSS_n523 4.77762
R10619 AVSS_n2760 AVSS_n2759 4.731
R10620 AVSS_n3503 AVSS_n3502 4.731
R10621 AVSS_n1557 AVSS_n1537 4.72191
R10622 AVSS_n2549 AVSS_n1538 4.72191
R10623 AVSS_n2546 AVSS_n2461 4.72191
R10624 AVSS_n2765 AVSS_n1557 4.72191
R10625 AVSS_n2549 AVSS_n1540 4.72191
R10626 AVSS_n2461 AVSS_n1539 4.72191
R10627 AVSS_n1085 AVSS_n1084 4.65166
R10628 AVSS_n1219 AVSS_n1117 4.65166
R10629 AVSS_n1222 AVSS_n1121 4.65166
R10630 AVSS_n1131 AVSS_n1130 4.65166
R10631 AVSS_n1134 AVSS_n1109 4.65166
R10632 AVSS_n1112 AVSS_n1111 4.65166
R10633 AVSS_n1138 AVSS_n1104 4.65166
R10634 AVSS_n1376 AVSS_n1246 4.65166
R10635 AVSS_n1366 AVSS_n1247 4.65166
R10636 AVSS_n1369 AVSS_n1248 4.65166
R10637 AVSS_n1365 AVSS_n1249 4.65166
R10638 AVSS_n1371 AVSS_n1250 4.65166
R10639 AVSS_n1384 AVSS_n1383 4.65166
R10640 AVSS_n1399 AVSS_n1398 4.65166
R10641 AVSS_n1338 AVSS_n1301 4.65166
R10642 AVSS_n245 AVSS_n225 4.42474
R10643 AVSS_n3217 AVSS_n2994 4.42474
R10644 AVSS_n245 AVSS_n222 4.42423
R10645 AVSS_n2994 AVSS_n223 4.42423
R10646 AVSS_n673 AVSS_n672 4.30244
R10647 AVSS_n709 AVSS_n308 4.30244
R10648 AVSS_n710 AVSS_n709 4.30244
R10649 AVSS_n672 AVSS_n307 4.30244
R10650 AVSS_n490 AVSS_n489 4.251
R10651 AVSS_n2812 AVSS_n2811 4.25034
R10652 AVSS_n661 AVSS_n653 4.23215
R10653 AVSS_n676 AVSS_n671 4.23159
R10654 AVSS_n677 AVSS_n667 4.23159
R10655 AVSS_n678 AVSS_n659 4.23159
R10656 AVSS_n715 AVSS_n713 4.23159
R10657 AVSS_n708 AVSS_n704 4.23159
R10658 AVSS_n680 AVSS_n679 4.23159
R10659 AVSS_n2129 AVSS_n1915 4.22172
R10660 AVSS_n2129 AVSS_n2128 4.22172
R10661 AVSS_n2064 AVSS_n1931 4.22172
R10662 AVSS_n565 AVSS_n556 4.17435
R10663 AVSS_n731 AVSS_n648 4.17435
R10664 AVSS_n1240 AVSS_n1239 4.16348
R10665 AVSS_n669 AVSS_n659 4.09343
R10666 AVSS_n3370 AVSS_n140 3.9723
R10667 AVSS_n3370 AVSS_n3369 3.9723
R10668 AVSS_n3327 AVSS_n178 3.9723
R10669 AVSS_n3431 AVSS_n3430 3.9255
R10670 AVSS_n3500 AVSS_n3499 3.87089
R10671 AVSS_n3501 AVSS_n7 3.87086
R10672 AVSS_n346 AVSS_n311 3.81903
R10673 AVSS_n1890 AVSS_n1889 3.74742
R10674 AVSS_n2223 AVSS_n2222 3.72143
R10675 AVSS_n2239 AVSS_n2238 3.72143
R10676 AVSS_n1210 AVSS_n1091 3.72143
R10677 AVSS_n1214 AVSS_n1081 3.72143
R10678 AVSS_n1216 AVSS_n1092 3.72143
R10679 AVSS_n1218 AVSS_n1080 3.72143
R10680 AVSS_n1217 AVSS_n1093 3.72143
R10681 AVSS_n1219 AVSS_n1093 3.72143
R10682 AVSS_n1172 AVSS_n1171 3.72143
R10683 AVSS_n1171 AVSS_n1170 3.72143
R10684 AVSS_n1189 AVSS_n1188 3.72143
R10685 AVSS_n1188 AVSS_n1149 3.72143
R10686 AVSS_n1154 AVSS_n1153 3.72143
R10687 AVSS_n1364 AVSS_n1248 3.72143
R10688 AVSS_n1351 AVSS_n1264 3.72143
R10689 AVSS_n2785 AVSS_n2784 3.72143
R10690 AVSS_n679 AVSS_n666 3.72088
R10691 AVSS_n676 AVSS_n675 3.72063
R10692 AVSS_n677 AVSS_n676 3.72063
R10693 AVSS_n679 AVSS_n678 3.72063
R10694 AVSS_n666 AVSS_n665 3.72063
R10695 AVSS_n713 AVSS_n712 3.72063
R10696 AVSS_n713 AVSS_n708 3.72063
R10697 AVSS_n708 AVSS_n707 3.72063
R10698 AVSS_n707 AVSS_n706 3.72063
R10699 AVSS_n706 AVSS_n705 3.72063
R10700 AVSS_n678 AVSS_n677 3.72038
R10701 AVSS_n2103 AVSS_n2047 3.70373
R10702 AVSS_n1887 AVSS_n1540 3.6968
R10703 AVSS_n1887 AVSS_n1537 3.69634
R10704 AVSS_n3219 AVSS_n3218 3.56825
R10705 AVSS_n3118 AVSS_n133 3.5505
R10706 AVSS_n3422 AVSS_n3421 3.5505
R10707 AVSS_n3427 AVSS_n130 3.5505
R10708 AVSS_n3430 AVSS_n3429 3.5505
R10709 AVSS_n2362 AVSS_n2361 3.5505
R10710 AVSS_n2401 AVSS_n2400 3.5505
R10711 AVSS_n2615 AVSS_n2194 3.5505
R10712 AVSS_n2756 AVSS_n2755 3.5505
R10713 AVSS_n2193 AVSS_n2192 3.5505
R10714 AVSS_n2060 AVSS_n11 3.38297
R10715 AVSS_n2060 AVSS_n2059 3.38297
R10716 AVSS_n2050 AVSS_n14 3.38297
R10717 AVSS_n1306 AVSS_n1290 3.35808
R10718 AVSS_n1419 AVSS_n1418 3.31195
R10719 AVSS_n454 AVSS_n453 3.3033
R10720 AVSS_n3218 AVSS_n306 3.2895
R10721 AVSS_n441 AVSS_n410 3.20768
R10722 AVSS_n403 AVSS_n393 3.20768
R10723 AVSS_n413 AVSS_n394 3.20768
R10724 AVSS_n412 AVSS_n411 3.20768
R10725 AVSS_n753 AVSS_n395 3.20768
R10726 AVSS_n754 AVSS_n398 3.20768
R10727 AVSS_n552 AVSS_n551 3.20768
R10728 AVSS_n635 AVSS_n634 3.20768
R10729 AVSS_n3425 AVSS_n3424 3.0005
R10730 AVSS_n127 AVSS_n126 2.89291
R10731 AVSS_n3478 AVSS_n3477 2.89291
R10732 AVSS_n3450 AVSS_n38 2.89291
R10733 AVSS_n127 AVSS_n125 2.89291
R10734 AVSS_n94 AVSS_n9 2.89291
R10735 AVSS_n1889 AVSS_n1538 2.88183
R10736 AVSS_n2060 AVSS_n32 2.85033
R10737 AVSS_n32 AVSS_n12 2.83383
R10738 AVSS_n3492 AVSS_n3491 2.83383
R10739 AVSS_n3490 AVSS_n13 2.83383
R10740 AVSS_n3489 AVSS_n23 2.83383
R10741 AVSS_n3488 AVSS_n14 2.83383
R10742 AVSS_n3487 AVSS_n22 2.83383
R10743 AVSS_n3486 AVSS_n15 2.83383
R10744 AVSS_n3484 AVSS_n20 2.83383
R10745 AVSS_n3483 AVSS_n16 2.83383
R10746 AVSS_n3482 AVSS_n19 2.83383
R10747 AVSS_n3481 AVSS_n17 2.83383
R10748 AVSS_n3479 AVSS_n3478 2.83383
R10749 AVSS_n3475 AVSS_n33 2.83383
R10750 AVSS_n119 AVSS_n39 2.83383
R10751 AVSS_n120 AVSS_n85 2.83383
R10752 AVSS_n121 AVSS_n40 2.83383
R10753 AVSS_n122 AVSS_n84 2.83383
R10754 AVSS_n123 AVSS_n41 2.83383
R10755 AVSS_n124 AVSS_n83 2.83383
R10756 AVSS_n128 AVSS_n127 2.83383
R10757 AVSS_n3470 AVSS_n3469 2.83383
R10758 AVSS_n3468 AVSS_n43 2.83383
R10759 AVSS_n3467 AVSS_n81 2.83383
R10760 AVSS_n3466 AVSS_n44 2.83383
R10761 AVSS_n3465 AVSS_n80 2.83383
R10762 AVSS_n3464 AVSS_n45 2.83383
R10763 AVSS_n3463 AVSS_n79 2.83383
R10764 AVSS_n3462 AVSS_n46 2.83383
R10765 AVSS_n3461 AVSS_n78 2.83383
R10766 AVSS_n3460 AVSS_n47 2.83383
R10767 AVSS_n3459 AVSS_n76 2.83383
R10768 AVSS_n3458 AVSS_n48 2.83383
R10769 AVSS_n3457 AVSS_n75 2.83383
R10770 AVSS_n3456 AVSS_n49 2.83383
R10771 AVSS_n3455 AVSS_n73 2.83383
R10772 AVSS_n3454 AVSS_n50 2.83383
R10773 AVSS_n3453 AVSS_n72 2.83383
R10774 AVSS_n3452 AVSS_n51 2.83383
R10775 AVSS_n3451 AVSS_n3450 2.83383
R10776 AVSS_n3448 AVSS_n52 2.83383
R10777 AVSS_n3447 AVSS_n70 2.83383
R10778 AVSS_n3446 AVSS_n53 2.83383
R10779 AVSS_n3445 AVSS_n69 2.83383
R10780 AVSS_n3444 AVSS_n54 2.83383
R10781 AVSS_n3443 AVSS_n68 2.83383
R10782 AVSS_n3442 AVSS_n55 2.83383
R10783 AVSS_n3441 AVSS_n67 2.83383
R10784 AVSS_n3440 AVSS_n56 2.83383
R10785 AVSS_n3439 AVSS_n66 2.83383
R10786 AVSS_n3438 AVSS_n57 2.83383
R10787 AVSS_n3437 AVSS_n64 2.83383
R10788 AVSS_n3436 AVSS_n58 2.83383
R10789 AVSS_n3435 AVSS_n63 2.83383
R10790 AVSS_n3434 AVSS_n59 2.83383
R10791 AVSS_n3433 AVSS_n61 2.83383
R10792 AVSS_n3316 AVSS_n141 2.83383
R10793 AVSS_n3417 AVSS_n3416 2.83383
R10794 AVSS_n3415 AVSS_n142 2.83383
R10795 AVSS_n3414 AVSS_n3279 2.83383
R10796 AVSS_n3413 AVSS_n143 2.83383
R10797 AVSS_n3412 AVSS_n3278 2.83383
R10798 AVSS_n3411 AVSS_n144 2.83383
R10799 AVSS_n3410 AVSS_n3277 2.83383
R10800 AVSS_n3409 AVSS_n145 2.83383
R10801 AVSS_n3408 AVSS_n3276 2.83383
R10802 AVSS_n3407 AVSS_n146 2.83383
R10803 AVSS_n3406 AVSS_n3275 2.83383
R10804 AVSS_n3405 AVSS_n147 2.83383
R10805 AVSS_n3404 AVSS_n3274 2.83383
R10806 AVSS_n3403 AVSS_n148 2.83383
R10807 AVSS_n3402 AVSS_n3273 2.83383
R10808 AVSS_n3401 AVSS_n149 2.83383
R10809 AVSS_n3400 AVSS_n3272 2.83383
R10810 AVSS_n3399 AVSS_n150 2.83383
R10811 AVSS_n3398 AVSS_n3271 2.83383
R10812 AVSS_n3397 AVSS_n151 2.83383
R10813 AVSS_n3396 AVSS_n3270 2.83383
R10814 AVSS_n3395 AVSS_n152 2.83383
R10815 AVSS_n3394 AVSS_n3269 2.83383
R10816 AVSS_n3393 AVSS_n153 2.83383
R10817 AVSS_n3392 AVSS_n3268 2.83383
R10818 AVSS_n3391 AVSS_n154 2.83383
R10819 AVSS_n3390 AVSS_n3267 2.83383
R10820 AVSS_n3389 AVSS_n155 2.83383
R10821 AVSS_n3388 AVSS_n3266 2.83383
R10822 AVSS_n3387 AVSS_n156 2.83383
R10823 AVSS_n3386 AVSS_n3265 2.83383
R10824 AVSS_n3385 AVSS_n157 2.83383
R10825 AVSS_n3384 AVSS_n3264 2.83383
R10826 AVSS_n3383 AVSS_n158 2.83383
R10827 AVSS_n3382 AVSS_n3263 2.83383
R10828 AVSS_n3381 AVSS_n159 2.83383
R10829 AVSS_n3380 AVSS_n3262 2.83383
R10830 AVSS_n3379 AVSS_n160 2.83383
R10831 AVSS_n3378 AVSS_n3261 2.83383
R10832 AVSS_n3377 AVSS_n161 2.83383
R10833 AVSS_n3376 AVSS_n3260 2.83383
R10834 AVSS_n3375 AVSS_n162 2.83383
R10835 AVSS_n3374 AVSS_n3259 2.83383
R10836 AVSS_n3373 AVSS_n163 2.83383
R10837 AVSS_n3372 AVSS_n3258 2.83383
R10838 AVSS_n3371 AVSS_n3370 2.83383
R10839 AVSS_n3325 AVSS_n3257 2.83383
R10840 AVSS_n3324 AVSS_n164 2.83383
R10841 AVSS_n3323 AVSS_n3256 2.83383
R10842 AVSS_n3322 AVSS_n165 2.83383
R10843 AVSS_n3321 AVSS_n3255 2.83383
R10844 AVSS_n3320 AVSS_n166 2.83383
R10845 AVSS_n3319 AVSS_n3254 2.83383
R10846 AVSS_n3318 AVSS_n167 2.83383
R10847 AVSS_n3317 AVSS_n3253 2.83383
R10848 AVSS_n168 AVSS_n134 2.83383
R10849 AVSS_n3252 AVSS_n135 2.83383
R10850 AVSS_n185 AVSS_n169 2.83383
R10851 AVSS_n3251 AVSS_n3250 2.83383
R10852 AVSS_n3249 AVSS_n170 2.83383
R10853 AVSS_n3248 AVSS_n184 2.83383
R10854 AVSS_n3247 AVSS_n171 2.83383
R10855 AVSS_n3246 AVSS_n183 2.83383
R10856 AVSS_n3245 AVSS_n172 2.83383
R10857 AVSS_n3244 AVSS_n182 2.83383
R10858 AVSS_n3243 AVSS_n173 2.83383
R10859 AVSS_n3242 AVSS_n181 2.83383
R10860 AVSS_n3241 AVSS_n174 2.83383
R10861 AVSS_n3240 AVSS_n180 2.83383
R10862 AVSS_n3239 AVSS_n175 2.83383
R10863 AVSS_n3238 AVSS_n179 2.83383
R10864 AVSS_n3237 AVSS_n176 2.83383
R10865 AVSS_n3235 AVSS_n3234 2.83383
R10866 AVSS_n3232 AVSS_n186 2.83383
R10867 AVSS_n217 AVSS_n193 2.83383
R10868 AVSS_n218 AVSS_n198 2.83383
R10869 AVSS_n219 AVSS_n203 2.83383
R10870 AVSS_n3230 AVSS_n3229 2.83383
R10871 AVSS_n3228 AVSS_n204 2.83383
R10872 AVSS_n3227 AVSS_n197 2.83383
R10873 AVSS_n3226 AVSS_n195 2.83383
R10874 AVSS_n3224 AVSS_n3223 2.83383
R10875 AVSS_n3221 AVSS_n220 2.83383
R10876 AVSS_n3015 AVSS_n227 2.83383
R10877 AVSS_n3016 AVSS_n2913 2.83383
R10878 AVSS_n3017 AVSS_n228 2.83383
R10879 AVSS_n3018 AVSS_n2912 2.83383
R10880 AVSS_n3019 AVSS_n229 2.83383
R10881 AVSS_n3020 AVSS_n2911 2.83383
R10882 AVSS_n3021 AVSS_n230 2.83383
R10883 AVSS_n3022 AVSS_n2910 2.83383
R10884 AVSS_n3023 AVSS_n231 2.83383
R10885 AVSS_n3024 AVSS_n2908 2.83383
R10886 AVSS_n3025 AVSS_n232 2.83383
R10887 AVSS_n3026 AVSS_n2907 2.83383
R10888 AVSS_n3027 AVSS_n233 2.83383
R10889 AVSS_n3028 AVSS_n2906 2.83383
R10890 AVSS_n3029 AVSS_n234 2.83383
R10891 AVSS_n3030 AVSS_n2905 2.83383
R10892 AVSS_n3031 AVSS_n235 2.83383
R10893 AVSS_n3032 AVSS_n2904 2.83383
R10894 AVSS_n3033 AVSS_n236 2.83383
R10895 AVSS_n3034 AVSS_n2903 2.83383
R10896 AVSS_n3035 AVSS_n237 2.83383
R10897 AVSS_n3036 AVSS_n2901 2.83383
R10898 AVSS_n3037 AVSS_n238 2.83383
R10899 AVSS_n3038 AVSS_n2900 2.83383
R10900 AVSS_n3039 AVSS_n239 2.83383
R10901 AVSS_n3040 AVSS_n2899 2.83383
R10902 AVSS_n3041 AVSS_n240 2.83383
R10903 AVSS_n3042 AVSS_n2898 2.83383
R10904 AVSS_n3043 AVSS_n241 2.83383
R10905 AVSS_n3044 AVSS_n2897 2.83383
R10906 AVSS_n3045 AVSS_n242 2.83383
R10907 AVSS_n3046 AVSS_n2895 2.83383
R10908 AVSS_n3047 AVSS_n243 2.83383
R10909 AVSS_n3048 AVSS_n2894 2.83383
R10910 AVSS_n3049 AVSS_n244 2.83383
R10911 AVSS_n3050 AVSS_n2893 2.83383
R10912 AVSS_n3052 AVSS_n247 2.83383
R10913 AVSS_n3053 AVSS_n2891 2.83383
R10914 AVSS_n3054 AVSS_n248 2.83383
R10915 AVSS_n3055 AVSS_n2890 2.83383
R10916 AVSS_n3056 AVSS_n249 2.83383
R10917 AVSS_n3057 AVSS_n2889 2.83383
R10918 AVSS_n3058 AVSS_n250 2.83383
R10919 AVSS_n3059 AVSS_n2888 2.83383
R10920 AVSS_n3060 AVSS_n251 2.83383
R10921 AVSS_n3061 AVSS_n2886 2.83383
R10922 AVSS_n3062 AVSS_n252 2.83383
R10923 AVSS_n3063 AVSS_n2885 2.83383
R10924 AVSS_n3064 AVSS_n253 2.83383
R10925 AVSS_n3065 AVSS_n2884 2.83383
R10926 AVSS_n3066 AVSS_n254 2.83383
R10927 AVSS_n3067 AVSS_n2883 2.83383
R10928 AVSS_n3068 AVSS_n255 2.83383
R10929 AVSS_n3069 AVSS_n2882 2.83383
R10930 AVSS_n3070 AVSS_n256 2.83383
R10931 AVSS_n3071 AVSS_n2881 2.83383
R10932 AVSS_n3072 AVSS_n257 2.83383
R10933 AVSS_n3073 AVSS_n2879 2.83383
R10934 AVSS_n3074 AVSS_n258 2.83383
R10935 AVSS_n3075 AVSS_n2878 2.83383
R10936 AVSS_n3076 AVSS_n259 2.83383
R10937 AVSS_n3077 AVSS_n2877 2.83383
R10938 AVSS_n3078 AVSS_n260 2.83383
R10939 AVSS_n3079 AVSS_n2876 2.83383
R10940 AVSS_n3080 AVSS_n261 2.83383
R10941 AVSS_n3081 AVSS_n2875 2.83383
R10942 AVSS_n3082 AVSS_n262 2.83383
R10943 AVSS_n3083 AVSS_n2873 2.83383
R10944 AVSS_n3084 AVSS_n263 2.83383
R10945 AVSS_n3085 AVSS_n2872 2.83383
R10946 AVSS_n3086 AVSS_n264 2.83383
R10947 AVSS_n3087 AVSS_n2871 2.83383
R10948 AVSS_n3088 AVSS_n265 2.83383
R10949 AVSS_n3089 AVSS_n2870 2.83383
R10950 AVSS_n3090 AVSS_n266 2.83383
R10951 AVSS_n3091 AVSS_n2869 2.83383
R10952 AVSS_n3092 AVSS_n267 2.83383
R10953 AVSS_n3093 AVSS_n2868 2.83383
R10954 AVSS_n3094 AVSS_n268 2.83383
R10955 AVSS_n3095 AVSS_n2866 2.83383
R10956 AVSS_n3096 AVSS_n269 2.83383
R10957 AVSS_n3097 AVSS_n2865 2.83383
R10958 AVSS_n3098 AVSS_n270 2.83383
R10959 AVSS_n3099 AVSS_n2864 2.83383
R10960 AVSS_n3100 AVSS_n271 2.83383
R10961 AVSS_n3101 AVSS_n2863 2.83383
R10962 AVSS_n3102 AVSS_n272 2.83383
R10963 AVSS_n3103 AVSS_n2862 2.83383
R10964 AVSS_n3104 AVSS_n273 2.83383
R10965 AVSS_n3105 AVSS_n2860 2.83383
R10966 AVSS_n3106 AVSS_n274 2.83383
R10967 AVSS_n3107 AVSS_n2859 2.83383
R10968 AVSS_n3108 AVSS_n275 2.83383
R10969 AVSS_n3109 AVSS_n2858 2.83383
R10970 AVSS_n3110 AVSS_n276 2.83383
R10971 AVSS_n3111 AVSS_n2857 2.83383
R10972 AVSS_n3112 AVSS_n277 2.83383
R10973 AVSS_n3113 AVSS_n2856 2.83383
R10974 AVSS_n3114 AVSS_n278 2.83383
R10975 AVSS_n3115 AVSS_n2855 2.83383
R10976 AVSS_n3116 AVSS_n279 2.83383
R10977 AVSS_n3117 AVSS_n2853 2.83383
R10978 AVSS_n3119 AVSS_n280 2.83383
R10979 AVSS_n3120 AVSS_n2852 2.83383
R10980 AVSS_n3121 AVSS_n281 2.83383
R10981 AVSS_n3122 AVSS_n2851 2.83383
R10982 AVSS_n3123 AVSS_n282 2.83383
R10983 AVSS_n3124 AVSS_n2850 2.83383
R10984 AVSS_n3125 AVSS_n283 2.83383
R10985 AVSS_n3126 AVSS_n2849 2.83383
R10986 AVSS_n3127 AVSS_n284 2.83383
R10987 AVSS_n3128 AVSS_n2847 2.83383
R10988 AVSS_n3129 AVSS_n285 2.83383
R10989 AVSS_n3130 AVSS_n2846 2.83383
R10990 AVSS_n3131 AVSS_n286 2.83383
R10991 AVSS_n3132 AVSS_n2845 2.83383
R10992 AVSS_n3173 AVSS_n3172 2.83383
R10993 AVSS_n3171 AVSS_n2843 2.83383
R10994 AVSS_n3170 AVSS_n287 2.83383
R10995 AVSS_n3169 AVSS_n2842 2.83383
R10996 AVSS_n3168 AVSS_n288 2.83383
R10997 AVSS_n3167 AVSS_n2841 2.83383
R10998 AVSS_n3166 AVSS_n289 2.83383
R10999 AVSS_n3165 AVSS_n2840 2.83383
R11000 AVSS_n3164 AVSS_n290 2.83383
R11001 AVSS_n3163 AVSS_n2839 2.83383
R11002 AVSS_n3162 AVSS_n291 2.83383
R11003 AVSS_n3161 AVSS_n2837 2.83383
R11004 AVSS_n3160 AVSS_n292 2.83383
R11005 AVSS_n3159 AVSS_n2836 2.83383
R11006 AVSS_n3158 AVSS_n293 2.83383
R11007 AVSS_n3157 AVSS_n2835 2.83383
R11008 AVSS_n3156 AVSS_n294 2.83383
R11009 AVSS_n3155 AVSS_n2834 2.83383
R11010 AVSS_n3154 AVSS_n295 2.83383
R11011 AVSS_n3153 AVSS_n2833 2.83383
R11012 AVSS_n3152 AVSS_n296 2.83383
R11013 AVSS_n3151 AVSS_n2832 2.83383
R11014 AVSS_n3150 AVSS_n297 2.83383
R11015 AVSS_n3149 AVSS_n2830 2.83383
R11016 AVSS_n3148 AVSS_n298 2.83383
R11017 AVSS_n3147 AVSS_n2829 2.83383
R11018 AVSS_n3146 AVSS_n299 2.83383
R11019 AVSS_n3145 AVSS_n2828 2.83383
R11020 AVSS_n3144 AVSS_n300 2.83383
R11021 AVSS_n3143 AVSS_n2827 2.83383
R11022 AVSS_n3142 AVSS_n301 2.83383
R11023 AVSS_n3141 AVSS_n2826 2.83383
R11024 AVSS_n3140 AVSS_n302 2.83383
R11025 AVSS_n3139 AVSS_n2824 2.83383
R11026 AVSS_n3138 AVSS_n303 2.83383
R11027 AVSS_n3137 AVSS_n2823 2.83383
R11028 AVSS_n3136 AVSS_n304 2.83383
R11029 AVSS_n3135 AVSS_n2822 2.83383
R11030 AVSS_n3134 AVSS_n305 2.83383
R11031 AVSS_n3133 AVSS_n2821 2.83383
R11032 AVSS_n2104 AVSS_n1916 2.83383
R11033 AVSS_n2105 AVSS_n2046 2.83383
R11034 AVSS_n2106 AVSS_n1917 2.83383
R11035 AVSS_n2107 AVSS_n2044 2.83383
R11036 AVSS_n2108 AVSS_n1918 2.83383
R11037 AVSS_n2109 AVSS_n2042 2.83383
R11038 AVSS_n2110 AVSS_n1919 2.83383
R11039 AVSS_n2111 AVSS_n2040 2.83383
R11040 AVSS_n2112 AVSS_n1920 2.83383
R11041 AVSS_n2114 AVSS_n2035 2.83383
R11042 AVSS_n2115 AVSS_n1921 2.83383
R11043 AVSS_n2116 AVSS_n2033 2.83383
R11044 AVSS_n2117 AVSS_n1922 2.83383
R11045 AVSS_n2118 AVSS_n2031 2.83383
R11046 AVSS_n2119 AVSS_n1923 2.83383
R11047 AVSS_n2120 AVSS_n2029 2.83383
R11048 AVSS_n2121 AVSS_n1924 2.83383
R11049 AVSS_n2122 AVSS_n2027 2.83383
R11050 AVSS_n2123 AVSS_n1925 2.83383
R11051 AVSS_n2124 AVSS_n2025 2.83383
R11052 AVSS_n2125 AVSS_n1926 2.83383
R11053 AVSS_n2130 AVSS_n2129 2.83383
R11054 AVSS_n2131 AVSS_n1927 2.83383
R11055 AVSS_n2132 AVSS_n2023 2.83383
R11056 AVSS_n2133 AVSS_n1928 2.83383
R11057 AVSS_n2134 AVSS_n2021 2.83383
R11058 AVSS_n2135 AVSS_n1929 2.83383
R11059 AVSS_n2136 AVSS_n2018 2.83383
R11060 AVSS_n2137 AVSS_n1930 2.83383
R11061 AVSS_n2138 AVSS_n2016 2.83383
R11062 AVSS_n2191 AVSS_n1931 2.83383
R11063 AVSS_n2190 AVSS_n2013 2.83383
R11064 AVSS_n2189 AVSS_n1932 2.83383
R11065 AVSS_n2188 AVSS_n2010 2.83383
R11066 AVSS_n2187 AVSS_n1933 2.83383
R11067 AVSS_n2186 AVSS_n2008 2.83383
R11068 AVSS_n2185 AVSS_n1934 2.83383
R11069 AVSS_n2184 AVSS_n2006 2.83383
R11070 AVSS_n2183 AVSS_n1935 2.83383
R11071 AVSS_n2182 AVSS_n2004 2.83383
R11072 AVSS_n2181 AVSS_n1936 2.83383
R11073 AVSS_n2180 AVSS_n2002 2.83383
R11074 AVSS_n2179 AVSS_n1937 2.83383
R11075 AVSS_n2178 AVSS_n2000 2.83383
R11076 AVSS_n2177 AVSS_n1938 2.83383
R11077 AVSS_n2176 AVSS_n1998 2.83383
R11078 AVSS_n2175 AVSS_n1939 2.83383
R11079 AVSS_n2174 AVSS_n1996 2.83383
R11080 AVSS_n2173 AVSS_n1940 2.83383
R11081 AVSS_n2172 AVSS_n1994 2.83383
R11082 AVSS_n2171 AVSS_n1941 2.83383
R11083 AVSS_n2170 AVSS_n1991 2.83383
R11084 AVSS_n2169 AVSS_n1942 2.83383
R11085 AVSS_n2168 AVSS_n1989 2.83383
R11086 AVSS_n2167 AVSS_n1943 2.83383
R11087 AVSS_n2166 AVSS_n1987 2.83383
R11088 AVSS_n2165 AVSS_n1944 2.83383
R11089 AVSS_n2164 AVSS_n1985 2.83383
R11090 AVSS_n2163 AVSS_n1945 2.83383
R11091 AVSS_n2162 AVSS_n1983 2.83383
R11092 AVSS_n2161 AVSS_n1946 2.83383
R11093 AVSS_n2160 AVSS_n1981 2.83383
R11094 AVSS_n2159 AVSS_n1947 2.83383
R11095 AVSS_n2158 AVSS_n1979 2.83383
R11096 AVSS_n2157 AVSS_n1948 2.83383
R11097 AVSS_n2156 AVSS_n1977 2.83383
R11098 AVSS_n2155 AVSS_n1949 2.83383
R11099 AVSS_n2154 AVSS_n1974 2.83383
R11100 AVSS_n2153 AVSS_n1950 2.83383
R11101 AVSS_n2152 AVSS_n1972 2.83383
R11102 AVSS_n2151 AVSS_n1951 2.83383
R11103 AVSS_n2150 AVSS_n1970 2.83383
R11104 AVSS_n2149 AVSS_n1952 2.83383
R11105 AVSS_n2148 AVSS_n1968 2.83383
R11106 AVSS_n2147 AVSS_n1953 2.83383
R11107 AVSS_n2146 AVSS_n1966 2.83383
R11108 AVSS_n2145 AVSS_n1954 2.83383
R11109 AVSS_n2144 AVSS_n1964 2.83383
R11110 AVSS_n2143 AVSS_n1955 2.83383
R11111 AVSS_n2142 AVSS_n1962 2.83383
R11112 AVSS_n2141 AVSS_n1956 2.83383
R11113 AVSS_n2140 AVSS_n1960 2.83383
R11114 AVSS_n2139 AVSS_n1957 2.83383
R11115 AVSS_n2195 AVSS_n1558 2.83383
R11116 AVSS_n2196 AVSS_n1907 2.83383
R11117 AVSS_n2197 AVSS_n1559 2.83383
R11118 AVSS_n2198 AVSS_n1905 2.83383
R11119 AVSS_n2199 AVSS_n1560 2.83383
R11120 AVSS_n2200 AVSS_n1903 2.83383
R11121 AVSS_n2201 AVSS_n1561 2.83383
R11122 AVSS_n2202 AVSS_n1901 2.83383
R11123 AVSS_n2203 AVSS_n1562 2.83383
R11124 AVSS_n2204 AVSS_n1899 2.83383
R11125 AVSS_n2205 AVSS_n1563 2.83383
R11126 AVSS_n2206 AVSS_n1896 2.83383
R11127 AVSS_n2207 AVSS_n1564 2.83383
R11128 AVSS_n2208 AVSS_n1894 2.83383
R11129 AVSS_n2209 AVSS_n1565 2.83383
R11130 AVSS_n2210 AVSS_n1892 2.83383
R11131 AVSS_n2211 AVSS_n1566 2.83383
R11132 AVSS_n2213 AVSS_n1886 2.83383
R11133 AVSS_n2214 AVSS_n1567 2.83383
R11134 AVSS_n2215 AVSS_n1885 2.83383
R11135 AVSS_n2216 AVSS_n1568 2.83383
R11136 AVSS_n2217 AVSS_n1883 2.83383
R11137 AVSS_n2551 AVSS_n2550 2.83383
R11138 AVSS_n2552 AVSS_n1881 2.83383
R11139 AVSS_n2553 AVSS_n1569 2.83383
R11140 AVSS_n2554 AVSS_n1879 2.83383
R11141 AVSS_n2555 AVSS_n1570 2.83383
R11142 AVSS_n2556 AVSS_n1877 2.83383
R11143 AVSS_n2557 AVSS_n1571 2.83383
R11144 AVSS_n2558 AVSS_n1875 2.83383
R11145 AVSS_n2559 AVSS_n1572 2.83383
R11146 AVSS_n2560 AVSS_n1873 2.83383
R11147 AVSS_n2561 AVSS_n1573 2.83383
R11148 AVSS_n2562 AVSS_n1871 2.83383
R11149 AVSS_n2563 AVSS_n1574 2.83383
R11150 AVSS_n2564 AVSS_n1869 2.83383
R11151 AVSS_n2565 AVSS_n1575 2.83383
R11152 AVSS_n2566 AVSS_n1867 2.83383
R11153 AVSS_n2567 AVSS_n1576 2.83383
R11154 AVSS_n2568 AVSS_n1865 2.83383
R11155 AVSS_n2569 AVSS_n1577 2.83383
R11156 AVSS_n2570 AVSS_n1863 2.83383
R11157 AVSS_n2571 AVSS_n1578 2.83383
R11158 AVSS_n2572 AVSS_n1860 2.83383
R11159 AVSS_n2573 AVSS_n1579 2.83383
R11160 AVSS_n2574 AVSS_n1858 2.83383
R11161 AVSS_n2575 AVSS_n1580 2.83383
R11162 AVSS_n2576 AVSS_n1856 2.83383
R11163 AVSS_n2577 AVSS_n1581 2.83383
R11164 AVSS_n2578 AVSS_n1854 2.83383
R11165 AVSS_n2579 AVSS_n1582 2.83383
R11166 AVSS_n2580 AVSS_n1852 2.83383
R11167 AVSS_n2581 AVSS_n1583 2.83383
R11168 AVSS_n2582 AVSS_n1849 2.83383
R11169 AVSS_n2583 AVSS_n1584 2.83383
R11170 AVSS_n2584 AVSS_n1847 2.83383
R11171 AVSS_n2585 AVSS_n1585 2.83383
R11172 AVSS_n2586 AVSS_n1845 2.83383
R11173 AVSS_n2587 AVSS_n1586 2.83383
R11174 AVSS_n2588 AVSS_n1843 2.83383
R11175 AVSS_n2589 AVSS_n1587 2.83383
R11176 AVSS_n2590 AVSS_n1841 2.83383
R11177 AVSS_n2591 AVSS_n1588 2.83383
R11178 AVSS_n2592 AVSS_n1838 2.83383
R11179 AVSS_n2593 AVSS_n1589 2.83383
R11180 AVSS_n2594 AVSS_n1836 2.83383
R11181 AVSS_n2595 AVSS_n1590 2.83383
R11182 AVSS_n2596 AVSS_n1834 2.83383
R11183 AVSS_n2597 AVSS_n1591 2.83383
R11184 AVSS_n2598 AVSS_n1831 2.83383
R11185 AVSS_n2599 AVSS_n1592 2.83383
R11186 AVSS_n2600 AVSS_n1829 2.83383
R11187 AVSS_n2601 AVSS_n1593 2.83383
R11188 AVSS_n2602 AVSS_n1827 2.83383
R11189 AVSS_n2603 AVSS_n1594 2.83383
R11190 AVSS_n2604 AVSS_n1825 2.83383
R11191 AVSS_n2605 AVSS_n1595 2.83383
R11192 AVSS_n2606 AVSS_n1823 2.83383
R11193 AVSS_n2607 AVSS_n1596 2.83383
R11194 AVSS_n2608 AVSS_n1821 2.83383
R11195 AVSS_n2609 AVSS_n1597 2.83383
R11196 AVSS_n2610 AVSS_n1819 2.83383
R11197 AVSS_n2754 AVSS_n1598 2.83383
R11198 AVSS_n2753 AVSS_n1817 2.83383
R11199 AVSS_n2752 AVSS_n1599 2.83383
R11200 AVSS_n2751 AVSS_n1815 2.83383
R11201 AVSS_n2750 AVSS_n1600 2.83383
R11202 AVSS_n2749 AVSS_n1813 2.83383
R11203 AVSS_n2748 AVSS_n1601 2.83383
R11204 AVSS_n2747 AVSS_n1810 2.83383
R11205 AVSS_n2746 AVSS_n1602 2.83383
R11206 AVSS_n2745 AVSS_n1808 2.83383
R11207 AVSS_n2744 AVSS_n1603 2.83383
R11208 AVSS_n2743 AVSS_n1806 2.83383
R11209 AVSS_n2742 AVSS_n1604 2.83383
R11210 AVSS_n2741 AVSS_n1804 2.83383
R11211 AVSS_n2740 AVSS_n1605 2.83383
R11212 AVSS_n2739 AVSS_n1802 2.83383
R11213 AVSS_n2738 AVSS_n1606 2.83383
R11214 AVSS_n2737 AVSS_n1800 2.83383
R11215 AVSS_n2736 AVSS_n1607 2.83383
R11216 AVSS_n2735 AVSS_n1798 2.83383
R11217 AVSS_n2734 AVSS_n1608 2.83383
R11218 AVSS_n2733 AVSS_n1796 2.83383
R11219 AVSS_n2732 AVSS_n1609 2.83383
R11220 AVSS_n2731 AVSS_n1794 2.83383
R11221 AVSS_n2730 AVSS_n1610 2.83383
R11222 AVSS_n2729 AVSS_n1792 2.83383
R11223 AVSS_n2728 AVSS_n1611 2.83383
R11224 AVSS_n2727 AVSS_n1790 2.83383
R11225 AVSS_n2726 AVSS_n1612 2.83383
R11226 AVSS_n2725 AVSS_n1788 2.83383
R11227 AVSS_n2724 AVSS_n1613 2.83383
R11228 AVSS_n2723 AVSS_n1786 2.83383
R11229 AVSS_n2722 AVSS_n1614 2.83383
R11230 AVSS_n2721 AVSS_n1784 2.83383
R11231 AVSS_n2720 AVSS_n1615 2.83383
R11232 AVSS_n2719 AVSS_n1781 2.83383
R11233 AVSS_n2718 AVSS_n1616 2.83383
R11234 AVSS_n2717 AVSS_n1779 2.83383
R11235 AVSS_n2716 AVSS_n1617 2.83383
R11236 AVSS_n2715 AVSS_n1777 2.83383
R11237 AVSS_n2714 AVSS_n1618 2.83383
R11238 AVSS_n2713 AVSS_n1775 2.83383
R11239 AVSS_n2712 AVSS_n1619 2.83383
R11240 AVSS_n2711 AVSS_n1773 2.83383
R11241 AVSS_n2710 AVSS_n1620 2.83383
R11242 AVSS_n2709 AVSS_n1771 2.83383
R11243 AVSS_n2708 AVSS_n1621 2.83383
R11244 AVSS_n2707 AVSS_n1769 2.83383
R11245 AVSS_n2706 AVSS_n1622 2.83383
R11246 AVSS_n2705 AVSS_n1766 2.83383
R11247 AVSS_n2704 AVSS_n1623 2.83383
R11248 AVSS_n2703 AVSS_n1764 2.83383
R11249 AVSS_n2702 AVSS_n1624 2.83383
R11250 AVSS_n2701 AVSS_n1762 2.83383
R11251 AVSS_n2700 AVSS_n1625 2.83383
R11252 AVSS_n2699 AVSS_n1760 2.83383
R11253 AVSS_n2698 AVSS_n1626 2.83383
R11254 AVSS_n2697 AVSS_n1758 2.83383
R11255 AVSS_n2696 AVSS_n1627 2.83383
R11256 AVSS_n2695 AVSS_n1756 2.83383
R11257 AVSS_n2694 AVSS_n1628 2.83383
R11258 AVSS_n2693 AVSS_n1753 2.83383
R11259 AVSS_n2692 AVSS_n1629 2.83383
R11260 AVSS_n2691 AVSS_n1751 2.83383
R11261 AVSS_n2690 AVSS_n1630 2.83383
R11262 AVSS_n2689 AVSS_n1749 2.83383
R11263 AVSS_n2688 AVSS_n1631 2.83383
R11264 AVSS_n2687 AVSS_n1747 2.83383
R11265 AVSS_n2686 AVSS_n1632 2.83383
R11266 AVSS_n2685 AVSS_n1745 2.83383
R11267 AVSS_n2684 AVSS_n1633 2.83383
R11268 AVSS_n2683 AVSS_n1743 2.83383
R11269 AVSS_n2682 AVSS_n1634 2.83383
R11270 AVSS_n2681 AVSS_n1741 2.83383
R11271 AVSS_n2680 AVSS_n1635 2.83383
R11272 AVSS_n2679 AVSS_n1739 2.83383
R11273 AVSS_n2678 AVSS_n1636 2.83383
R11274 AVSS_n2677 AVSS_n1737 2.83383
R11275 AVSS_n2676 AVSS_n1637 2.83383
R11276 AVSS_n2675 AVSS_n1735 2.83383
R11277 AVSS_n2674 AVSS_n1638 2.83383
R11278 AVSS_n2673 AVSS_n1733 2.83383
R11279 AVSS_n2672 AVSS_n1639 2.83383
R11280 AVSS_n2671 AVSS_n1731 2.83383
R11281 AVSS_n2670 AVSS_n1640 2.83383
R11282 AVSS_n2669 AVSS_n1729 2.83383
R11283 AVSS_n2668 AVSS_n1641 2.83383
R11284 AVSS_n2667 AVSS_n1727 2.83383
R11285 AVSS_n2666 AVSS_n1642 2.83383
R11286 AVSS_n2665 AVSS_n1725 2.83383
R11287 AVSS_n2664 AVSS_n1643 2.83383
R11288 AVSS_n2663 AVSS_n1723 2.83383
R11289 AVSS_n2662 AVSS_n1644 2.83383
R11290 AVSS_n2661 AVSS_n1721 2.83383
R11291 AVSS_n2660 AVSS_n1645 2.83383
R11292 AVSS_n2659 AVSS_n1719 2.83383
R11293 AVSS_n2658 AVSS_n1646 2.83383
R11294 AVSS_n2657 AVSS_n1717 2.83383
R11295 AVSS_n2656 AVSS_n1647 2.83383
R11296 AVSS_n2655 AVSS_n1715 2.83383
R11297 AVSS_n2654 AVSS_n1648 2.83383
R11298 AVSS_n2653 AVSS_n1713 2.83383
R11299 AVSS_n2652 AVSS_n1649 2.83383
R11300 AVSS_n2651 AVSS_n1711 2.83383
R11301 AVSS_n2650 AVSS_n1650 2.83383
R11302 AVSS_n2649 AVSS_n1709 2.83383
R11303 AVSS_n2648 AVSS_n1651 2.83383
R11304 AVSS_n2647 AVSS_n1707 2.83383
R11305 AVSS_n2646 AVSS_n1652 2.83383
R11306 AVSS_n2645 AVSS_n1704 2.83383
R11307 AVSS_n2644 AVSS_n1653 2.83383
R11308 AVSS_n2643 AVSS_n1702 2.83383
R11309 AVSS_n2642 AVSS_n1654 2.83383
R11310 AVSS_n2641 AVSS_n1700 2.83383
R11311 AVSS_n2640 AVSS_n1655 2.83383
R11312 AVSS_n2639 AVSS_n1698 2.83383
R11313 AVSS_n2638 AVSS_n1656 2.83383
R11314 AVSS_n2637 AVSS_n1696 2.83383
R11315 AVSS_n2636 AVSS_n1657 2.83383
R11316 AVSS_n2635 AVSS_n1694 2.83383
R11317 AVSS_n2634 AVSS_n1658 2.83383
R11318 AVSS_n2633 AVSS_n1692 2.83383
R11319 AVSS_n2632 AVSS_n1659 2.83383
R11320 AVSS_n2631 AVSS_n1690 2.83383
R11321 AVSS_n2630 AVSS_n1660 2.83383
R11322 AVSS_n2629 AVSS_n1688 2.83383
R11323 AVSS_n2628 AVSS_n1661 2.83383
R11324 AVSS_n2627 AVSS_n1686 2.83383
R11325 AVSS_n2626 AVSS_n1662 2.83383
R11326 AVSS_n2625 AVSS_n1684 2.83383
R11327 AVSS_n2624 AVSS_n1663 2.83383
R11328 AVSS_n2623 AVSS_n1682 2.83383
R11329 AVSS_n2622 AVSS_n1664 2.83383
R11330 AVSS_n2621 AVSS_n1680 2.83383
R11331 AVSS_n2620 AVSS_n1665 2.83383
R11332 AVSS_n2619 AVSS_n1678 2.83383
R11333 AVSS_n2618 AVSS_n1666 2.83383
R11334 AVSS_n2617 AVSS_n1675 2.83383
R11335 AVSS_n2616 AVSS_n1667 2.83383
R11336 AVSS_n2614 AVSS_n1673 2.83383
R11337 AVSS_n2613 AVSS_n1668 2.83383
R11338 AVSS_n2612 AVSS_n1671 2.83383
R11339 AVSS_n2611 AVSS_n1669 2.83383
R11340 AVSS_n1555 AVSS_n1514 2.83383
R11341 AVSS_n1554 AVSS_n1522 2.83383
R11342 AVSS_n1553 AVSS_n1515 2.83383
R11343 AVSS_n1552 AVSS_n1521 2.83383
R11344 AVSS_n1551 AVSS_n1516 2.83383
R11345 AVSS_n1550 AVSS_n1520 2.83383
R11346 AVSS_n1549 AVSS_n1517 2.83383
R11347 AVSS_n1548 AVSS_n1519 2.83383
R11348 AVSS_n1547 AVSS_n1546 2.83383
R11349 AVSS_n1541 AVSS_n1518 2.83383
R11350 AVSS_n1511 AVSS_n1453 2.83383
R11351 AVSS_n1510 AVSS_n1487 2.83383
R11352 AVSS_n1509 AVSS_n1454 2.83383
R11353 AVSS_n2770 AVSS_n1451 2.83383
R11354 AVSS_n2363 AVSS_n1455 2.83383
R11355 AVSS_n2364 AVSS_n1486 2.83383
R11356 AVSS_n2365 AVSS_n1456 2.83383
R11357 AVSS_n2366 AVSS_n1484 2.83383
R11358 AVSS_n2367 AVSS_n1457 2.83383
R11359 AVSS_n2368 AVSS_n1483 2.83383
R11360 AVSS_n2369 AVSS_n1458 2.83383
R11361 AVSS_n2370 AVSS_n1482 2.83383
R11362 AVSS_n2371 AVSS_n1459 2.83383
R11363 AVSS_n2372 AVSS_n1481 2.83383
R11364 AVSS_n2373 AVSS_n1460 2.83383
R11365 AVSS_n2374 AVSS_n1480 2.83383
R11366 AVSS_n2375 AVSS_n1461 2.83383
R11367 AVSS_n2376 AVSS_n1479 2.83383
R11368 AVSS_n2377 AVSS_n1462 2.83383
R11369 AVSS_n2378 AVSS_n1443 2.83383
R11370 AVSS_n2379 AVSS_n1463 2.83383
R11371 AVSS_n2380 AVSS_n1478 2.83383
R11372 AVSS_n2381 AVSS_n1464 2.83383
R11373 AVSS_n2382 AVSS_n1477 2.83383
R11374 AVSS_n2383 AVSS_n1465 2.83383
R11375 AVSS_n2384 AVSS_n1476 2.83383
R11376 AVSS_n2385 AVSS_n1466 2.83383
R11377 AVSS_n2386 AVSS_n1475 2.83383
R11378 AVSS_n2387 AVSS_n1467 2.83383
R11379 AVSS_n2388 AVSS_n1474 2.83383
R11380 AVSS_n2389 AVSS_n1468 2.83383
R11381 AVSS_n2391 AVSS_n1471 2.83383
R11382 AVSS_n2392 AVSS_n1469 2.83383
R11383 AVSS_n2396 AVSS_n2395 2.83383
R11384 AVSS_n2397 AVSS_n1470 2.83383
R11385 AVSS_n2773 AVSS_n1059 2.83383
R11386 AVSS_n2775 AVSS_n1059 2.83383
R11387 AVSS_n2778 AVSS_n1059 2.83383
R11388 AVSS_n2776 AVSS_n1059 2.83383
R11389 AVSS_n1317 AVSS_n1059 2.83383
R11390 AVSS_n1314 AVSS_n1059 2.83383
R11391 AVSS_n1315 AVSS_n1059 2.83383
R11392 AVSS_n1311 AVSS_n1059 2.83383
R11393 AVSS_n1312 AVSS_n1059 2.83383
R11394 AVSS_n1308 AVSS_n1059 2.83383
R11395 AVSS_n1309 AVSS_n1059 2.83383
R11396 AVSS_n1305 AVSS_n1059 2.83383
R11397 AVSS_n1303 AVSS_n1059 2.83383
R11398 AVSS_n1339 AVSS_n1059 2.83383
R11399 AVSS_n1338 AVSS_n1059 2.83383
R11400 AVSS_n1323 AVSS_n1059 2.83383
R11401 AVSS_n1336 AVSS_n1059 2.83383
R11402 AVSS_n1298 AVSS_n1059 2.83383
R11403 AVSS_n1326 AVSS_n1059 2.83383
R11404 AVSS_n1334 AVSS_n1059 2.83383
R11405 AVSS_n1328 AVSS_n1059 2.83383
R11406 AVSS_n1332 AVSS_n1059 2.83383
R11407 AVSS_n1282 AVSS_n1059 2.83383
R11408 AVSS_n2783 AVSS_n1059 2.83383
R11409 AVSS_n2784 AVSS_n1059 2.83383
R11410 AVSS_n1414 AVSS_n1059 2.83383
R11411 AVSS_n1415 AVSS_n1059 2.83383
R11412 AVSS_n1411 AVSS_n1059 2.83383
R11413 AVSS_n1396 AVSS_n1059 2.83383
R11414 AVSS_n1398 AVSS_n1059 2.83383
R11415 AVSS_n1400 AVSS_n1059 2.83383
R11416 AVSS_n1402 AVSS_n1059 2.83383
R11417 AVSS_n1270 AVSS_n1059 2.83383
R11418 AVSS_n1404 AVSS_n1059 2.83383
R11419 AVSS_n1406 AVSS_n1059 2.83383
R11420 AVSS_n1408 AVSS_n1059 2.83383
R11421 AVSS_n1390 AVSS_n1059 2.83383
R11422 AVSS_n1351 AVSS_n1059 2.83383
R11423 AVSS_n1393 AVSS_n1059 2.83383
R11424 AVSS_n1262 AVSS_n1059 2.83383
R11425 AVSS_n1260 AVSS_n1059 2.83383
R11426 AVSS_n1380 AVSS_n1059 2.83383
R11427 AVSS_n1383 AVSS_n1059 2.83383
R11428 AVSS_n1357 AVSS_n1059 2.83383
R11429 AVSS_n1374 AVSS_n1059 2.83383
R11430 AVSS_n1360 AVSS_n1059 2.83383
R11431 AVSS_n1372 AVSS_n1059 2.83383
R11432 AVSS_n1362 AVSS_n1059 2.83383
R11433 AVSS_n1251 AVSS_n1059 2.83383
R11434 AVSS_n1370 AVSS_n1059 2.83383
R11435 AVSS_n1364 AVSS_n1059 2.83383
R11436 AVSS_n1368 AVSS_n1059 2.83383
R11437 AVSS_n1246 AVSS_n1059 2.83383
R11438 AVSS_n1378 AVSS_n1059 2.83383
R11439 AVSS_n1164 AVSS_n1059 2.83383
R11440 AVSS_n1158 AVSS_n1059 2.83383
R11441 AVSS_n1156 AVSS_n1059 2.83383
R11442 AVSS_n1154 AVSS_n1059 2.83383
R11443 AVSS_n1199 AVSS_n1059 2.83383
R11444 AVSS_n1151 AVSS_n1059 2.83383
R11445 AVSS_n1193 AVSS_n1059 2.83383
R11446 AVSS_n1188 AVSS_n1059 2.83383
R11447 AVSS_n1178 AVSS_n1059 2.83383
R11448 AVSS_n1176 AVSS_n1059 2.83383
R11449 AVSS_n1174 AVSS_n1059 2.83383
R11450 AVSS_n1171 AVSS_n1059 2.83383
R11451 AVSS_n1168 AVSS_n1059 2.83383
R11452 AVSS_n1167 AVSS_n1059 2.83383
R11453 AVSS_n1115 AVSS_n1059 2.83383
R11454 AVSS_n2795 AVSS_n1059 2.83383
R11455 AVSS_n1140 AVSS_n1059 2.83383
R11456 AVSS_n1138 AVSS_n1059 2.83383
R11457 AVSS_n1110 AVSS_n1059 2.83383
R11458 AVSS_n1102 AVSS_n1059 2.83383
R11459 AVSS_n1134 AVSS_n1059 2.83383
R11460 AVSS_n1132 AVSS_n1059 2.83383
R11461 AVSS_n1130 AVSS_n1059 2.83383
R11462 AVSS_n1128 AVSS_n1059 2.83383
R11463 AVSS_n1126 AVSS_n1059 2.83383
R11464 AVSS_n1123 AVSS_n1059 2.83383
R11465 AVSS_n1229 AVSS_n1059 2.83383
R11466 AVSS_n1222 AVSS_n1059 2.83383
R11467 AVSS_n1226 AVSS_n1059 2.83383
R11468 AVSS_n1220 AVSS_n1059 2.83383
R11469 AVSS_n1116 AVSS_n1059 2.83383
R11470 AVSS_n1217 AVSS_n1059 2.83383
R11471 AVSS_n1215 AVSS_n1059 2.83383
R11472 AVSS_n1213 AVSS_n1059 2.83383
R11473 AVSS_n1209 AVSS_n1059 2.83383
R11474 AVSS_n2238 AVSS_n1059 2.83383
R11475 AVSS_n2232 AVSS_n1059 2.83383
R11476 AVSS_n2235 AVSS_n1059 2.83383
R11477 AVSS_n1071 AVSS_n1059 2.83383
R11478 AVSS_n1084 AVSS_n1059 2.83383
R11479 AVSS_n1086 AVSS_n1059 2.83383
R11480 AVSS_n2229 AVSS_n1059 2.83383
R11481 AVSS_n2226 AVSS_n1059 2.83383
R11482 AVSS_n2224 AVSS_n1059 2.83383
R11483 AVSS_n2222 AVSS_n1059 2.83383
R11484 AVSS_n1066 AVSS_n1059 2.83383
R11485 AVSS_n1057 AVSS_n1007 2.83383
R11486 AVSS_n1056 AVSS_n1029 2.83383
R11487 AVSS_n1055 AVSS_n1008 2.83383
R11488 AVSS_n1054 AVSS_n1053 2.83383
R11489 AVSS_n1049 AVSS_n1009 2.83383
R11490 AVSS_n1048 AVSS_n1026 2.83383
R11491 AVSS_n1047 AVSS_n1010 2.83383
R11492 AVSS_n1046 AVSS_n1024 2.83383
R11493 AVSS_n1045 AVSS_n1011 2.83383
R11494 AVSS_n1043 AVSS_n1018 2.83383
R11495 AVSS_n1042 AVSS_n1012 2.83383
R11496 AVSS_n1041 AVSS_n1017 2.83383
R11497 AVSS_n1040 AVSS_n1013 2.83383
R11498 AVSS_n1039 AVSS_n1015 2.83383
R11499 AVSS_n2249 AVSS_n843 2.83383
R11500 AVSS_n2250 AVSS_n952 2.83383
R11501 AVSS_n2251 AVSS_n844 2.83383
R11502 AVSS_n2252 AVSS_n951 2.83383
R11503 AVSS_n2253 AVSS_n845 2.83383
R11504 AVSS_n2254 AVSS_n950 2.83383
R11505 AVSS_n2255 AVSS_n846 2.83383
R11506 AVSS_n2256 AVSS_n949 2.83383
R11507 AVSS_n2257 AVSS_n847 2.83383
R11508 AVSS_n2258 AVSS_n778 2.83383
R11509 AVSS_n2259 AVSS_n849 2.83383
R11510 AVSS_n2260 AVSS_n948 2.83383
R11511 AVSS_n2261 AVSS_n850 2.83383
R11512 AVSS_n2262 AVSS_n946 2.83383
R11513 AVSS_n2263 AVSS_n851 2.83383
R11514 AVSS_n2264 AVSS_n945 2.83383
R11515 AVSS_n2265 AVSS_n852 2.83383
R11516 AVSS_n2266 AVSS_n782 2.83383
R11517 AVSS_n2267 AVSS_n854 2.83383
R11518 AVSS_n2268 AVSS_n944 2.83383
R11519 AVSS_n2269 AVSS_n855 2.83383
R11520 AVSS_n2270 AVSS_n943 2.83383
R11521 AVSS_n2271 AVSS_n856 2.83383
R11522 AVSS_n2272 AVSS_n942 2.83383
R11523 AVSS_n2273 AVSS_n857 2.83383
R11524 AVSS_n2274 AVSS_n941 2.83383
R11525 AVSS_n2275 AVSS_n858 2.83383
R11526 AVSS_n2276 AVSS_n940 2.83383
R11527 AVSS_n2277 AVSS_n859 2.83383
R11528 AVSS_n2278 AVSS_n939 2.83383
R11529 AVSS_n2279 AVSS_n860 2.83383
R11530 AVSS_n2280 AVSS_n938 2.83383
R11531 AVSS_n2281 AVSS_n790 2.83383
R11532 AVSS_n2282 AVSS_n937 2.83383
R11533 AVSS_n2283 AVSS_n861 2.83383
R11534 AVSS_n2284 AVSS_n935 2.83383
R11535 AVSS_n2285 AVSS_n862 2.83383
R11536 AVSS_n2286 AVSS_n793 2.83383
R11537 AVSS_n2287 AVSS_n864 2.83383
R11538 AVSS_n2288 AVSS_n934 2.83383
R11539 AVSS_n2289 AVSS_n795 2.83383
R11540 AVSS_n2290 AVSS_n933 2.83383
R11541 AVSS_n2291 AVSS_n865 2.83383
R11542 AVSS_n2292 AVSS_n931 2.83383
R11543 AVSS_n2293 AVSS_n866 2.83383
R11544 AVSS_n2294 AVSS_n930 2.83383
R11545 AVSS_n2295 AVSS_n867 2.83383
R11546 AVSS_n2296 AVSS_n929 2.83383
R11547 AVSS_n2297 AVSS_n868 2.83383
R11548 AVSS_n2298 AVSS_n928 2.83383
R11549 AVSS_n2300 AVSS_n871 2.83383
R11550 AVSS_n2301 AVSS_n927 2.83383
R11551 AVSS_n2305 AVSS_n2304 2.83383
R11552 AVSS_n2306 AVSS_n803 2.83383
R11553 AVSS_n2307 AVSS_n873 2.83383
R11554 AVSS_n2360 AVSS_n926 2.83383
R11555 AVSS_n2359 AVSS_n805 2.83383
R11556 AVSS_n2358 AVSS_n925 2.83383
R11557 AVSS_n2357 AVSS_n874 2.83383
R11558 AVSS_n2356 AVSS_n923 2.83383
R11559 AVSS_n2355 AVSS_n875 2.83383
R11560 AVSS_n2354 AVSS_n922 2.83383
R11561 AVSS_n2353 AVSS_n876 2.83383
R11562 AVSS_n2352 AVSS_n809 2.83383
R11563 AVSS_n2351 AVSS_n878 2.83383
R11564 AVSS_n2350 AVSS_n921 2.83383
R11565 AVSS_n2349 AVSS_n879 2.83383
R11566 AVSS_n2348 AVSS_n920 2.83383
R11567 AVSS_n2347 AVSS_n880 2.83383
R11568 AVSS_n2346 AVSS_n919 2.83383
R11569 AVSS_n2345 AVSS_n813 2.83383
R11570 AVSS_n2344 AVSS_n918 2.83383
R11571 AVSS_n2343 AVSS_n881 2.83383
R11572 AVSS_n2342 AVSS_n815 2.83383
R11573 AVSS_n2341 AVSS_n883 2.83383
R11574 AVSS_n2340 AVSS_n916 2.83383
R11575 AVSS_n2339 AVSS_n884 2.83383
R11576 AVSS_n2338 AVSS_n915 2.83383
R11577 AVSS_n2337 AVSS_n885 2.83383
R11578 AVSS_n2336 AVSS_n914 2.83383
R11579 AVSS_n2335 AVSS_n819 2.83383
R11580 AVSS_n2334 AVSS_n913 2.83383
R11581 AVSS_n2333 AVSS_n886 2.83383
R11582 AVSS_n2332 AVSS_n821 2.83383
R11583 AVSS_n2331 AVSS_n888 2.83383
R11584 AVSS_n2330 AVSS_n911 2.83383
R11585 AVSS_n2329 AVSS_n889 2.83383
R11586 AVSS_n2328 AVSS_n910 2.83383
R11587 AVSS_n2327 AVSS_n890 2.83383
R11588 AVSS_n2326 AVSS_n909 2.83383
R11589 AVSS_n2325 AVSS_n825 2.83383
R11590 AVSS_n2324 AVSS_n908 2.83383
R11591 AVSS_n2323 AVSS_n891 2.83383
R11592 AVSS_n2322 AVSS_n906 2.83383
R11593 AVSS_n2321 AVSS_n892 2.83383
R11594 AVSS_n2320 AVSS_n905 2.83383
R11595 AVSS_n2319 AVSS_n893 2.83383
R11596 AVSS_n2318 AVSS_n829 2.83383
R11597 AVSS_n2317 AVSS_n895 2.83383
R11598 AVSS_n2316 AVSS_n904 2.83383
R11599 AVSS_n2315 AVSS_n896 2.83383
R11600 AVSS_n2314 AVSS_n903 2.83383
R11601 AVSS_n2313 AVSS_n897 2.83383
R11602 AVSS_n2312 AVSS_n902 2.83383
R11603 AVSS_n2311 AVSS_n898 2.83383
R11604 AVSS_n2310 AVSS_n901 2.83383
R11605 AVSS_n2309 AVSS_n899 2.83383
R11606 AVSS_n2308 AVSS_n900 2.83383
R11607 AVSS_n2816 AVSS_n841 2.83383
R11608 AVSS_n1086 AVSS_n1069 2.7912
R11609 AVSS_n1229 AVSS_n1122 2.7912
R11610 AVSS_n1129 AVSS_n1128 2.7912
R11611 AVSS_n2800 AVSS_n1102 2.7912
R11612 AVSS_n1140 AVSS_n1113 2.7912
R11613 AVSS_n1167 AVSS_n1166 2.7912
R11614 AVSS_n1379 AVSS_n1378 2.7912
R11615 AVSS_n1381 AVSS_n1380 2.7912
R11616 AVSS_n1401 AVSS_n1400 2.7912
R11617 AVSS_n1339 AVSS_n1291 2.7912
R11618 AVSS_n446 AVSS_n422 2.72818
R11619 AVSS_n2242 AVSS_n2240 2.7239
R11620 AVSS_n605 AVSS_n581 2.71714
R11621 AVSS_n740 AVSS_n457 2.70468
R11622 AVSS_n762 AVSS_n358 2.70299
R11623 AVSS_n2395 AVSS_n1452 2.61155
R11624 AVSS_n2395 AVSS_n2394 2.61155
R11625 AVSS_n1455 AVSS_n1435 2.61155
R11626 AVSS_n635 AVSS_n468 2.56625
R11627 AVSS_n636 AVSS_n482 2.56625
R11628 AVSS_n640 AVSS_n467 2.56625
R11629 AVSS_n637 AVSS_n483 2.56625
R11630 AVSS_n642 AVSS_n466 2.56625
R11631 AVSS_n3504 AVSS_n3503 2.41336
R11632 AVSS_n2099 AVSS_n2038 2.41067
R11633 AVSS_n1890 AVSS_n1887 2.40384
R11634 AVSS_n1355 AVSS_n1354 2.38612
R11635 AVSS_n750 AVSS_n749 2.38612
R11636 AVSS_n2761 AVSS_n2102 2.33259
R11637 AVSS_n602 AVSS_n599 2.29333
R11638 AVSS_n364 AVSS_n334 2.21914
R11639 AVSS_n246 AVSS_n245 2.03988
R11640 AVSS_n2994 AVSS_n246 2.03988
R11641 AVSS_n1425 AVSS_n1319 1.96948
R11642 AVSS_n2791 AVSS_n2790 1.96319
R11643 AVSS_n2786 AVSS_n1281 1.96319
R11644 AVSS_n760 AVSS_n352 1.96319
R11645 AVSS_n755 AVSS_n397 1.96319
R11646 AVSS_n762 AVSS_n761 1.95689
R11647 AVSS_n644 AVSS_n643 1.95473
R11648 AVSS_n1232 AVSS_n1231 1.95372
R11649 AVSS_n601 AVSS_n600 1.92481
R11650 AVSS_n584 AVSS_n547 1.92481
R11651 AVSS_n705 AVSS_n132 1.9228
R11652 AVSS_n1170 AVSS_n1163 1.89014
R11653 AVSS_n1192 AVSS_n1191 1.88989
R11654 AVSS_n1377 AVSS_n1245 1.88989
R11655 AVSS_n1331 AVSS_n1330 1.88989
R11656 AVSS_n360 AVSS_n359 1.88989
R11657 AVSS_n2792 AVSS_n2791 1.88939
R11658 AVSS_n2786 AVSS_n2785 1.88939
R11659 AVSS_n1341 AVSS_n1340 1.88939
R11660 AVSS_n2792 AVSS_n1163 1.88939
R11661 AVSS_n352 AVSS_n335 1.88939
R11662 AVSS_n755 AVSS_n754 1.88939
R11663 AVSS_n609 AVSS_n608 1.88939
R11664 AVSS_n609 AVSS_n562 1.88939
R11665 AVSS_n591 AVSS_n570 1.88939
R11666 AVSS_n499 AVSS_n457 1.86299
R11667 AVSS_n570 AVSS_n569 1.86269
R11668 AVSS_n351 AVSS_n350 1.86269
R11669 AVSS_n351 AVSS_n349 1.86269
R11670 AVSS_n351 AVSS_n345 1.86269
R11671 AVSS_n351 AVSS_n341 1.86269
R11672 AVSS_n351 AVSS_n340 1.86269
R11673 AVSS_n351 AVSS_n336 1.86269
R11674 AVSS_n585 AVSS_n583 1.86269
R11675 AVSS_n585 AVSS_n582 1.86269
R11676 AVSS_n1066 AVSS_n1060 1.86097
R11677 AVSS_n1116 AVSS_n1079 1.86097
R11678 AVSS_n1111 AVSS_n1110 1.86097
R11679 AVSS_n1165 AVSS_n1115 1.86097
R11680 AVSS_n1169 AVSS_n1168 1.86097
R11681 AVSS_n1174 AVSS_n1173 1.86097
R11682 AVSS_n1179 AVSS_n1178 1.86097
R11683 AVSS_n1191 AVSS_n1190 1.86097
R11684 AVSS_n1193 AVSS_n1150 1.86097
R11685 AVSS_n1199 AVSS_n1152 1.86097
R11686 AVSS_n1378 AVSS_n1377 1.86097
R11687 AVSS_n1368 AVSS_n1247 1.86097
R11688 AVSS_n1330 AVSS_n1296 1.86097
R11689 AVSS_n1333 AVSS_n1295 1.86097
R11690 AVSS_n1329 AVSS_n1297 1.86097
R11691 AVSS_n1335 AVSS_n1294 1.86097
R11692 AVSS_n1327 AVSS_n1299 1.86097
R11693 AVSS_n1185 AVSS_n1099 1.8583
R11694 AVSS_n3507 AVSS_n1 1.8381
R11695 AVSS_n599 AVSS_n593 1.79859
R11696 AVSS_n442 AVSS_n368 1.79525
R11697 AVSS_n1236 AVSS_n1114 1.79349
R11698 AVSS_n621 AVSS_n619 1.79349
R11699 AVSS_n1281 AVSS_n1280 1.78682
R11700 AVSS_n661 AVSS_n132 1.76036
R11701 AVSS_n2403 AVSS_n2402 1.75202
R11702 AVSS_n609 AVSS_n561 1.71419
R11703 AVSS_n455 AVSS_n453 1.68687
R11704 AVSS_n1224 AVSS_n1204 1.68587
R11705 AVSS_n638 AVSS_n512 1.67939
R11706 AVSS_n442 AVSS_n397 1.67505
R11707 AVSS_n870 AVSS_n869 1.66991
R11708 AVSS_n964 AVSS_n870 1.66991
R11709 AVSS_n2759 AVSS_n2103 1.6378
R11710 AVSS_n699 AVSS_n652 1.533
R11711 AVSS_n2428 AVSS_n2419 1.533
R11712 AVSS_n755 AVSS_n368 1.51101
R11713 AVSS_n1241 AVSS_n1240 1.50829
R11714 AVSS_n1235 AVSS_n1101 1.50681
R11715 AVSS_n622 AVSS_n613 1.50681
R11716 AVSS_n2247 AVSS_n2220 1.50419
R11717 AVSS_n2791 AVSS_n1201 1.50251
R11718 AVSS_n758 AVSS_n352 1.50199
R11719 AVSS_n1206 AVSS_n1061 1.50033
R11720 AVSS_n749 AVSS_n748 1.4984
R11721 AVSS_n2220 AVSS_n2219 1.49509
R11722 AVSS_n1386 AVSS_n1385 1.4906
R11723 AVSS_n1410 AVSS_n1350 1.4906
R11724 AVSS_n449 AVSS_n448 1.48976
R11725 AVSS_n752 AVSS_n751 1.48976
R11726 AVSS_n2802 AVSS_n1089 1.48875
R11727 AVSS_n765 AVSS_n322 1.48875
R11728 AVSS_n1302 AVSS_n1283 1.48677
R11729 AVSS_n421 AVSS_n415 1.4861
R11730 AVSS_n1420 AVSS_n1349 1.48015
R11731 AVSS_n365 AVSS_n322 1.47806
R11732 AVSS_n1354 AVSS_n1161 1.47587
R11733 AVSS_n1053 AVSS_n1006 1.46328
R11734 AVSS_n1053 AVSS_n1052 1.46328
R11735 AVSS_n1033 AVSS_n1007 1.46328
R11736 AVSS_n1280 AVSS_n1243 1.46278
R11737 AVSS_n735 AVSS_n463 1.45436
R11738 AVSS_n1206 AVSS_n1064 1.44456
R11739 AVSS_n3133 AVSS_n306 1.43778
R11740 AVSS_n841 AVSS_n836 1.43778
R11741 AVSS_n2245 AVSS_n1161 1.43638
R11742 AVSS_n697 AVSS_n686 1.43208
R11743 AVSS_n2437 AVSS_n2436 1.43174
R11744 AVSS_n418 AVSS_n416 1.42458
R11745 AVSS_n420 AVSS_n419 1.41526
R11746 AVSS_n748 AVSS_n747 1.41366
R11747 AVSS_n3485 AVSS_n21 1.41355
R11748 AVSS_n3480 AVSS_n18 1.41355
R11749 AVSS_n3420 AVSS_n3419 1.41355
R11750 AVSS_n3236 AVSS_n178 1.41355
R11751 AVSS_n216 AVSS_n201 1.41355
R11752 AVSS_n3225 AVSS_n196 1.41355
R11753 AVSS_n3051 AVSS_n246 1.41355
R11754 AVSS_n2113 AVSS_n2038 1.41355
R11755 AVSS_n2764 AVSS_n1914 1.41355
R11756 AVSS_n2212 AVSS_n1890 1.41355
R11757 AVSS_n2766 AVSS_n1556 1.41355
R11758 AVSS_n2390 AVSS_n1473 1.41355
R11759 AVSS_n2812 AVSS_n1058 1.41355
R11760 AVSS_n1044 AVSS_n1022 1.41355
R11761 AVSS_n2814 AVSS_n1005 1.41355
R11762 AVSS_n2299 AVSS_n870 1.41355
R11763 AVSS_n2038 AVSS_n2036 1.405
R11764 AVSS_n597 AVSS_n593 1.39555
R11765 AVSS_n1425 AVSS_n1424 1.39337
R11766 AVSS_n1422 AVSS_n1421 1.38998
R11767 AVSS_n1423 AVSS_n1348 1.37908
R11768 AVSS_n736 AVSS_n735 1.37648
R11769 AVSS_n1354 AVSS_n1160 1.37365
R11770 AVSS_n1355 AVSS_n1353 1.3608
R11771 AVSS_n452 AVSS_n451 1.36078
R11772 AVSS_n1388 AVSS_n1349 1.35904
R11773 AVSS_n581 AVSS_n580 1.35735
R11774 AVSS_n2245 AVSS_n1160 1.35651
R11775 AVSS_n750 AVSS_n452 1.35368
R11776 AVSS_n1387 AVSS_n1353 1.35366
R11777 AVSS_n450 AVSS_n415 1.3508
R11778 AVSS_n1319 AVSS_n1284 1.34508
R11779 AVSS_n757 AVSS_n756 1.33939
R11780 AVSS_n2788 AVSS_n2787 1.33808
R11781 AVSS_n747 AVSS_n455 1.33721
R11782 AVSS_n457 AVSS_n456 1.33147
R11783 AVSS_n692 AVSS_n691 1.32708
R11784 AVSS_n2439 AVSS_n2438 1.32674
R11785 AVSS_n2793 AVSS_n1117 1.30894
R11786 AVSS_n1187 AVSS_n1165 1.30894
R11787 AVSS_n2807 AVSS_n2806 1.30869
R11788 AVSS_n1211 AVSS_n1210 1.30869
R11789 AVSS_n1125 AVSS_n1107 1.30869
R11790 AVSS_n2230 AVSS_n1088 1.30869
R11791 AVSS_n2221 AVSS_n1060 1.30869
R11792 AVSS_n2782 AVSS_n2781 1.30869
R11793 AVSS_n600 AVSS_n545 1.30869
R11794 AVSS_n767 AVSS_n766 1.30869
R11795 AVSS_n626 AVSS_n514 1.30869
R11796 AVSS_n503 AVSS_n502 1.30869
R11797 AVSS_n551 AVSS_n475 1.30869
R11798 AVSS_n562 AVSS_n519 1.30869
R11799 AVSS_n2234 AVSS_n1061 1.30819
R11800 AVSS_n1231 AVSS_n1230 1.30819
R11801 AVSS_n1166 AVSS_n1101 1.30819
R11802 AVSS_n1111 AVSS_n1072 1.30819
R11803 AVSS_n2792 AVSS_n1187 1.30819
R11804 AVSS_n2240 AVSS_n2239 1.30819
R11805 AVSS_n2793 AVSS_n2792 1.30819
R11806 AVSS_n2774 AVSS_n1284 1.30819
R11807 AVSS_n2774 AVSS_n1283 1.30819
R11808 AVSS_n2782 AVSS_n1283 1.30819
R11809 AVSS_n726 AVSS_n457 1.30819
R11810 AVSS_n634 AVSS_n633 1.30819
R11811 AVSS_n623 AVSS_n622 1.30819
R11812 AVSS_n370 AVSS_n311 1.30819
R11813 AVSS_n370 AVSS_n351 1.30819
R11814 AVSS_n643 AVSS_n642 1.30819
R11815 AVSS_n725 AVSS_n495 1.30819
R11816 AVSS_n585 AVSS_n584 1.30819
R11817 AVSS_n585 AVSS_n562 1.30819
R11818 AVSS_n498 AVSS_n494 1.30819
R11819 AVSS_n1421 AVSS_n1348 1.29917
R11820 AVSS_n3419 AVSS_n139 1.29677
R11821 AVSS_n3419 AVSS_n136 1.29677
R11822 AVSS_n1423 AVSS_n1422 1.29188
R11823 AVSS_n722 AVSS_n651 1.28583
R11824 AVSS_n2417 AVSS_n2416 1.28549
R11825 AVSS_n356 AVSS_n332 1.28337
R11826 AVSS_n363 AVSS_n313 1.28337
R11827 AVSS_n354 AVSS_n333 1.28337
R11828 AVSS_n763 AVSS_n353 1.28337
R11829 AVSS_n764 AVSS_n335 1.28337
R11830 AVSS_n608 AVSS_n607 1.28337
R11831 AVSS_n568 AVSS_n562 1.28042
R11832 AVSS_n1347 AVSS_n1346 1.27684
R11833 AVSS_n1187 AVSS_n1186 1.2768
R11834 AVSS_n419 AVSS_n418 1.26668
R11835 AVSS_n420 AVSS_n416 1.26646
R11836 AVSS_n648 AVSS_n647 1.2622
R11837 AVSS_n656 AVSS_n652 1.26208
R11838 AVSS_n2429 AVSS_n2428 1.26174
R11839 AVSS_n1238 AVSS_n1237 1.25862
R11840 AVSS_n612 AVSS_n611 1.25862
R11841 AVSS_n2787 AVSS_n1244 1.20474
R11842 AVSS_n756 AVSS_n369 1.20361
R11843 AVSS_n1203 AVSS_n1114 1.19279
R11844 AVSS_n619 AVSS_n546 1.19279
R11845 AVSS_n1205 AVSS_n1061 1.17972
R11846 AVSS_n1231 AVSS_n1204 1.17972
R11847 AVSS_n643 AVSS_n512 1.17972
R11848 AVSS_n581 AVSS_n577 1.1749
R11849 AVSS_n1184 AVSS_n1183 1.16524
R11850 AVSS_n596 AVSS_n595 1.16524
R11851 AVSS_n599 AVSS_n598 1.16171
R11852 AVSS_n1186 AVSS_n1184 1.15986
R11853 AVSS_n595 AVSS_n594 1.15986
R11854 AVSS_n2789 AVSS_n2788 1.15183
R11855 AVSS_n560 AVSS_n369 1.15183
R11856 AVSS_n1424 AVSS_n1347 1.13185
R11857 AVSS_n647 AVSS_n646 1.12642
R11858 AVSS_n417 AVSS_n334 1.10272
R11859 AVSS_n638 AVSS_n515 1.09887
R11860 AVSS_n1224 AVSS_n1212 1.09665
R11861 AVSS_n3234 AVSS_n187 1.09252
R11862 AVSS_n204 AVSS_n191 1.09252
R11863 AVSS_n210 AVSS_n203 1.09252
R11864 AVSS_n1546 AVSS_n1513 1.09252
R11865 AVSS_n1546 AVSS_n1545 1.09252
R11866 AVSS_n1530 AVSS_n1514 1.09252
R11867 AVSS_n580 AVSS_n579 1.08945
R11868 AVSS_n366 AVSS_n364 1.07394
R11869 AVSS_n609 AVSS_n555 1.07166
R11870 AVSS_n2241 AVSS_n1099 1.07128
R11871 AVSS_n1236 AVSS_n1101 1.0603
R11872 AVSS_n1185 AVSS_n1072 1.0603
R11873 AVSS_n622 AVSS_n621 1.0603
R11874 AVSS_n598 AVSS_n585 1.0603
R11875 AVSS_n494 AVSS_n462 1.0603
R11876 AVSS_n30 AVSS_n21 1.0568
R11877 AVSS_n2056 AVSS_n21 1.0568
R11878 AVSS_n2758 AVSS_n2757 1.03071
R11879 AVSS_n761 AVSS_n760 0.97591
R11880 AVSS_n449 AVSS_n422 0.973909
R11881 AVSS_n577 AVSS_n570 0.970421
R11882 AVSS_n758 AVSS_n358 0.969762
R11883 AVSS_n2244 AVSS_n2243 0.963523
R11884 AVSS_n1344 AVSS_n1343 0.96307
R11885 AVSS_n1321 AVSS_n1320 0.961247
R11886 AVSS_n731 AVSS_n507 0.958472
R11887 AVSS_n2242 AVSS_n2219 0.95468
R11888 AVSS_n366 AVSS_n365 0.945347
R11889 AVSS_n2768 AVSS_n1512 0.938269
R11890 AVSS_n1181 AVSS_n1064 0.933825
R11891 AVSS_n1227 AVSS_n1094 0.930733
R11892 AVSS_n1223 AVSS_n1078 0.930733
R11893 AVSS_n1230 AVSS_n1095 0.930733
R11894 AVSS_n1124 AVSS_n1123 0.930733
R11895 AVSS_n1127 AVSS_n1126 0.930733
R11896 AVSS_n1125 AVSS_n1076 0.930733
R11897 AVSS_n1106 AVSS_n1097 0.930733
R11898 AVSS_n1108 AVSS_n1075 0.930733
R11899 AVSS_n1105 AVSS_n1098 0.930733
R11900 AVSS_n1136 AVSS_n1109 0.930733
R11901 AVSS_n2801 AVSS_n2800 0.930733
R11902 AVSS_n2796 AVSS_n2795 0.930733
R11903 AVSS_n2798 AVSS_n1115 0.930733
R11904 AVSS_n1403 AVSS_n1402 0.930733
R11905 AVSS_n1304 AVSS_n1303 0.930733
R11906 AVSS_n739 AVSS_n738 0.930684
R11907 AVSS_n1242 AVSS_n1163 0.928963
R11908 AVSS_n511 AVSS_n507 0.927186
R11909 AVSS_n1344 AVSS_n1322 0.912799
R11910 AVSS_n767 AVSS_n310 0.903036
R11911 AVSS_n1419 AVSS_n1350 0.893476
R11912 AVSS_n1345 AVSS_n1344 0.882494
R11913 AVSS_n2246 AVSS_n2244 0.880898
R11914 AVSS_n1205 AVSS_n1070 0.876852
R11915 AVSS_n2805 AVSS_n1064 0.867105
R11916 AVSS_n560 AVSS_n555 0.835281
R11917 AVSS_n3505 AVSS_n3 0.833833
R11918 AVSS_n1239 AVSS_n1201 0.831082
R11919 AVSS_n611 AVSS_n555 0.820745
R11920 AVSS_n3508 AVSS_n3507 0.81428
R11921 AVSS_n738 AVSS_n737 0.805532
R11922 AVSS_n3500 AVSS_n2 0.803757
R11923 AVSS_n738 AVSS_n457 0.790224
R11924 AVSS_n1345 AVSS_n1320 0.789104
R11925 AVSS_n1341 AVSS_n1320 0.787646
R11926 AVSS_n365 AVSS_n311 0.783365
R11927 AVSS_n1473 AVSS_n1472 0.772389
R11928 AVSS_n1500 AVSS_n1473 0.772389
R11929 AVSS_n1022 AVSS_n1021 0.765237
R11930 AVSS_n510 AVSS_n507 0.754046
R11931 AVSS_n2429 AVSS_n2417 0.752075
R11932 AVSS_n656 AVSS_n651 0.751736
R11933 AVSS_n1233 AVSS_n1204 0.738897
R11934 AVSS_n1207 AVSS_n1205 0.738897
R11935 AVSS_n645 AVSS_n512 0.738897
R11936 AVSS_n1182 AVSS_n1089 0.735076
R11937 AVSS_n2419 AVSS_n2418 0.734575
R11938 AVSS_n700 AVSS_n699 0.734236
R11939 AVSS_n1386 AVSS_n1356 0.712614
R11940 AVSS_n1389 AVSS_n1350 0.712614
R11941 AVSS_n751 AVSS_n414 0.70259
R11942 AVSS_n450 AVSS_n449 0.69866
R11943 AVSS_n751 AVSS_n750 0.69866
R11944 AVSS_n579 AVSS_n577 0.689721
R11945 AVSS_n2247 AVSS_n2246 0.689455
R11946 AVSS_n1387 AVSS_n1386 0.689356
R11947 AVSS_n1242 AVSS_n1241 0.684185
R11948 AVSS_n736 AVSS_n462 0.673597
R11949 AVSS_n1237 AVSS_n1236 0.665089
R11950 AVSS_n1186 AVSS_n1185 0.665089
R11951 AVSS_n621 AVSS_n620 0.665089
R11952 AVSS_n598 AVSS_n597 0.665089
R11953 AVSS_n594 AVSS_n462 0.665089
R11954 AVSS_n1235 AVSS_n1234 0.665037
R11955 AVSS_n613 AVSS_n612 0.665037
R11956 AVSS_n1237 AVSS_n1235 0.663686
R11957 AVSS_n620 AVSS_n613 0.663686
R11958 AVSS_n2241 AVSS_n1089 0.646178
R11959 AVSS_n417 AVSS_n322 0.646178
R11960 AVSS_n2244 AVSS_n2240 0.64611
R11961 AVSS_n1225 AVSS_n1224 0.644173
R11962 AVSS_n639 AVSS_n638 0.642768
R11963 AVSS_n553 AVSS_n474 0.641937
R11964 AVSS_n554 AVSS_n476 0.641937
R11965 AVSS_n614 AVSS_n473 0.641937
R11966 AVSS_n616 AVSS_n477 0.641937
R11967 AVSS_n615 AVSS_n472 0.641937
R11968 AVSS_n623 AVSS_n478 0.641937
R11969 AVSS_n626 AVSS_n470 0.641937
R11970 AVSS_n516 AVSS_n480 0.641937
R11971 AVSS_n517 AVSS_n469 0.641937
R11972 AVSS_n1346 AVSS_n1319 0.635608
R11973 AVSS AVSS_n3508 0.6161
R11974 AVSS_n746 AVSS_n456 0.613625
R11975 AVSS_n2436 AVSS_n2408 0.610825
R11976 AVSS_n2438 AVSS_n2437 0.610825
R11977 AVSS_n2439 AVSS_n2404 0.610825
R11978 AVSS_n691 AVSS_n690 0.610486
R11979 AVSS_n692 AVSS_n686 0.610486
R11980 AVSS_n698 AVSS_n697 0.610486
R11981 AVSS_n2243 AVSS_n2241 0.598625
R11982 AVSS_n739 AVSS_n736 0.598625
R11983 AVSS_n1421 AVSS_n1420 0.59175
R11984 AVSS_n421 AVSS_n420 0.59175
R11985 AVSS_n644 AVSS_n513 0.590057
R11986 AVSS_n3506 AVSS_n3505 0.58134
R11987 AVSS_n3 AVSS_n2 0.58134
R11988 AVSS_n1232 AVSS_n1208 0.580907
R11989 AVSS_n1207 AVSS_n1206 0.564051
R11990 AVSS_n2246 AVSS_n2245 0.5615
R11991 AVSS_n747 AVSS_n746 0.5615
R11992 AVSS_n2789 AVSS_n1201 0.558535
R11993 AVSS_n759 AVSS_n758 0.552498
R11994 AVSS_n3424 AVSS_n3423 0.5505
R11995 AVSS_n580 AVSS_n570 0.544042
R11996 AVSS_n647 AVSS_n495 0.534632
R11997 AVSS_n737 AVSS_n456 0.53407
R11998 AVSS_n2248 AVSS_n2219 0.533247
R11999 AVSS_n1346 AVSS_n1345 0.529875
R12000 AVSS_n367 AVSS_n366 0.529875
R12001 AVSS_n597 AVSS_n596 0.5285
R12002 AVSS_n1241 AVSS_n1238 0.52734
R12003 AVSS_n2790 AVSS_n2789 0.510855
R12004 AVSS_n1281 AVSS_n1244 0.510855
R12005 AVSS_n397 AVSS_n369 0.510855
R12006 AVSS_n760 AVSS_n759 0.510855
R12007 AVSS_n557 AVSS_n556 0.502707
R12008 AVSS_n1382 AVSS_n1381 0.5005
R12009 AVSS_n1382 AVSS_n1379 0.5005
R12010 AVSS_n1418 AVSS_n1417 0.5005
R12011 AVSS_n1418 AVSS_n1394 0.5005
R12012 AVSS_n446 AVSS_n445 0.5005
R12013 AVSS_n446 AVSS_n436 0.5005
R12014 AVSS_n401 AVSS_n398 0.5005
R12015 AVSS_n401 AVSS_n400 0.5005
R12016 AVSS_n755 AVSS_n371 0.499748
R12017 AVSS_n570 AVSS_n568 0.499655
R12018 AVSS_n757 AVSS_n368 0.498014
R12019 AVSS_n1183 AVSS_n1181 0.4955
R12020 AVSS_n594 AVSS_n510 0.4955
R12021 AVSS_n2799 AVSS_n1114 0.493233
R12022 AVSS_n619 AVSS_n618 0.493233
R12023 AVSS_n2248 AVSS_n2247 0.482353
R12024 AVSS_n1233 AVSS_n1232 0.455409
R12025 AVSS_n741 AVSS_n740 0.454856
R12026 AVSS_n578 AVSS_n561 0.453722
R12027 AVSS_n761 AVSS_n367 0.452462
R12028 AVSS_n364 AVSS_n311 0.451085
R12029 AVSS_n1388 AVSS_n1387 0.447833
R12030 AVSS_n451 AVSS_n450 0.447833
R12031 AVSS_n561 AVSS_n560 0.446817
R12032 AVSS_n645 AVSS_n644 0.446801
R12033 AVSS_n1184 AVSS_n1072 0.445055
R12034 AVSS_n595 AVSS_n494 0.445055
R12035 AVSS_n2243 AVSS_n2242 0.422646
R12036 AVSS_n2802 AVSS_n1099 0.409114
R12037 AVSS_n367 AVSS_n358 0.40399
R12038 AVSS_n2790 AVSS_n1242 0.402078
R12039 AVSS_n1022 AVSS_n1019 0.401337
R12040 AVSS_n610 AVSS_n556 0.399681
R12041 AVSS_n740 AVSS_n739 0.382591
R12042 AVSS_n3422 AVSS_n133 0.3755
R12043 AVSS_n3423 AVSS_n3422 0.3755
R12044 AVSS_n3423 AVSS_n130 0.3755
R12045 AVSS_n3430 AVSS_n130 0.3755
R12046 AVSS_n2401 AVSS_n2194 0.3755
R12047 AVSS_n2756 AVSS_n2194 0.3755
R12048 AVSS_n765 AVSS_n334 0.372151
R12049 AVSS_n1234 AVSS_n1233 0.367167
R12050 AVSS_n620 AVSS_n513 0.367167
R12051 AVSS_n743 AVSS_n742 0.367121
R12052 AVSS_n1208 AVSS_n1207 0.356167
R12053 AVSS_n646 AVSS_n645 0.356167
R12054 AVSS_n648 AVSS_n510 0.355781
R12055 AVSS_n351 AVSS_n310 0.352569
R12056 AVSS_n3429 AVSS_n129 0.337683
R12057 AVSS_n1239 AVSS_n1238 0.336103
R12058 AVSS_n3428 AVSS_n3427 0.335849
R12059 AVSS_n3426 AVSS_n3425 0.334016
R12060 AVSS_n422 AVSS_n421 0.333669
R12061 AVSS_n2193 AVSS_n2103 0.332887
R12062 AVSS_n2757 AVSS_n2756 0.32675
R12063 AVSS_n2104 AVSS_n2047 0.320123
R12064 AVSS_n1321 AVSS_n1244 0.3195
R12065 AVSS_n759 AVSS_n757 0.3195
R12066 AVSS_n742 AVSS_n741 0.312358
R12067 AVSS_n744 AVSS_n743 0.304801
R12068 AVSS_n201 AVSS_n192 0.292968
R12069 AVSS_n214 AVSS_n201 0.292968
R12070 AVSS_n2768 AVSS_n1489 0.292968
R12071 AVSS_n2768 AVSS_n1488 0.292968
R12072 AVSS_n2400 AVSS_n2398 0.291855
R12073 AVSS_n3316 AVSS_n131 0.290817
R12074 AVSS_n1347 AVSS_n1284 0.286091
R12075 AVSS_n1420 AVSS_n1419 0.280445
R12076 AVSS_n3432 AVSS_n3431 0.279559
R12077 AVSS_n2399 AVSS_n1058 0.278411
R12078 AVSS_n443 AVSS_n442 0.275231
R12079 AVSS_n749 AVSS_n453 0.27298
R12080 AVSS_n1424 AVSS_n1423 0.2645
R12081 AVSS_n418 AVSS_n417 0.2645
R12082 AVSS_n745 AVSS_n744 0.250378
R12083 AVSS_n578 AVSS_n557 0.249752
R12084 AVSS_n3507 AVSS_n3506 0.2453
R12085 AVSS_n2362 AVSS_n0 0.2447
R12086 AVSS_n2423 AVSS_n2420 0.241078
R12087 AVSS_n3508 AVSS_n0 0.23477
R12088 AVSS_n2398 AVSS_n2397 0.22479
R12089 AVSS_n3433 AVSS_n3432 0.224607
R12090 AVSS_n3425 AVSS_n131 0.2229
R12091 AVSS_n3427 AVSS_n3426 0.221804
R12092 AVSS_n756 AVSS_n755 0.220529
R12093 AVSS_n2787 AVSS_n2786 0.220511
R12094 AVSS_n3429 AVSS_n3428 0.21997
R12095 AVSS_n3431 AVSS_n129 0.218137
R12096 AVSS_n1306 AVSS_n1059 0.207287
R12097 AVSS_n2400 AVSS_n2399 0.205685
R12098 AVSS_n133 AVSS_n0 0.188
R12099 AVSS_n2427 AVSS_n2420 0.180789
R12100 AVSS_n3506 AVSS_n2 0.1805
R12101 AVSS_n2402 AVSS_n2362 0.179
R12102 AVSS_n2402 AVSS_n2401 0.1745
R12103 AVSS_n735 AVSS_n734 0.172516
R12104 AVSS_n3501 AVSS_n3500 0.159167
R12105 AVSS_n1181 AVSS_n1070 0.158425
R12106 AVSS_n593 AVSS_n585 0.158073
R12107 AVSS_n2780 AVSS_n1425 0.15769
R12108 AVSS_n579 AVSS_n578 0.1545
R12109 AVSS_n1280 AVSS_n1279 0.141314
R12110 AVSS_n746 AVSS_n745 0.132772
R12111 AVSS_n419 AVSS_n351 0.130983
R12112 AVSS_n1348 AVSS_n1283 0.130662
R12113 AVSS_n1422 AVSS_n1283 0.130001
R12114 AVSS_n416 AVSS_n351 0.129928
R12115 AVSS_n611 AVSS_n610 0.125358
R12116 AVSS_n1356 AVSS_n1355 0.125167
R12117 AVSS_n1389 AVSS_n1388 0.125167
R12118 AVSS_n451 AVSS_n414 0.125167
R12119 AVSS_n3502 AVSS_n3501 0.122538
R12120 AVSS_n748 AVSS_n454 0.118464
R12121 AVSS_n2793 AVSS_n1161 0.11662
R12122 AVSS_n3504 AVSS_n4 0.0948368
R12123 AVSS_n3502 AVSS_n3 0.0753846
R12124 AVSS_n633 AVSS_n455 0.0531384
R12125 AVSS_n1183 AVSS_n1182 0.0357621
R12126 AVSS_n1322 AVSS_n1321 0.0357621
R12127 AVSS_n2788 AVSS_n1243 0.0357621
R12128 AVSS_n1234 AVSS_n1203 0.0357621
R12129 AVSS_n1212 AVSS_n1208 0.0357621
R12130 AVSS_n596 AVSS_n463 0.0357621
R12131 AVSS_n646 AVSS_n511 0.0357621
R12132 AVSS_n515 AVSS_n513 0.0357621
R12133 AVSS_n612 AVSS_n546 0.0357621
R12134 AVSS_n2793 AVSS_n1160 0.0355967
R12135 AVSS_n1512 AVSS_n1511 0.0345708
R12136 AVSS_n1541 AVSS_n1512 0.0342323
R12137 AVSS_n2757 AVSS_n2193 0.02675
R12138 AVSS_n3052 AVSS_n3051 0.025726
R12139 AVSS_n3051 AVSS_n3050 0.025726
R12140 AVSS_n3225 AVSS_n3224 0.025726
R12141 AVSS_n3226 AVSS_n3225 0.025726
R12142 AVSS_n217 AVSS_n216 0.025726
R12143 AVSS_n216 AVSS_n186 0.025726
R12144 AVSS_n3236 AVSS_n3235 0.025726
R12145 AVSS_n3237 AVSS_n3236 0.025726
R12146 AVSS_n3420 AVSS_n135 0.025726
R12147 AVSS_n3480 AVSS_n3479 0.025726
R12148 AVSS_n3481 AVSS_n3480 0.025726
R12149 AVSS_n3485 AVSS_n3484 0.025726
R12150 AVSS_n3486 AVSS_n3485 0.025726
R12151 AVSS_n2300 AVSS_n2299 0.025726
R12152 AVSS_n2299 AVSS_n2298 0.025726
R12153 AVSS_n2249 AVSS_n1005 0.025726
R12154 AVSS_n1039 AVSS_n1005 0.025726
R12155 AVSS_n1044 AVSS_n1043 0.025726
R12156 AVSS_n1045 AVSS_n1044 0.025726
R12157 AVSS_n1058 AVSS_n1057 0.025726
R12158 AVSS_n2391 AVSS_n2390 0.025726
R12159 AVSS_n2390 AVSS_n2389 0.025726
R12160 AVSS_n1556 AVSS_n1555 0.025726
R12161 AVSS_n2611 AVSS_n1556 0.025726
R12162 AVSS_n2213 AVSS_n2212 0.025726
R12163 AVSS_n2212 AVSS_n2211 0.025726
R12164 AVSS_n2195 AVSS_n1914 0.025726
R12165 AVSS_n2139 AVSS_n1914 0.025726
R12166 AVSS_n2114 AVSS_n2113 0.025726
R12167 AVSS_n2113 AVSS_n2112 0.025726
R12168 AVSS_n3134 AVSS_n3133 0.017
R12169 AVSS_n3135 AVSS_n3134 0.017
R12170 AVSS_n3136 AVSS_n3135 0.017
R12171 AVSS_n3137 AVSS_n3136 0.017
R12172 AVSS_n3138 AVSS_n3137 0.017
R12173 AVSS_n3139 AVSS_n3138 0.017
R12174 AVSS_n3140 AVSS_n3139 0.017
R12175 AVSS_n3141 AVSS_n3140 0.017
R12176 AVSS_n3142 AVSS_n3141 0.017
R12177 AVSS_n3143 AVSS_n3142 0.017
R12178 AVSS_n3144 AVSS_n3143 0.017
R12179 AVSS_n3145 AVSS_n3144 0.017
R12180 AVSS_n3146 AVSS_n3145 0.017
R12181 AVSS_n3147 AVSS_n3146 0.017
R12182 AVSS_n3148 AVSS_n3147 0.017
R12183 AVSS_n3149 AVSS_n3148 0.017
R12184 AVSS_n3150 AVSS_n3149 0.017
R12185 AVSS_n3151 AVSS_n3150 0.017
R12186 AVSS_n3152 AVSS_n3151 0.017
R12187 AVSS_n3153 AVSS_n3152 0.017
R12188 AVSS_n3154 AVSS_n3153 0.017
R12189 AVSS_n3155 AVSS_n3154 0.017
R12190 AVSS_n3156 AVSS_n3155 0.017
R12191 AVSS_n3157 AVSS_n3156 0.017
R12192 AVSS_n3158 AVSS_n3157 0.017
R12193 AVSS_n3159 AVSS_n3158 0.017
R12194 AVSS_n3160 AVSS_n3159 0.017
R12195 AVSS_n3161 AVSS_n3160 0.017
R12196 AVSS_n3162 AVSS_n3161 0.017
R12197 AVSS_n3163 AVSS_n3162 0.017
R12198 AVSS_n3164 AVSS_n3163 0.017
R12199 AVSS_n3165 AVSS_n3164 0.017
R12200 AVSS_n3166 AVSS_n3165 0.017
R12201 AVSS_n3167 AVSS_n3166 0.017
R12202 AVSS_n3168 AVSS_n3167 0.017
R12203 AVSS_n3169 AVSS_n3168 0.017
R12204 AVSS_n3170 AVSS_n3169 0.017
R12205 AVSS_n3171 AVSS_n3170 0.017
R12206 AVSS_n3172 AVSS_n3171 0.017
R12207 AVSS_n3172 AVSS_n3132 0.017
R12208 AVSS_n3132 AVSS_n3131 0.017
R12209 AVSS_n3131 AVSS_n3130 0.017
R12210 AVSS_n3130 AVSS_n3129 0.017
R12211 AVSS_n3129 AVSS_n3128 0.017
R12212 AVSS_n3128 AVSS_n3127 0.017
R12213 AVSS_n3127 AVSS_n3126 0.017
R12214 AVSS_n3126 AVSS_n3125 0.017
R12215 AVSS_n3125 AVSS_n3124 0.017
R12216 AVSS_n3124 AVSS_n3123 0.017
R12217 AVSS_n3123 AVSS_n3122 0.017
R12218 AVSS_n3122 AVSS_n3121 0.017
R12219 AVSS_n3121 AVSS_n3120 0.017
R12220 AVSS_n3120 AVSS_n3119 0.017
R12221 AVSS_n3117 AVSS_n3116 0.017
R12222 AVSS_n3116 AVSS_n3115 0.017
R12223 AVSS_n3115 AVSS_n3114 0.017
R12224 AVSS_n3114 AVSS_n3113 0.017
R12225 AVSS_n3113 AVSS_n3112 0.017
R12226 AVSS_n3112 AVSS_n3111 0.017
R12227 AVSS_n3111 AVSS_n3110 0.017
R12228 AVSS_n3110 AVSS_n3109 0.017
R12229 AVSS_n3109 AVSS_n3108 0.017
R12230 AVSS_n3108 AVSS_n3107 0.017
R12231 AVSS_n3107 AVSS_n3106 0.017
R12232 AVSS_n3106 AVSS_n3105 0.017
R12233 AVSS_n3105 AVSS_n3104 0.017
R12234 AVSS_n3104 AVSS_n3103 0.017
R12235 AVSS_n3103 AVSS_n3102 0.017
R12236 AVSS_n3102 AVSS_n3101 0.017
R12237 AVSS_n3101 AVSS_n3100 0.017
R12238 AVSS_n3100 AVSS_n3099 0.017
R12239 AVSS_n3099 AVSS_n3098 0.017
R12240 AVSS_n3098 AVSS_n3097 0.017
R12241 AVSS_n3097 AVSS_n3096 0.017
R12242 AVSS_n3096 AVSS_n3095 0.017
R12243 AVSS_n3095 AVSS_n3094 0.017
R12244 AVSS_n3094 AVSS_n3093 0.017
R12245 AVSS_n3093 AVSS_n3092 0.017
R12246 AVSS_n3092 AVSS_n3091 0.017
R12247 AVSS_n3091 AVSS_n3090 0.017
R12248 AVSS_n3090 AVSS_n3089 0.017
R12249 AVSS_n3089 AVSS_n3088 0.017
R12250 AVSS_n3088 AVSS_n3087 0.017
R12251 AVSS_n3087 AVSS_n3086 0.017
R12252 AVSS_n3086 AVSS_n3085 0.017
R12253 AVSS_n3085 AVSS_n3084 0.017
R12254 AVSS_n3084 AVSS_n3083 0.017
R12255 AVSS_n3083 AVSS_n3082 0.017
R12256 AVSS_n3082 AVSS_n3081 0.017
R12257 AVSS_n3081 AVSS_n3080 0.017
R12258 AVSS_n3080 AVSS_n3079 0.017
R12259 AVSS_n3079 AVSS_n3078 0.017
R12260 AVSS_n3078 AVSS_n3077 0.017
R12261 AVSS_n3077 AVSS_n3076 0.017
R12262 AVSS_n3076 AVSS_n3075 0.017
R12263 AVSS_n3075 AVSS_n3074 0.017
R12264 AVSS_n3074 AVSS_n3073 0.017
R12265 AVSS_n3073 AVSS_n3072 0.017
R12266 AVSS_n3072 AVSS_n3071 0.017
R12267 AVSS_n3071 AVSS_n3070 0.017
R12268 AVSS_n3070 AVSS_n3069 0.017
R12269 AVSS_n3069 AVSS_n3068 0.017
R12270 AVSS_n3068 AVSS_n3067 0.017
R12271 AVSS_n3067 AVSS_n3066 0.017
R12272 AVSS_n3066 AVSS_n3065 0.017
R12273 AVSS_n3065 AVSS_n3064 0.017
R12274 AVSS_n3064 AVSS_n3063 0.017
R12275 AVSS_n3063 AVSS_n3062 0.017
R12276 AVSS_n3062 AVSS_n3061 0.017
R12277 AVSS_n3061 AVSS_n3060 0.017
R12278 AVSS_n3060 AVSS_n3059 0.017
R12279 AVSS_n3059 AVSS_n3058 0.017
R12280 AVSS_n3058 AVSS_n3057 0.017
R12281 AVSS_n3057 AVSS_n3056 0.017
R12282 AVSS_n3056 AVSS_n3055 0.017
R12283 AVSS_n3055 AVSS_n3054 0.017
R12284 AVSS_n3054 AVSS_n3053 0.017
R12285 AVSS_n3053 AVSS_n3052 0.017
R12286 AVSS_n3050 AVSS_n3049 0.017
R12287 AVSS_n3049 AVSS_n3048 0.017
R12288 AVSS_n3048 AVSS_n3047 0.017
R12289 AVSS_n3047 AVSS_n3046 0.017
R12290 AVSS_n3046 AVSS_n3045 0.017
R12291 AVSS_n3045 AVSS_n3044 0.017
R12292 AVSS_n3044 AVSS_n3043 0.017
R12293 AVSS_n3043 AVSS_n3042 0.017
R12294 AVSS_n3042 AVSS_n3041 0.017
R12295 AVSS_n3041 AVSS_n3040 0.017
R12296 AVSS_n3040 AVSS_n3039 0.017
R12297 AVSS_n3039 AVSS_n3038 0.017
R12298 AVSS_n3038 AVSS_n3037 0.017
R12299 AVSS_n3037 AVSS_n3036 0.017
R12300 AVSS_n3036 AVSS_n3035 0.017
R12301 AVSS_n3035 AVSS_n3034 0.017
R12302 AVSS_n3034 AVSS_n3033 0.017
R12303 AVSS_n3033 AVSS_n3032 0.017
R12304 AVSS_n3032 AVSS_n3031 0.017
R12305 AVSS_n3031 AVSS_n3030 0.017
R12306 AVSS_n3030 AVSS_n3029 0.017
R12307 AVSS_n3029 AVSS_n3028 0.017
R12308 AVSS_n3028 AVSS_n3027 0.017
R12309 AVSS_n3027 AVSS_n3026 0.017
R12310 AVSS_n3026 AVSS_n3025 0.017
R12311 AVSS_n3025 AVSS_n3024 0.017
R12312 AVSS_n3024 AVSS_n3023 0.017
R12313 AVSS_n3023 AVSS_n3022 0.017
R12314 AVSS_n3022 AVSS_n3021 0.017
R12315 AVSS_n3021 AVSS_n3020 0.017
R12316 AVSS_n3020 AVSS_n3019 0.017
R12317 AVSS_n3019 AVSS_n3018 0.017
R12318 AVSS_n3018 AVSS_n3017 0.017
R12319 AVSS_n3017 AVSS_n3016 0.017
R12320 AVSS_n3016 AVSS_n3015 0.017
R12321 AVSS_n3015 AVSS_n220 0.017
R12322 AVSS_n3224 AVSS_n220 0.017
R12323 AVSS_n3227 AVSS_n3226 0.017
R12324 AVSS_n3228 AVSS_n3227 0.017
R12325 AVSS_n3229 AVSS_n3228 0.017
R12326 AVSS_n3229 AVSS_n219 0.017
R12327 AVSS_n219 AVSS_n218 0.017
R12328 AVSS_n218 AVSS_n217 0.017
R12329 AVSS_n3235 AVSS_n186 0.017
R12330 AVSS_n3238 AVSS_n3237 0.017
R12331 AVSS_n3239 AVSS_n3238 0.017
R12332 AVSS_n3240 AVSS_n3239 0.017
R12333 AVSS_n3241 AVSS_n3240 0.017
R12334 AVSS_n3242 AVSS_n3241 0.017
R12335 AVSS_n3243 AVSS_n3242 0.017
R12336 AVSS_n3244 AVSS_n3243 0.017
R12337 AVSS_n3245 AVSS_n3244 0.017
R12338 AVSS_n3246 AVSS_n3245 0.017
R12339 AVSS_n3247 AVSS_n3246 0.017
R12340 AVSS_n3248 AVSS_n3247 0.017
R12341 AVSS_n3249 AVSS_n3248 0.017
R12342 AVSS_n3250 AVSS_n3249 0.017
R12343 AVSS_n3250 AVSS_n185 0.017
R12344 AVSS_n185 AVSS_n135 0.017
R12345 AVSS_n3421 AVSS_n134 0.017
R12346 AVSS_n3317 AVSS_n134 0.017
R12347 AVSS_n3318 AVSS_n3317 0.017
R12348 AVSS_n3319 AVSS_n3318 0.017
R12349 AVSS_n3320 AVSS_n3319 0.017
R12350 AVSS_n3321 AVSS_n3320 0.017
R12351 AVSS_n3322 AVSS_n3321 0.017
R12352 AVSS_n3323 AVSS_n3322 0.017
R12353 AVSS_n3324 AVSS_n3323 0.017
R12354 AVSS_n3325 AVSS_n3324 0.017
R12355 AVSS_n3371 AVSS_n3325 0.017
R12356 AVSS_n3372 AVSS_n3371 0.017
R12357 AVSS_n3373 AVSS_n3372 0.017
R12358 AVSS_n3374 AVSS_n3373 0.017
R12359 AVSS_n3375 AVSS_n3374 0.017
R12360 AVSS_n3376 AVSS_n3375 0.017
R12361 AVSS_n3377 AVSS_n3376 0.017
R12362 AVSS_n3378 AVSS_n3377 0.017
R12363 AVSS_n3379 AVSS_n3378 0.017
R12364 AVSS_n3380 AVSS_n3379 0.017
R12365 AVSS_n3381 AVSS_n3380 0.017
R12366 AVSS_n3382 AVSS_n3381 0.017
R12367 AVSS_n3383 AVSS_n3382 0.017
R12368 AVSS_n3384 AVSS_n3383 0.017
R12369 AVSS_n3385 AVSS_n3384 0.017
R12370 AVSS_n3386 AVSS_n3385 0.017
R12371 AVSS_n3387 AVSS_n3386 0.017
R12372 AVSS_n3388 AVSS_n3387 0.017
R12373 AVSS_n3389 AVSS_n3388 0.017
R12374 AVSS_n3390 AVSS_n3389 0.017
R12375 AVSS_n3391 AVSS_n3390 0.017
R12376 AVSS_n3392 AVSS_n3391 0.017
R12377 AVSS_n3393 AVSS_n3392 0.017
R12378 AVSS_n3394 AVSS_n3393 0.017
R12379 AVSS_n3395 AVSS_n3394 0.017
R12380 AVSS_n3396 AVSS_n3395 0.017
R12381 AVSS_n3397 AVSS_n3396 0.017
R12382 AVSS_n3398 AVSS_n3397 0.017
R12383 AVSS_n3399 AVSS_n3398 0.017
R12384 AVSS_n3400 AVSS_n3399 0.017
R12385 AVSS_n3401 AVSS_n3400 0.017
R12386 AVSS_n3402 AVSS_n3401 0.017
R12387 AVSS_n3403 AVSS_n3402 0.017
R12388 AVSS_n3404 AVSS_n3403 0.017
R12389 AVSS_n3405 AVSS_n3404 0.017
R12390 AVSS_n3406 AVSS_n3405 0.017
R12391 AVSS_n3407 AVSS_n3406 0.017
R12392 AVSS_n3408 AVSS_n3407 0.017
R12393 AVSS_n3409 AVSS_n3408 0.017
R12394 AVSS_n3410 AVSS_n3409 0.017
R12395 AVSS_n3411 AVSS_n3410 0.017
R12396 AVSS_n3412 AVSS_n3411 0.017
R12397 AVSS_n3413 AVSS_n3412 0.017
R12398 AVSS_n3414 AVSS_n3413 0.017
R12399 AVSS_n3415 AVSS_n3414 0.017
R12400 AVSS_n3416 AVSS_n3415 0.017
R12401 AVSS_n3416 AVSS_n3316 0.017
R12402 AVSS_n3434 AVSS_n3433 0.017
R12403 AVSS_n3435 AVSS_n3434 0.017
R12404 AVSS_n3436 AVSS_n3435 0.017
R12405 AVSS_n3437 AVSS_n3436 0.017
R12406 AVSS_n3438 AVSS_n3437 0.017
R12407 AVSS_n3439 AVSS_n3438 0.017
R12408 AVSS_n3440 AVSS_n3439 0.017
R12409 AVSS_n3441 AVSS_n3440 0.017
R12410 AVSS_n3442 AVSS_n3441 0.017
R12411 AVSS_n3443 AVSS_n3442 0.017
R12412 AVSS_n3444 AVSS_n3443 0.017
R12413 AVSS_n3445 AVSS_n3444 0.017
R12414 AVSS_n3446 AVSS_n3445 0.017
R12415 AVSS_n3447 AVSS_n3446 0.017
R12416 AVSS_n3448 AVSS_n3447 0.017
R12417 AVSS_n3451 AVSS_n3448 0.017
R12418 AVSS_n3452 AVSS_n3451 0.017
R12419 AVSS_n3453 AVSS_n3452 0.017
R12420 AVSS_n3454 AVSS_n3453 0.017
R12421 AVSS_n3455 AVSS_n3454 0.017
R12422 AVSS_n3456 AVSS_n3455 0.017
R12423 AVSS_n3457 AVSS_n3456 0.017
R12424 AVSS_n3458 AVSS_n3457 0.017
R12425 AVSS_n3459 AVSS_n3458 0.017
R12426 AVSS_n3460 AVSS_n3459 0.017
R12427 AVSS_n3461 AVSS_n3460 0.017
R12428 AVSS_n3462 AVSS_n3461 0.017
R12429 AVSS_n3463 AVSS_n3462 0.017
R12430 AVSS_n3464 AVSS_n3463 0.017
R12431 AVSS_n3465 AVSS_n3464 0.017
R12432 AVSS_n3466 AVSS_n3465 0.017
R12433 AVSS_n3467 AVSS_n3466 0.017
R12434 AVSS_n3468 AVSS_n3467 0.017
R12435 AVSS_n3469 AVSS_n3468 0.017
R12436 AVSS_n3469 AVSS_n128 0.017
R12437 AVSS_n128 AVSS_n124 0.017
R12438 AVSS_n124 AVSS_n123 0.017
R12439 AVSS_n123 AVSS_n122 0.017
R12440 AVSS_n122 AVSS_n121 0.017
R12441 AVSS_n121 AVSS_n120 0.017
R12442 AVSS_n120 AVSS_n119 0.017
R12443 AVSS_n119 AVSS_n33 0.017
R12444 AVSS_n3479 AVSS_n33 0.017
R12445 AVSS_n3482 AVSS_n3481 0.017
R12446 AVSS_n3483 AVSS_n3482 0.017
R12447 AVSS_n3484 AVSS_n3483 0.017
R12448 AVSS_n3487 AVSS_n3486 0.017
R12449 AVSS_n3488 AVSS_n3487 0.017
R12450 AVSS_n3489 AVSS_n3488 0.017
R12451 AVSS_n3490 AVSS_n3489 0.017
R12452 AVSS_n3491 AVSS_n3490 0.017
R12453 AVSS_n3491 AVSS_n32 0.017
R12454 AVSS_n2308 AVSS_n841 0.017
R12455 AVSS_n2309 AVSS_n2308 0.017
R12456 AVSS_n2310 AVSS_n2309 0.017
R12457 AVSS_n2311 AVSS_n2310 0.017
R12458 AVSS_n2312 AVSS_n2311 0.017
R12459 AVSS_n2313 AVSS_n2312 0.017
R12460 AVSS_n2314 AVSS_n2313 0.017
R12461 AVSS_n2315 AVSS_n2314 0.017
R12462 AVSS_n2316 AVSS_n2315 0.017
R12463 AVSS_n2317 AVSS_n2316 0.017
R12464 AVSS_n2318 AVSS_n2317 0.017
R12465 AVSS_n2319 AVSS_n2318 0.017
R12466 AVSS_n2320 AVSS_n2319 0.017
R12467 AVSS_n2321 AVSS_n2320 0.017
R12468 AVSS_n2322 AVSS_n2321 0.017
R12469 AVSS_n2323 AVSS_n2322 0.017
R12470 AVSS_n2324 AVSS_n2323 0.017
R12471 AVSS_n2325 AVSS_n2324 0.017
R12472 AVSS_n2326 AVSS_n2325 0.017
R12473 AVSS_n2327 AVSS_n2326 0.017
R12474 AVSS_n2328 AVSS_n2327 0.017
R12475 AVSS_n2329 AVSS_n2328 0.017
R12476 AVSS_n2330 AVSS_n2329 0.017
R12477 AVSS_n2331 AVSS_n2330 0.017
R12478 AVSS_n2332 AVSS_n2331 0.017
R12479 AVSS_n2333 AVSS_n2332 0.017
R12480 AVSS_n2334 AVSS_n2333 0.017
R12481 AVSS_n2335 AVSS_n2334 0.017
R12482 AVSS_n2336 AVSS_n2335 0.017
R12483 AVSS_n2337 AVSS_n2336 0.017
R12484 AVSS_n2338 AVSS_n2337 0.017
R12485 AVSS_n2339 AVSS_n2338 0.017
R12486 AVSS_n2340 AVSS_n2339 0.017
R12487 AVSS_n2341 AVSS_n2340 0.017
R12488 AVSS_n2342 AVSS_n2341 0.017
R12489 AVSS_n2343 AVSS_n2342 0.017
R12490 AVSS_n2344 AVSS_n2343 0.017
R12491 AVSS_n2345 AVSS_n2344 0.017
R12492 AVSS_n2346 AVSS_n2345 0.017
R12493 AVSS_n2347 AVSS_n2346 0.017
R12494 AVSS_n2348 AVSS_n2347 0.017
R12495 AVSS_n2349 AVSS_n2348 0.017
R12496 AVSS_n2350 AVSS_n2349 0.017
R12497 AVSS_n2351 AVSS_n2350 0.017
R12498 AVSS_n2352 AVSS_n2351 0.017
R12499 AVSS_n2353 AVSS_n2352 0.017
R12500 AVSS_n2354 AVSS_n2353 0.017
R12501 AVSS_n2355 AVSS_n2354 0.017
R12502 AVSS_n2356 AVSS_n2355 0.017
R12503 AVSS_n2357 AVSS_n2356 0.017
R12504 AVSS_n2358 AVSS_n2357 0.017
R12505 AVSS_n2359 AVSS_n2358 0.017
R12506 AVSS_n2360 AVSS_n2359 0.017
R12507 AVSS_n2307 AVSS_n2306 0.017
R12508 AVSS_n2306 AVSS_n2305 0.017
R12509 AVSS_n2305 AVSS_n2301 0.017
R12510 AVSS_n2301 AVSS_n2300 0.017
R12511 AVSS_n2298 AVSS_n2297 0.017
R12512 AVSS_n2297 AVSS_n2296 0.017
R12513 AVSS_n2296 AVSS_n2295 0.017
R12514 AVSS_n2295 AVSS_n2294 0.017
R12515 AVSS_n2294 AVSS_n2293 0.017
R12516 AVSS_n2293 AVSS_n2292 0.017
R12517 AVSS_n2292 AVSS_n2291 0.017
R12518 AVSS_n2291 AVSS_n2290 0.017
R12519 AVSS_n2290 AVSS_n2289 0.017
R12520 AVSS_n2289 AVSS_n2288 0.017
R12521 AVSS_n2288 AVSS_n2287 0.017
R12522 AVSS_n2287 AVSS_n2286 0.017
R12523 AVSS_n2286 AVSS_n2285 0.017
R12524 AVSS_n2285 AVSS_n2284 0.017
R12525 AVSS_n2284 AVSS_n2283 0.017
R12526 AVSS_n2283 AVSS_n2282 0.017
R12527 AVSS_n2282 AVSS_n2281 0.017
R12528 AVSS_n2281 AVSS_n2280 0.017
R12529 AVSS_n2280 AVSS_n2279 0.017
R12530 AVSS_n2279 AVSS_n2278 0.017
R12531 AVSS_n2278 AVSS_n2277 0.017
R12532 AVSS_n2277 AVSS_n2276 0.017
R12533 AVSS_n2276 AVSS_n2275 0.017
R12534 AVSS_n2275 AVSS_n2274 0.017
R12535 AVSS_n2274 AVSS_n2273 0.017
R12536 AVSS_n2273 AVSS_n2272 0.017
R12537 AVSS_n2272 AVSS_n2271 0.017
R12538 AVSS_n2271 AVSS_n2270 0.017
R12539 AVSS_n2270 AVSS_n2269 0.017
R12540 AVSS_n2269 AVSS_n2268 0.017
R12541 AVSS_n2268 AVSS_n2267 0.017
R12542 AVSS_n2267 AVSS_n2266 0.017
R12543 AVSS_n2266 AVSS_n2265 0.017
R12544 AVSS_n2265 AVSS_n2264 0.017
R12545 AVSS_n2264 AVSS_n2263 0.017
R12546 AVSS_n2263 AVSS_n2262 0.017
R12547 AVSS_n2262 AVSS_n2261 0.017
R12548 AVSS_n2261 AVSS_n2260 0.017
R12549 AVSS_n2260 AVSS_n2259 0.017
R12550 AVSS_n2259 AVSS_n2258 0.017
R12551 AVSS_n2258 AVSS_n2257 0.017
R12552 AVSS_n2257 AVSS_n2256 0.017
R12553 AVSS_n2256 AVSS_n2255 0.017
R12554 AVSS_n2255 AVSS_n2254 0.017
R12555 AVSS_n2254 AVSS_n2253 0.017
R12556 AVSS_n2253 AVSS_n2252 0.017
R12557 AVSS_n2252 AVSS_n2251 0.017
R12558 AVSS_n2251 AVSS_n2250 0.017
R12559 AVSS_n2250 AVSS_n2249 0.017
R12560 AVSS_n1040 AVSS_n1039 0.017
R12561 AVSS_n1041 AVSS_n1040 0.017
R12562 AVSS_n1042 AVSS_n1041 0.017
R12563 AVSS_n1043 AVSS_n1042 0.017
R12564 AVSS_n1046 AVSS_n1045 0.017
R12565 AVSS_n1047 AVSS_n1046 0.017
R12566 AVSS_n1048 AVSS_n1047 0.017
R12567 AVSS_n1049 AVSS_n1048 0.017
R12568 AVSS_n1054 AVSS_n1049 0.017
R12569 AVSS_n1055 AVSS_n1054 0.017
R12570 AVSS_n1056 AVSS_n1055 0.017
R12571 AVSS_n1057 AVSS_n1056 0.017
R12572 AVSS_n2397 AVSS_n2396 0.017
R12573 AVSS_n2396 AVSS_n2392 0.017
R12574 AVSS_n2392 AVSS_n2391 0.017
R12575 AVSS_n2389 AVSS_n2388 0.017
R12576 AVSS_n2388 AVSS_n2387 0.017
R12577 AVSS_n2387 AVSS_n2386 0.017
R12578 AVSS_n2386 AVSS_n2385 0.017
R12579 AVSS_n2385 AVSS_n2384 0.017
R12580 AVSS_n2384 AVSS_n2383 0.017
R12581 AVSS_n2383 AVSS_n2382 0.017
R12582 AVSS_n2382 AVSS_n2381 0.017
R12583 AVSS_n2381 AVSS_n2380 0.017
R12584 AVSS_n2380 AVSS_n2379 0.017
R12585 AVSS_n2379 AVSS_n2378 0.017
R12586 AVSS_n2378 AVSS_n2377 0.017
R12587 AVSS_n2377 AVSS_n2376 0.017
R12588 AVSS_n2376 AVSS_n2375 0.017
R12589 AVSS_n2375 AVSS_n2374 0.017
R12590 AVSS_n2374 AVSS_n2373 0.017
R12591 AVSS_n2373 AVSS_n2372 0.017
R12592 AVSS_n2372 AVSS_n2371 0.017
R12593 AVSS_n2371 AVSS_n2370 0.017
R12594 AVSS_n2370 AVSS_n2369 0.017
R12595 AVSS_n2369 AVSS_n2368 0.017
R12596 AVSS_n2368 AVSS_n2367 0.017
R12597 AVSS_n2367 AVSS_n2366 0.017
R12598 AVSS_n2366 AVSS_n2365 0.017
R12599 AVSS_n2365 AVSS_n2364 0.017
R12600 AVSS_n2364 AVSS_n2363 0.017
R12601 AVSS_n2363 AVSS_n1451 0.017
R12602 AVSS_n1509 AVSS_n1451 0.017
R12603 AVSS_n1510 AVSS_n1509 0.017
R12604 AVSS_n1511 AVSS_n1510 0.017
R12605 AVSS_n1547 AVSS_n1541 0.017
R12606 AVSS_n1548 AVSS_n1547 0.017
R12607 AVSS_n1549 AVSS_n1548 0.017
R12608 AVSS_n1550 AVSS_n1549 0.017
R12609 AVSS_n1551 AVSS_n1550 0.017
R12610 AVSS_n1552 AVSS_n1551 0.017
R12611 AVSS_n1553 AVSS_n1552 0.017
R12612 AVSS_n1554 AVSS_n1553 0.017
R12613 AVSS_n1555 AVSS_n1554 0.017
R12614 AVSS_n2612 AVSS_n2611 0.017
R12615 AVSS_n2613 AVSS_n2612 0.017
R12616 AVSS_n2614 AVSS_n2613 0.017
R12617 AVSS_n2617 AVSS_n2616 0.017
R12618 AVSS_n2618 AVSS_n2617 0.017
R12619 AVSS_n2619 AVSS_n2618 0.017
R12620 AVSS_n2620 AVSS_n2619 0.017
R12621 AVSS_n2621 AVSS_n2620 0.017
R12622 AVSS_n2622 AVSS_n2621 0.017
R12623 AVSS_n2623 AVSS_n2622 0.017
R12624 AVSS_n2624 AVSS_n2623 0.017
R12625 AVSS_n2625 AVSS_n2624 0.017
R12626 AVSS_n2626 AVSS_n2625 0.017
R12627 AVSS_n2627 AVSS_n2626 0.017
R12628 AVSS_n2628 AVSS_n2627 0.017
R12629 AVSS_n2629 AVSS_n2628 0.017
R12630 AVSS_n2630 AVSS_n2629 0.017
R12631 AVSS_n2631 AVSS_n2630 0.017
R12632 AVSS_n2632 AVSS_n2631 0.017
R12633 AVSS_n2633 AVSS_n2632 0.017
R12634 AVSS_n2634 AVSS_n2633 0.017
R12635 AVSS_n2635 AVSS_n2634 0.017
R12636 AVSS_n2636 AVSS_n2635 0.017
R12637 AVSS_n2637 AVSS_n2636 0.017
R12638 AVSS_n2638 AVSS_n2637 0.017
R12639 AVSS_n2639 AVSS_n2638 0.017
R12640 AVSS_n2640 AVSS_n2639 0.017
R12641 AVSS_n2641 AVSS_n2640 0.017
R12642 AVSS_n2642 AVSS_n2641 0.017
R12643 AVSS_n2643 AVSS_n2642 0.017
R12644 AVSS_n2644 AVSS_n2643 0.017
R12645 AVSS_n2645 AVSS_n2644 0.017
R12646 AVSS_n2646 AVSS_n2645 0.017
R12647 AVSS_n2647 AVSS_n2646 0.017
R12648 AVSS_n2648 AVSS_n2647 0.017
R12649 AVSS_n2649 AVSS_n2648 0.017
R12650 AVSS_n2650 AVSS_n2649 0.017
R12651 AVSS_n2651 AVSS_n2650 0.017
R12652 AVSS_n2652 AVSS_n2651 0.017
R12653 AVSS_n2653 AVSS_n2652 0.017
R12654 AVSS_n2654 AVSS_n2653 0.017
R12655 AVSS_n2655 AVSS_n2654 0.017
R12656 AVSS_n2656 AVSS_n2655 0.017
R12657 AVSS_n2657 AVSS_n2656 0.017
R12658 AVSS_n2658 AVSS_n2657 0.017
R12659 AVSS_n2659 AVSS_n2658 0.017
R12660 AVSS_n2660 AVSS_n2659 0.017
R12661 AVSS_n2661 AVSS_n2660 0.017
R12662 AVSS_n2662 AVSS_n2661 0.017
R12663 AVSS_n2663 AVSS_n2662 0.017
R12664 AVSS_n2664 AVSS_n2663 0.017
R12665 AVSS_n2665 AVSS_n2664 0.017
R12666 AVSS_n2666 AVSS_n2665 0.017
R12667 AVSS_n2667 AVSS_n2666 0.017
R12668 AVSS_n2668 AVSS_n2667 0.017
R12669 AVSS_n2669 AVSS_n2668 0.017
R12670 AVSS_n2670 AVSS_n2669 0.017
R12671 AVSS_n2671 AVSS_n2670 0.017
R12672 AVSS_n2672 AVSS_n2671 0.017
R12673 AVSS_n2673 AVSS_n2672 0.017
R12674 AVSS_n2674 AVSS_n2673 0.017
R12675 AVSS_n2675 AVSS_n2674 0.017
R12676 AVSS_n2676 AVSS_n2675 0.017
R12677 AVSS_n2677 AVSS_n2676 0.017
R12678 AVSS_n2678 AVSS_n2677 0.017
R12679 AVSS_n2679 AVSS_n2678 0.017
R12680 AVSS_n2680 AVSS_n2679 0.017
R12681 AVSS_n2681 AVSS_n2680 0.017
R12682 AVSS_n2682 AVSS_n2681 0.017
R12683 AVSS_n2683 AVSS_n2682 0.017
R12684 AVSS_n2684 AVSS_n2683 0.017
R12685 AVSS_n2685 AVSS_n2684 0.017
R12686 AVSS_n2686 AVSS_n2685 0.017
R12687 AVSS_n2687 AVSS_n2686 0.017
R12688 AVSS_n2688 AVSS_n2687 0.017
R12689 AVSS_n2689 AVSS_n2688 0.017
R12690 AVSS_n2690 AVSS_n2689 0.017
R12691 AVSS_n2691 AVSS_n2690 0.017
R12692 AVSS_n2692 AVSS_n2691 0.017
R12693 AVSS_n2693 AVSS_n2692 0.017
R12694 AVSS_n2694 AVSS_n2693 0.017
R12695 AVSS_n2695 AVSS_n2694 0.017
R12696 AVSS_n2696 AVSS_n2695 0.017
R12697 AVSS_n2697 AVSS_n2696 0.017
R12698 AVSS_n2698 AVSS_n2697 0.017
R12699 AVSS_n2699 AVSS_n2698 0.017
R12700 AVSS_n2700 AVSS_n2699 0.017
R12701 AVSS_n2701 AVSS_n2700 0.017
R12702 AVSS_n2702 AVSS_n2701 0.017
R12703 AVSS_n2703 AVSS_n2702 0.017
R12704 AVSS_n2704 AVSS_n2703 0.017
R12705 AVSS_n2705 AVSS_n2704 0.017
R12706 AVSS_n2706 AVSS_n2705 0.017
R12707 AVSS_n2707 AVSS_n2706 0.017
R12708 AVSS_n2708 AVSS_n2707 0.017
R12709 AVSS_n2709 AVSS_n2708 0.017
R12710 AVSS_n2710 AVSS_n2709 0.017
R12711 AVSS_n2711 AVSS_n2710 0.017
R12712 AVSS_n2712 AVSS_n2711 0.017
R12713 AVSS_n2713 AVSS_n2712 0.017
R12714 AVSS_n2714 AVSS_n2713 0.017
R12715 AVSS_n2715 AVSS_n2714 0.017
R12716 AVSS_n2716 AVSS_n2715 0.017
R12717 AVSS_n2717 AVSS_n2716 0.017
R12718 AVSS_n2718 AVSS_n2717 0.017
R12719 AVSS_n2719 AVSS_n2718 0.017
R12720 AVSS_n2720 AVSS_n2719 0.017
R12721 AVSS_n2721 AVSS_n2720 0.017
R12722 AVSS_n2722 AVSS_n2721 0.017
R12723 AVSS_n2723 AVSS_n2722 0.017
R12724 AVSS_n2724 AVSS_n2723 0.017
R12725 AVSS_n2725 AVSS_n2724 0.017
R12726 AVSS_n2726 AVSS_n2725 0.017
R12727 AVSS_n2727 AVSS_n2726 0.017
R12728 AVSS_n2728 AVSS_n2727 0.017
R12729 AVSS_n2729 AVSS_n2728 0.017
R12730 AVSS_n2730 AVSS_n2729 0.017
R12731 AVSS_n2731 AVSS_n2730 0.017
R12732 AVSS_n2732 AVSS_n2731 0.017
R12733 AVSS_n2733 AVSS_n2732 0.017
R12734 AVSS_n2734 AVSS_n2733 0.017
R12735 AVSS_n2735 AVSS_n2734 0.017
R12736 AVSS_n2736 AVSS_n2735 0.017
R12737 AVSS_n2737 AVSS_n2736 0.017
R12738 AVSS_n2738 AVSS_n2737 0.017
R12739 AVSS_n2739 AVSS_n2738 0.017
R12740 AVSS_n2740 AVSS_n2739 0.017
R12741 AVSS_n2741 AVSS_n2740 0.017
R12742 AVSS_n2742 AVSS_n2741 0.017
R12743 AVSS_n2743 AVSS_n2742 0.017
R12744 AVSS_n2744 AVSS_n2743 0.017
R12745 AVSS_n2745 AVSS_n2744 0.017
R12746 AVSS_n2746 AVSS_n2745 0.017
R12747 AVSS_n2747 AVSS_n2746 0.017
R12748 AVSS_n2748 AVSS_n2747 0.017
R12749 AVSS_n2749 AVSS_n2748 0.017
R12750 AVSS_n2750 AVSS_n2749 0.017
R12751 AVSS_n2751 AVSS_n2750 0.017
R12752 AVSS_n2752 AVSS_n2751 0.017
R12753 AVSS_n2753 AVSS_n2752 0.017
R12754 AVSS_n2754 AVSS_n2753 0.017
R12755 AVSS_n2610 AVSS_n2609 0.017
R12756 AVSS_n2609 AVSS_n2608 0.017
R12757 AVSS_n2608 AVSS_n2607 0.017
R12758 AVSS_n2607 AVSS_n2606 0.017
R12759 AVSS_n2606 AVSS_n2605 0.017
R12760 AVSS_n2605 AVSS_n2604 0.017
R12761 AVSS_n2604 AVSS_n2603 0.017
R12762 AVSS_n2603 AVSS_n2602 0.017
R12763 AVSS_n2602 AVSS_n2601 0.017
R12764 AVSS_n2601 AVSS_n2600 0.017
R12765 AVSS_n2600 AVSS_n2599 0.017
R12766 AVSS_n2599 AVSS_n2598 0.017
R12767 AVSS_n2598 AVSS_n2597 0.017
R12768 AVSS_n2597 AVSS_n2596 0.017
R12769 AVSS_n2596 AVSS_n2595 0.017
R12770 AVSS_n2595 AVSS_n2594 0.017
R12771 AVSS_n2594 AVSS_n2593 0.017
R12772 AVSS_n2593 AVSS_n2592 0.017
R12773 AVSS_n2592 AVSS_n2591 0.017
R12774 AVSS_n2591 AVSS_n2590 0.017
R12775 AVSS_n2590 AVSS_n2589 0.017
R12776 AVSS_n2589 AVSS_n2588 0.017
R12777 AVSS_n2588 AVSS_n2587 0.017
R12778 AVSS_n2587 AVSS_n2586 0.017
R12779 AVSS_n2586 AVSS_n2585 0.017
R12780 AVSS_n2585 AVSS_n2584 0.017
R12781 AVSS_n2584 AVSS_n2583 0.017
R12782 AVSS_n2583 AVSS_n2582 0.017
R12783 AVSS_n2582 AVSS_n2581 0.017
R12784 AVSS_n2581 AVSS_n2580 0.017
R12785 AVSS_n2580 AVSS_n2579 0.017
R12786 AVSS_n2579 AVSS_n2578 0.017
R12787 AVSS_n2578 AVSS_n2577 0.017
R12788 AVSS_n2577 AVSS_n2576 0.017
R12789 AVSS_n2576 AVSS_n2575 0.017
R12790 AVSS_n2575 AVSS_n2574 0.017
R12791 AVSS_n2574 AVSS_n2573 0.017
R12792 AVSS_n2573 AVSS_n2572 0.017
R12793 AVSS_n2572 AVSS_n2571 0.017
R12794 AVSS_n2571 AVSS_n2570 0.017
R12795 AVSS_n2570 AVSS_n2569 0.017
R12796 AVSS_n2569 AVSS_n2568 0.017
R12797 AVSS_n2568 AVSS_n2567 0.017
R12798 AVSS_n2567 AVSS_n2566 0.017
R12799 AVSS_n2566 AVSS_n2565 0.017
R12800 AVSS_n2565 AVSS_n2564 0.017
R12801 AVSS_n2564 AVSS_n2563 0.017
R12802 AVSS_n2563 AVSS_n2562 0.017
R12803 AVSS_n2562 AVSS_n2561 0.017
R12804 AVSS_n2561 AVSS_n2560 0.017
R12805 AVSS_n2560 AVSS_n2559 0.017
R12806 AVSS_n2559 AVSS_n2558 0.017
R12807 AVSS_n2558 AVSS_n2557 0.017
R12808 AVSS_n2557 AVSS_n2556 0.017
R12809 AVSS_n2556 AVSS_n2555 0.017
R12810 AVSS_n2555 AVSS_n2554 0.017
R12811 AVSS_n2554 AVSS_n2553 0.017
R12812 AVSS_n2553 AVSS_n2552 0.017
R12813 AVSS_n2552 AVSS_n2551 0.017
R12814 AVSS_n2551 AVSS_n2217 0.017
R12815 AVSS_n2217 AVSS_n2216 0.017
R12816 AVSS_n2216 AVSS_n2215 0.017
R12817 AVSS_n2215 AVSS_n2214 0.017
R12818 AVSS_n2214 AVSS_n2213 0.017
R12819 AVSS_n2211 AVSS_n2210 0.017
R12820 AVSS_n2210 AVSS_n2209 0.017
R12821 AVSS_n2209 AVSS_n2208 0.017
R12822 AVSS_n2208 AVSS_n2207 0.017
R12823 AVSS_n2207 AVSS_n2206 0.017
R12824 AVSS_n2206 AVSS_n2205 0.017
R12825 AVSS_n2205 AVSS_n2204 0.017
R12826 AVSS_n2204 AVSS_n2203 0.017
R12827 AVSS_n2203 AVSS_n2202 0.017
R12828 AVSS_n2202 AVSS_n2201 0.017
R12829 AVSS_n2201 AVSS_n2200 0.017
R12830 AVSS_n2200 AVSS_n2199 0.017
R12831 AVSS_n2199 AVSS_n2198 0.017
R12832 AVSS_n2198 AVSS_n2197 0.017
R12833 AVSS_n2197 AVSS_n2196 0.017
R12834 AVSS_n2196 AVSS_n2195 0.017
R12835 AVSS_n2140 AVSS_n2139 0.017
R12836 AVSS_n2141 AVSS_n2140 0.017
R12837 AVSS_n2142 AVSS_n2141 0.017
R12838 AVSS_n2143 AVSS_n2142 0.017
R12839 AVSS_n2144 AVSS_n2143 0.017
R12840 AVSS_n2145 AVSS_n2144 0.017
R12841 AVSS_n2146 AVSS_n2145 0.017
R12842 AVSS_n2147 AVSS_n2146 0.017
R12843 AVSS_n2148 AVSS_n2147 0.017
R12844 AVSS_n2149 AVSS_n2148 0.017
R12845 AVSS_n2150 AVSS_n2149 0.017
R12846 AVSS_n2151 AVSS_n2150 0.017
R12847 AVSS_n2152 AVSS_n2151 0.017
R12848 AVSS_n2153 AVSS_n2152 0.017
R12849 AVSS_n2154 AVSS_n2153 0.017
R12850 AVSS_n2155 AVSS_n2154 0.017
R12851 AVSS_n2156 AVSS_n2155 0.017
R12852 AVSS_n2157 AVSS_n2156 0.017
R12853 AVSS_n2158 AVSS_n2157 0.017
R12854 AVSS_n2159 AVSS_n2158 0.017
R12855 AVSS_n2160 AVSS_n2159 0.017
R12856 AVSS_n2161 AVSS_n2160 0.017
R12857 AVSS_n2162 AVSS_n2161 0.017
R12858 AVSS_n2163 AVSS_n2162 0.017
R12859 AVSS_n2164 AVSS_n2163 0.017
R12860 AVSS_n2165 AVSS_n2164 0.017
R12861 AVSS_n2166 AVSS_n2165 0.017
R12862 AVSS_n2167 AVSS_n2166 0.017
R12863 AVSS_n2168 AVSS_n2167 0.017
R12864 AVSS_n2169 AVSS_n2168 0.017
R12865 AVSS_n2170 AVSS_n2169 0.017
R12866 AVSS_n2171 AVSS_n2170 0.017
R12867 AVSS_n2172 AVSS_n2171 0.017
R12868 AVSS_n2173 AVSS_n2172 0.017
R12869 AVSS_n2174 AVSS_n2173 0.017
R12870 AVSS_n2175 AVSS_n2174 0.017
R12871 AVSS_n2176 AVSS_n2175 0.017
R12872 AVSS_n2177 AVSS_n2176 0.017
R12873 AVSS_n2178 AVSS_n2177 0.017
R12874 AVSS_n2179 AVSS_n2178 0.017
R12875 AVSS_n2180 AVSS_n2179 0.017
R12876 AVSS_n2181 AVSS_n2180 0.017
R12877 AVSS_n2182 AVSS_n2181 0.017
R12878 AVSS_n2183 AVSS_n2182 0.017
R12879 AVSS_n2184 AVSS_n2183 0.017
R12880 AVSS_n2185 AVSS_n2184 0.017
R12881 AVSS_n2186 AVSS_n2185 0.017
R12882 AVSS_n2187 AVSS_n2186 0.017
R12883 AVSS_n2188 AVSS_n2187 0.017
R12884 AVSS_n2189 AVSS_n2188 0.017
R12885 AVSS_n2190 AVSS_n2189 0.017
R12886 AVSS_n2191 AVSS_n2190 0.017
R12887 AVSS_n2138 AVSS_n2137 0.017
R12888 AVSS_n2137 AVSS_n2136 0.017
R12889 AVSS_n2136 AVSS_n2135 0.017
R12890 AVSS_n2135 AVSS_n2134 0.017
R12891 AVSS_n2134 AVSS_n2133 0.017
R12892 AVSS_n2133 AVSS_n2132 0.017
R12893 AVSS_n2132 AVSS_n2131 0.017
R12894 AVSS_n2131 AVSS_n2130 0.017
R12895 AVSS_n2130 AVSS_n2125 0.017
R12896 AVSS_n2125 AVSS_n2124 0.017
R12897 AVSS_n2124 AVSS_n2123 0.017
R12898 AVSS_n2123 AVSS_n2122 0.017
R12899 AVSS_n2122 AVSS_n2121 0.017
R12900 AVSS_n2121 AVSS_n2120 0.017
R12901 AVSS_n2120 AVSS_n2119 0.017
R12902 AVSS_n2119 AVSS_n2118 0.017
R12903 AVSS_n2118 AVSS_n2117 0.017
R12904 AVSS_n2117 AVSS_n2116 0.017
R12905 AVSS_n2116 AVSS_n2115 0.017
R12906 AVSS_n2115 AVSS_n2114 0.017
R12907 AVSS_n2112 AVSS_n2111 0.017
R12908 AVSS_n2111 AVSS_n2110 0.017
R12909 AVSS_n2110 AVSS_n2109 0.017
R12910 AVSS_n2109 AVSS_n2108 0.017
R12911 AVSS_n2108 AVSS_n2107 0.017
R12912 AVSS_n2107 AVSS_n2106 0.017
R12913 AVSS_n2106 AVSS_n2105 0.017
R12914 AVSS_n2105 AVSS_n2104 0.017
R12915 AVSS_n3118 AVSS_n3117 0.0151667
R12916 AVSS_n2361 AVSS_n2307 0.0151667
R12917 AVSS_n2615 AVSS_n2614 0.0151667
R12918 AVSS_n2755 AVSS_n2754 0.0133333
R12919 AVSS_n2192 AVSS_n2191 0.0115
R12920 AVSS_n2399 AVSS_n1059 0.0104362
R12921 AVSS_n3421 AVSS_n3420 0.00922605
R12922 AVSS_n2811 AVSS_n1059 0.00893825
R12923 AVSS_n3432 AVSS_n9 0.00798967
R12924 AVSS_n131 AVSS_n9 0.00786276
R12925 AVSS_n2398 AVSS_n1059 0.0078064
R12926 AVSS_n129 AVSS_n9 0.00712483
R12927 AVSS_n3428 AVSS_n9 0.00712483
R12928 AVSS_n3426 AVSS_n9 0.00712483
R12929 AVSS_n446 AVSS_n415 0.00662375
R12930 AVSS_n1418 AVSS_n1349 0.00646183
R12931 AVSS_n2192 AVSS_n2138 0.006
R12932 AVSS_n2762 AVSS_n2047 0.00506715
R12933 AVSS_n452 AVSS_n401 0.00472051
R12934 AVSS_n1382 AVSS_n1353 0.00471997
R12935 AVSS_n2755 AVSS_n2610 0.00416667
R12936 AVSS_n9 AVSS_n5 0.00254391
R12937 AVSS_n3119 AVSS_n3118 0.00233333
R12938 AVSS_n2361 AVSS_n2360 0.00233333
R12939 AVSS_n2616 AVSS_n2615 0.00233333
R12940 AVSS_n489 AVSS_n458 0.00175
R12941 AVSS_n1518 AVSS_n1508 0.00166667
R12942 AVSS_n1034 AVSS_n1011 0.00166667
R12943 AVSS_n2541 AVSS_n1566 0.00166667
R12944 AVSS_n2037 AVSS_n1920 0.00166667
R12945 AVSS_n487 AVSS_n459 0.00166667
R12946 AVSS_n2038 AVSS_n2037 0.00133332
R12947 AVSS_n2541 AVSS_n1890 0.00133332
R12948 AVSS_n1034 AVSS_n1022 0.00133332
R12949 AVSS_n2768 AVSS_n1508 0.00133332
R12950 AVSS_n487 AVSS_n460 0.00133332
R12951 AVSS_n489 AVSS_n457 0.00124998
R12952 AVSS_n9 AVSS_n6 0.00111772
R12953 AVSS_n2762 AVSS_n2761 0.00110474
R12954 AVSS_n2808 AVSS_n1059 0.00103656
R12955 AVSS_n2762 AVSS_n2063 0.00101643
R12956 AVSS_n3496 AVSS_n9 0.0010146
R12957 AVSS_n662 AVSS_n9 0.00100862
R12958 AVSS_n1162 AVSS_n1059 0.00100268
R12959 AVSS_n29 AVSS_n22 0.001
R12960 AVSS_n3470 AVSS_n42 0.001
R12961 AVSS_n3230 AVSS_n194 0.001
R12962 AVSS_n25 AVSS_n14 0.001
R12963 AVSS_n3474 AVSS_n39 0.001
R12964 AVSS_n83 AVSS_n82 0.001
R12965 AVSS_n77 AVSS_n47 0.001
R12966 AVSS_n75 AVSS_n74 0.001
R12967 AVSS_n71 AVSS_n51 0.001
R12968 AVSS_n66 AVSS_n65 0.001
R12969 AVSS_n62 AVSS_n59 0.001
R12970 AVSS_n60 AVSS_n9 0.001
R12971 AVSS_n3313 AVSS_n142 0.001
R12972 AVSS_n3360 AVSS_n3277 0.001
R12973 AVSS_n3367 AVSS_n150 0.001
R12974 AVSS_n3361 AVSS_n3266 0.001
R12975 AVSS_n3366 AVSS_n161 0.001
R12976 AVSS_n3362 AVSS_n3258 0.001
R12977 AVSS_n3365 AVSS_n168 0.001
R12978 AVSS_n3363 AVSS_n182 0.001
R12979 AVSS_n3364 AVSS_n178 0.001
R12980 AVSS_n203 AVSS_n202 0.001
R12981 AVSS_n2909 AVSS_n231 0.001
R12982 AVSS_n2903 AVSS_n2902 0.001
R12983 AVSS_n2896 AVSS_n242 0.001
R12984 AVSS_n2893 AVSS_n2892 0.001
R12985 AVSS_n2887 AVSS_n251 0.001
R12986 AVSS_n2881 AVSS_n2880 0.001
R12987 AVSS_n2874 AVSS_n262 0.001
R12988 AVSS_n2868 AVSS_n2867 0.001
R12989 AVSS_n2861 AVSS_n273 0.001
R12990 AVSS_n2855 AVSS_n2854 0.001
R12991 AVSS_n2848 AVSS_n284 0.001
R12992 AVSS_n2845 AVSS_n2844 0.001
R12993 AVSS_n2838 AVSS_n291 0.001
R12994 AVSS_n2832 AVSS_n2831 0.001
R12995 AVSS_n2825 AVSS_n302 0.001
R12996 AVSS_n3492 AVSS_n28 0.001
R12997 AVSS_n2053 AVSS_n23 0.001
R12998 AVSS_n2057 AVSS_n15 0.001
R12999 AVSS_n2055 AVSS_n16 0.001
R13000 AVSS_n2054 AVSS_n17 0.001
R13001 AVSS_n3475 AVSS_n36 0.001
R13002 AVSS_n117 AVSS_n40 0.001
R13003 AVSS_n116 AVSS_n41 0.001
R13004 AVSS_n103 AVSS_n81 0.001
R13005 AVSS_n104 AVSS_n80 0.001
R13006 AVSS_n105 AVSS_n79 0.001
R13007 AVSS_n106 AVSS_n78 0.001
R13008 AVSS_n115 AVSS_n48 0.001
R13009 AVSS_n107 AVSS_n73 0.001
R13010 AVSS_n108 AVSS_n72 0.001
R13011 AVSS_n3449 AVSS_n52 0.001
R13012 AVSS_n114 AVSS_n53 0.001
R13013 AVSS_n113 AVSS_n54 0.001
R13014 AVSS_n112 AVSS_n55 0.001
R13015 AVSS_n111 AVSS_n56 0.001
R13016 AVSS_n109 AVSS_n64 0.001
R13017 AVSS_n110 AVSS_n63 0.001
R13018 AVSS_n3417 AVSS_n3314 0.001
R13019 AVSS_n3357 AVSS_n143 0.001
R13020 AVSS_n3356 AVSS_n144 0.001
R13021 AVSS_n3328 AVSS_n3276 0.001
R13022 AVSS_n3329 AVSS_n3275 0.001
R13023 AVSS_n3330 AVSS_n3274 0.001
R13024 AVSS_n3331 AVSS_n3273 0.001
R13025 AVSS_n3332 AVSS_n3272 0.001
R13026 AVSS_n3355 AVSS_n151 0.001
R13027 AVSS_n3354 AVSS_n152 0.001
R13028 AVSS_n3353 AVSS_n153 0.001
R13029 AVSS_n3352 AVSS_n154 0.001
R13030 AVSS_n3351 AVSS_n155 0.001
R13031 AVSS_n3333 AVSS_n3265 0.001
R13032 AVSS_n3334 AVSS_n3264 0.001
R13033 AVSS_n3335 AVSS_n3263 0.001
R13034 AVSS_n3336 AVSS_n3262 0.001
R13035 AVSS_n3337 AVSS_n3261 0.001
R13036 AVSS_n3350 AVSS_n162 0.001
R13037 AVSS_n3349 AVSS_n163 0.001
R13038 AVSS_n3359 AVSS_n3257 0.001
R13039 AVSS_n3338 AVSS_n3256 0.001
R13040 AVSS_n3339 AVSS_n3255 0.001
R13041 AVSS_n3340 AVSS_n3254 0.001
R13042 AVSS_n3341 AVSS_n3253 0.001
R13043 AVSS_n3348 AVSS_n169 0.001
R13044 AVSS_n3347 AVSS_n170 0.001
R13045 AVSS_n3346 AVSS_n171 0.001
R13046 AVSS_n3345 AVSS_n172 0.001
R13047 AVSS_n3342 AVSS_n181 0.001
R13048 AVSS_n3343 AVSS_n180 0.001
R13049 AVSS_n3344 AVSS_n179 0.001
R13050 AVSS_n3232 AVSS_n190 0.001
R13051 AVSS_n211 AVSS_n198 0.001
R13052 AVSS_n212 AVSS_n197 0.001
R13053 AVSS_n213 AVSS_n196 0.001
R13054 AVSS_n3221 AVSS_n224 0.001
R13055 AVSS_n2985 AVSS_n2913 0.001
R13056 AVSS_n2986 AVSS_n2912 0.001
R13057 AVSS_n2987 AVSS_n2911 0.001
R13058 AVSS_n2988 AVSS_n2910 0.001
R13059 AVSS_n3216 AVSS_n232 0.001
R13060 AVSS_n3215 AVSS_n233 0.001
R13061 AVSS_n3214 AVSS_n234 0.001
R13062 AVSS_n3213 AVSS_n235 0.001
R13063 AVSS_n3212 AVSS_n236 0.001
R13064 AVSS_n2989 AVSS_n2901 0.001
R13065 AVSS_n2990 AVSS_n2900 0.001
R13066 AVSS_n2991 AVSS_n2899 0.001
R13067 AVSS_n2992 AVSS_n2898 0.001
R13068 AVSS_n2993 AVSS_n2897 0.001
R13069 AVSS_n3211 AVSS_n243 0.001
R13070 AVSS_n3210 AVSS_n244 0.001
R13071 AVSS_n2995 AVSS_n2891 0.001
R13072 AVSS_n2996 AVSS_n2890 0.001
R13073 AVSS_n2997 AVSS_n2889 0.001
R13074 AVSS_n2998 AVSS_n2888 0.001
R13075 AVSS_n3209 AVSS_n252 0.001
R13076 AVSS_n3208 AVSS_n253 0.001
R13077 AVSS_n3207 AVSS_n254 0.001
R13078 AVSS_n3206 AVSS_n255 0.001
R13079 AVSS_n3205 AVSS_n256 0.001
R13080 AVSS_n2999 AVSS_n2879 0.001
R13081 AVSS_n3000 AVSS_n2878 0.001
R13082 AVSS_n3001 AVSS_n2877 0.001
R13083 AVSS_n3002 AVSS_n2876 0.001
R13084 AVSS_n3003 AVSS_n2875 0.001
R13085 AVSS_n3204 AVSS_n263 0.001
R13086 AVSS_n3203 AVSS_n264 0.001
R13087 AVSS_n3202 AVSS_n265 0.001
R13088 AVSS_n3201 AVSS_n266 0.001
R13089 AVSS_n3200 AVSS_n267 0.001
R13090 AVSS_n3004 AVSS_n2866 0.001
R13091 AVSS_n3005 AVSS_n2865 0.001
R13092 AVSS_n3006 AVSS_n2864 0.001
R13093 AVSS_n3007 AVSS_n2863 0.001
R13094 AVSS_n3008 AVSS_n2862 0.001
R13095 AVSS_n3199 AVSS_n274 0.001
R13096 AVSS_n3198 AVSS_n275 0.001
R13097 AVSS_n3197 AVSS_n276 0.001
R13098 AVSS_n3196 AVSS_n277 0.001
R13099 AVSS_n3195 AVSS_n278 0.001
R13100 AVSS_n3009 AVSS_n2853 0.001
R13101 AVSS_n3010 AVSS_n2852 0.001
R13102 AVSS_n3011 AVSS_n2851 0.001
R13103 AVSS_n3012 AVSS_n2850 0.001
R13104 AVSS_n3013 AVSS_n2849 0.001
R13105 AVSS_n3194 AVSS_n285 0.001
R13106 AVSS_n3193 AVSS_n286 0.001
R13107 AVSS_n3174 AVSS_n2843 0.001
R13108 AVSS_n3175 AVSS_n2842 0.001
R13109 AVSS_n3176 AVSS_n2841 0.001
R13110 AVSS_n3177 AVSS_n2840 0.001
R13111 AVSS_n3178 AVSS_n2839 0.001
R13112 AVSS_n3192 AVSS_n292 0.001
R13113 AVSS_n3191 AVSS_n293 0.001
R13114 AVSS_n3190 AVSS_n294 0.001
R13115 AVSS_n3189 AVSS_n295 0.001
R13116 AVSS_n3188 AVSS_n296 0.001
R13117 AVSS_n3179 AVSS_n2830 0.001
R13118 AVSS_n3180 AVSS_n2829 0.001
R13119 AVSS_n3181 AVSS_n2828 0.001
R13120 AVSS_n3182 AVSS_n2827 0.001
R13121 AVSS_n3183 AVSS_n2826 0.001
R13122 AVSS_n3187 AVSS_n303 0.001
R13123 AVSS_n3186 AVSS_n304 0.001
R13124 AVSS_n3185 AVSS_n305 0.001
R13125 AVSS_n3184 AVSS_n306 0.001
R13126 AVSS_n2061 AVSS_n12 0.001
R13127 AVSS_n3492 AVSS_n27 0.001
R13128 AVSS_n2052 AVSS_n15 0.001
R13129 AVSS_n2048 AVSS_n20 0.001
R13130 AVSS_n2049 AVSS_n19 0.001
R13131 AVSS_n2051 AVSS_n17 0.001
R13132 AVSS_n3478 AVSS_n35 0.001
R13133 AVSS_n3472 AVSS_n39 0.001
R13134 AVSS_n86 AVSS_n84 0.001
R13135 AVSS_n87 AVSS_n83 0.001
R13136 AVSS_n3471 AVSS_n43 0.001
R13137 AVSS_n102 AVSS_n44 0.001
R13138 AVSS_n88 AVSS_n80 0.001
R13139 AVSS_n101 AVSS_n46 0.001
R13140 AVSS_n100 AVSS_n47 0.001
R13141 AVSS_n89 AVSS_n75 0.001
R13142 AVSS_n99 AVSS_n50 0.001
R13143 AVSS_n98 AVSS_n51 0.001
R13144 AVSS_n90 AVSS_n70 0.001
R13145 AVSS_n91 AVSS_n69 0.001
R13146 AVSS_n97 AVSS_n54 0.001
R13147 AVSS_n92 AVSS_n67 0.001
R13148 AVSS_n93 AVSS_n66 0.001
R13149 AVSS_n96 AVSS_n58 0.001
R13150 AVSS_n95 AVSS_n59 0.001
R13151 AVSS_n3311 AVSS_n141 0.001
R13152 AVSS_n3310 AVSS_n142 0.001
R13153 AVSS_n3281 AVSS_n3278 0.001
R13154 AVSS_n3282 AVSS_n3277 0.001
R13155 AVSS_n3309 AVSS_n146 0.001
R13156 AVSS_n3308 AVSS_n147 0.001
R13157 AVSS_n3283 AVSS_n3274 0.001
R13158 AVSS_n3307 AVSS_n149 0.001
R13159 AVSS_n3306 AVSS_n150 0.001
R13160 AVSS_n3284 AVSS_n3270 0.001
R13161 AVSS_n3285 AVSS_n3269 0.001
R13162 AVSS_n3305 AVSS_n153 0.001
R13163 AVSS_n3286 AVSS_n3267 0.001
R13164 AVSS_n3287 AVSS_n3266 0.001
R13165 AVSS_n3304 AVSS_n157 0.001
R13166 AVSS_n3303 AVSS_n158 0.001
R13167 AVSS_n3288 AVSS_n3263 0.001
R13168 AVSS_n3302 AVSS_n160 0.001
R13169 AVSS_n3301 AVSS_n161 0.001
R13170 AVSS_n3289 AVSS_n3259 0.001
R13171 AVSS_n3326 AVSS_n3258 0.001
R13172 AVSS_n3300 AVSS_n164 0.001
R13173 AVSS_n3299 AVSS_n165 0.001
R13174 AVSS_n3290 AVSS_n3255 0.001
R13175 AVSS_n3298 AVSS_n167 0.001
R13176 AVSS_n168 AVSS_n138 0.001
R13177 AVSS_n3252 AVSS_n137 0.001
R13178 AVSS_n3291 AVSS_n3251 0.001
R13179 AVSS_n3297 AVSS_n170 0.001
R13180 AVSS_n3292 AVSS_n183 0.001
R13181 AVSS_n3293 AVSS_n182 0.001
R13182 AVSS_n3296 AVSS_n174 0.001
R13183 AVSS_n3295 AVSS_n175 0.001
R13184 AVSS_n3294 AVSS_n179 0.001
R13185 AVSS_n3234 AVSS_n189 0.001
R13186 AVSS_n3232 AVSS_n200 0.001
R13187 AVSS_n208 AVSS_n193 0.001
R13188 AVSS_n3230 AVSS_n206 0.001
R13189 AVSS_n207 AVSS_n195 0.001
R13190 AVSS_n221 AVSS_n196 0.001
R13191 AVSS_n3220 AVSS_n227 0.001
R13192 AVSS_n2914 AVSS_n228 0.001
R13193 AVSS_n2915 AVSS_n2912 0.001
R13194 AVSS_n2916 AVSS_n230 0.001
R13195 AVSS_n2917 AVSS_n231 0.001
R13196 AVSS_n2918 AVSS_n2907 0.001
R13197 AVSS_n2919 AVSS_n2906 0.001
R13198 AVSS_n2920 AVSS_n234 0.001
R13199 AVSS_n2921 AVSS_n2904 0.001
R13200 AVSS_n2922 AVSS_n2903 0.001
R13201 AVSS_n2923 AVSS_n238 0.001
R13202 AVSS_n2924 AVSS_n239 0.001
R13203 AVSS_n2925 AVSS_n2899 0.001
R13204 AVSS_n2926 AVSS_n241 0.001
R13205 AVSS_n2927 AVSS_n242 0.001
R13206 AVSS_n2928 AVSS_n2894 0.001
R13207 AVSS_n2929 AVSS_n2893 0.001
R13208 AVSS_n2930 AVSS_n247 0.001
R13209 AVSS_n2931 AVSS_n248 0.001
R13210 AVSS_n2932 AVSS_n2890 0.001
R13211 AVSS_n2933 AVSS_n250 0.001
R13212 AVSS_n2934 AVSS_n251 0.001
R13213 AVSS_n2935 AVSS_n2885 0.001
R13214 AVSS_n2936 AVSS_n2884 0.001
R13215 AVSS_n2937 AVSS_n254 0.001
R13216 AVSS_n2938 AVSS_n2882 0.001
R13217 AVSS_n2939 AVSS_n2881 0.001
R13218 AVSS_n2940 AVSS_n258 0.001
R13219 AVSS_n2941 AVSS_n259 0.001
R13220 AVSS_n2942 AVSS_n2877 0.001
R13221 AVSS_n2943 AVSS_n261 0.001
R13222 AVSS_n2944 AVSS_n262 0.001
R13223 AVSS_n2945 AVSS_n2872 0.001
R13224 AVSS_n2946 AVSS_n2871 0.001
R13225 AVSS_n2947 AVSS_n265 0.001
R13226 AVSS_n2948 AVSS_n2869 0.001
R13227 AVSS_n2949 AVSS_n2868 0.001
R13228 AVSS_n2950 AVSS_n269 0.001
R13229 AVSS_n2951 AVSS_n270 0.001
R13230 AVSS_n2952 AVSS_n2864 0.001
R13231 AVSS_n2953 AVSS_n272 0.001
R13232 AVSS_n2954 AVSS_n273 0.001
R13233 AVSS_n2955 AVSS_n2859 0.001
R13234 AVSS_n2956 AVSS_n2858 0.001
R13235 AVSS_n2957 AVSS_n276 0.001
R13236 AVSS_n2958 AVSS_n2856 0.001
R13237 AVSS_n2959 AVSS_n2855 0.001
R13238 AVSS_n2960 AVSS_n280 0.001
R13239 AVSS_n2961 AVSS_n281 0.001
R13240 AVSS_n2962 AVSS_n2851 0.001
R13241 AVSS_n2963 AVSS_n283 0.001
R13242 AVSS_n2964 AVSS_n284 0.001
R13243 AVSS_n2965 AVSS_n2846 0.001
R13244 AVSS_n2966 AVSS_n2845 0.001
R13245 AVSS_n2967 AVSS_n287 0.001
R13246 AVSS_n2968 AVSS_n288 0.001
R13247 AVSS_n2969 AVSS_n2841 0.001
R13248 AVSS_n2970 AVSS_n290 0.001
R13249 AVSS_n2971 AVSS_n291 0.001
R13250 AVSS_n2972 AVSS_n2836 0.001
R13251 AVSS_n2973 AVSS_n2835 0.001
R13252 AVSS_n2974 AVSS_n294 0.001
R13253 AVSS_n2975 AVSS_n2833 0.001
R13254 AVSS_n2976 AVSS_n2832 0.001
R13255 AVSS_n2977 AVSS_n298 0.001
R13256 AVSS_n2978 AVSS_n299 0.001
R13257 AVSS_n2979 AVSS_n2828 0.001
R13258 AVSS_n2980 AVSS_n301 0.001
R13259 AVSS_n2981 AVSS_n302 0.001
R13260 AVSS_n2982 AVSS_n2823 0.001
R13261 AVSS_n2983 AVSS_n2822 0.001
R13262 AVSS_n2984 AVSS_n305 0.001
R13263 AVSS_n3184 AVSS_n2821 0.001
R13264 AVSS_n2984 AVSS_n2821 0.001
R13265 AVSS_n3185 AVSS_n2822 0.001
R13266 AVSS_n2983 AVSS_n304 0.001
R13267 AVSS_n3186 AVSS_n2823 0.001
R13268 AVSS_n2982 AVSS_n303 0.001
R13269 AVSS_n3187 AVSS_n2824 0.001
R13270 AVSS_n2981 AVSS_n2824 0.001
R13271 AVSS_n2826 AVSS_n2825 0.001
R13272 AVSS_n3183 AVSS_n301 0.001
R13273 AVSS_n2980 AVSS_n2827 0.001
R13274 AVSS_n3182 AVSS_n300 0.001
R13275 AVSS_n2979 AVSS_n300 0.001
R13276 AVSS_n3181 AVSS_n299 0.001
R13277 AVSS_n2978 AVSS_n2829 0.001
R13278 AVSS_n3180 AVSS_n298 0.001
R13279 AVSS_n2977 AVSS_n2830 0.001
R13280 AVSS_n3179 AVSS_n297 0.001
R13281 AVSS_n2976 AVSS_n297 0.001
R13282 AVSS_n2831 AVSS_n296 0.001
R13283 AVSS_n3188 AVSS_n2833 0.001
R13284 AVSS_n2975 AVSS_n295 0.001
R13285 AVSS_n3189 AVSS_n2834 0.001
R13286 AVSS_n2974 AVSS_n2834 0.001
R13287 AVSS_n3190 AVSS_n2835 0.001
R13288 AVSS_n2973 AVSS_n293 0.001
R13289 AVSS_n3191 AVSS_n2836 0.001
R13290 AVSS_n2972 AVSS_n292 0.001
R13291 AVSS_n3192 AVSS_n2837 0.001
R13292 AVSS_n2971 AVSS_n2837 0.001
R13293 AVSS_n2839 AVSS_n2838 0.001
R13294 AVSS_n3178 AVSS_n290 0.001
R13295 AVSS_n2970 AVSS_n2840 0.001
R13296 AVSS_n3177 AVSS_n289 0.001
R13297 AVSS_n2969 AVSS_n289 0.001
R13298 AVSS_n3176 AVSS_n288 0.001
R13299 AVSS_n2968 AVSS_n2842 0.001
R13300 AVSS_n3175 AVSS_n287 0.001
R13301 AVSS_n2967 AVSS_n2843 0.001
R13302 AVSS_n3174 AVSS_n3173 0.001
R13303 AVSS_n3173 AVSS_n2966 0.001
R13304 AVSS_n2844 AVSS_n286 0.001
R13305 AVSS_n3193 AVSS_n2846 0.001
R13306 AVSS_n2965 AVSS_n285 0.001
R13307 AVSS_n3194 AVSS_n2847 0.001
R13308 AVSS_n2964 AVSS_n2847 0.001
R13309 AVSS_n2849 AVSS_n2848 0.001
R13310 AVSS_n3013 AVSS_n283 0.001
R13311 AVSS_n2963 AVSS_n2850 0.001
R13312 AVSS_n3012 AVSS_n282 0.001
R13313 AVSS_n2962 AVSS_n282 0.001
R13314 AVSS_n3011 AVSS_n281 0.001
R13315 AVSS_n2961 AVSS_n2852 0.001
R13316 AVSS_n3010 AVSS_n280 0.001
R13317 AVSS_n2960 AVSS_n2853 0.001
R13318 AVSS_n3009 AVSS_n279 0.001
R13319 AVSS_n2959 AVSS_n279 0.001
R13320 AVSS_n2854 AVSS_n278 0.001
R13321 AVSS_n3195 AVSS_n2856 0.001
R13322 AVSS_n2958 AVSS_n277 0.001
R13323 AVSS_n3196 AVSS_n2857 0.001
R13324 AVSS_n2957 AVSS_n2857 0.001
R13325 AVSS_n3197 AVSS_n2858 0.001
R13326 AVSS_n2956 AVSS_n275 0.001
R13327 AVSS_n3198 AVSS_n2859 0.001
R13328 AVSS_n2955 AVSS_n274 0.001
R13329 AVSS_n3199 AVSS_n2860 0.001
R13330 AVSS_n2954 AVSS_n2860 0.001
R13331 AVSS_n2862 AVSS_n2861 0.001
R13332 AVSS_n3008 AVSS_n272 0.001
R13333 AVSS_n2953 AVSS_n2863 0.001
R13334 AVSS_n3007 AVSS_n271 0.001
R13335 AVSS_n2952 AVSS_n271 0.001
R13336 AVSS_n3006 AVSS_n270 0.001
R13337 AVSS_n2951 AVSS_n2865 0.001
R13338 AVSS_n3005 AVSS_n269 0.001
R13339 AVSS_n2950 AVSS_n2866 0.001
R13340 AVSS_n3004 AVSS_n268 0.001
R13341 AVSS_n2949 AVSS_n268 0.001
R13342 AVSS_n2867 AVSS_n267 0.001
R13343 AVSS_n3200 AVSS_n2869 0.001
R13344 AVSS_n2948 AVSS_n266 0.001
R13345 AVSS_n3201 AVSS_n2870 0.001
R13346 AVSS_n2947 AVSS_n2870 0.001
R13347 AVSS_n3202 AVSS_n2871 0.001
R13348 AVSS_n2946 AVSS_n264 0.001
R13349 AVSS_n3203 AVSS_n2872 0.001
R13350 AVSS_n2945 AVSS_n263 0.001
R13351 AVSS_n3204 AVSS_n2873 0.001
R13352 AVSS_n2944 AVSS_n2873 0.001
R13353 AVSS_n2875 AVSS_n2874 0.001
R13354 AVSS_n3003 AVSS_n261 0.001
R13355 AVSS_n2943 AVSS_n2876 0.001
R13356 AVSS_n3002 AVSS_n260 0.001
R13357 AVSS_n2942 AVSS_n260 0.001
R13358 AVSS_n3001 AVSS_n259 0.001
R13359 AVSS_n2941 AVSS_n2878 0.001
R13360 AVSS_n3000 AVSS_n258 0.001
R13361 AVSS_n2940 AVSS_n2879 0.001
R13362 AVSS_n2999 AVSS_n257 0.001
R13363 AVSS_n2939 AVSS_n257 0.001
R13364 AVSS_n2880 AVSS_n256 0.001
R13365 AVSS_n3205 AVSS_n2882 0.001
R13366 AVSS_n2938 AVSS_n255 0.001
R13367 AVSS_n3206 AVSS_n2883 0.001
R13368 AVSS_n2937 AVSS_n2883 0.001
R13369 AVSS_n3207 AVSS_n2884 0.001
R13370 AVSS_n2936 AVSS_n253 0.001
R13371 AVSS_n3208 AVSS_n2885 0.001
R13372 AVSS_n2935 AVSS_n252 0.001
R13373 AVSS_n3209 AVSS_n2886 0.001
R13374 AVSS_n2934 AVSS_n2886 0.001
R13375 AVSS_n2888 AVSS_n2887 0.001
R13376 AVSS_n2998 AVSS_n250 0.001
R13377 AVSS_n2933 AVSS_n2889 0.001
R13378 AVSS_n2997 AVSS_n249 0.001
R13379 AVSS_n2932 AVSS_n249 0.001
R13380 AVSS_n2996 AVSS_n248 0.001
R13381 AVSS_n2931 AVSS_n2891 0.001
R13382 AVSS_n2995 AVSS_n247 0.001
R13383 AVSS_n2930 AVSS_n246 0.001
R13384 AVSS_n2929 AVSS_n246 0.001
R13385 AVSS_n2892 AVSS_n244 0.001
R13386 AVSS_n3210 AVSS_n2894 0.001
R13387 AVSS_n2928 AVSS_n243 0.001
R13388 AVSS_n3211 AVSS_n2895 0.001
R13389 AVSS_n2927 AVSS_n2895 0.001
R13390 AVSS_n2897 AVSS_n2896 0.001
R13391 AVSS_n2993 AVSS_n241 0.001
R13392 AVSS_n2926 AVSS_n2898 0.001
R13393 AVSS_n2992 AVSS_n240 0.001
R13394 AVSS_n2925 AVSS_n240 0.001
R13395 AVSS_n2991 AVSS_n239 0.001
R13396 AVSS_n2924 AVSS_n2900 0.001
R13397 AVSS_n2990 AVSS_n238 0.001
R13398 AVSS_n2923 AVSS_n2901 0.001
R13399 AVSS_n2989 AVSS_n237 0.001
R13400 AVSS_n2922 AVSS_n237 0.001
R13401 AVSS_n2902 AVSS_n236 0.001
R13402 AVSS_n3212 AVSS_n2904 0.001
R13403 AVSS_n2921 AVSS_n235 0.001
R13404 AVSS_n3213 AVSS_n2905 0.001
R13405 AVSS_n2920 AVSS_n2905 0.001
R13406 AVSS_n3214 AVSS_n2906 0.001
R13407 AVSS_n2919 AVSS_n233 0.001
R13408 AVSS_n3215 AVSS_n2907 0.001
R13409 AVSS_n2918 AVSS_n232 0.001
R13410 AVSS_n3216 AVSS_n2908 0.001
R13411 AVSS_n2917 AVSS_n2908 0.001
R13412 AVSS_n2910 AVSS_n2909 0.001
R13413 AVSS_n2988 AVSS_n230 0.001
R13414 AVSS_n2916 AVSS_n2911 0.001
R13415 AVSS_n2987 AVSS_n229 0.001
R13416 AVSS_n2915 AVSS_n229 0.001
R13417 AVSS_n2986 AVSS_n228 0.001
R13418 AVSS_n2914 AVSS_n2913 0.001
R13419 AVSS_n2985 AVSS_n227 0.001
R13420 AVSS_n3221 AVSS_n3220 0.001
R13421 AVSS_n3223 AVSS_n224 0.001
R13422 AVSS_n3223 AVSS_n221 0.001
R13423 AVSS_n213 AVSS_n195 0.001
R13424 AVSS_n207 AVSS_n197 0.001
R13425 AVSS_n212 AVSS_n204 0.001
R13426 AVSS_n206 AVSS_n204 0.001
R13427 AVSS_n203 AVSS_n194 0.001
R13428 AVSS_n202 AVSS_n198 0.001
R13429 AVSS_n211 AVSS_n193 0.001
R13430 AVSS_n208 AVSS_n201 0.001
R13431 AVSS_n201 AVSS_n200 0.001
R13432 AVSS_n3234 AVSS_n190 0.001
R13433 AVSS_n189 AVSS_n178 0.001
R13434 AVSS_n3364 AVSS_n176 0.001
R13435 AVSS_n3294 AVSS_n176 0.001
R13436 AVSS_n3344 AVSS_n175 0.001
R13437 AVSS_n3295 AVSS_n180 0.001
R13438 AVSS_n3343 AVSS_n174 0.001
R13439 AVSS_n3296 AVSS_n181 0.001
R13440 AVSS_n3342 AVSS_n173 0.001
R13441 AVSS_n3293 AVSS_n173 0.001
R13442 AVSS_n3363 AVSS_n172 0.001
R13443 AVSS_n3345 AVSS_n183 0.001
R13444 AVSS_n3292 AVSS_n171 0.001
R13445 AVSS_n3346 AVSS_n184 0.001
R13446 AVSS_n3297 AVSS_n184 0.001
R13447 AVSS_n3347 AVSS_n3251 0.001
R13448 AVSS_n3291 AVSS_n169 0.001
R13449 AVSS_n3348 AVSS_n3252 0.001
R13450 AVSS_n3419 AVSS_n137 0.001
R13451 AVSS_n3419 AVSS_n138 0.001
R13452 AVSS_n3365 AVSS_n3253 0.001
R13453 AVSS_n3341 AVSS_n167 0.001
R13454 AVSS_n3298 AVSS_n3254 0.001
R13455 AVSS_n3340 AVSS_n166 0.001
R13456 AVSS_n3290 AVSS_n166 0.001
R13457 AVSS_n3339 AVSS_n165 0.001
R13458 AVSS_n3299 AVSS_n3256 0.001
R13459 AVSS_n3338 AVSS_n164 0.001
R13460 AVSS_n3300 AVSS_n3257 0.001
R13461 AVSS_n3370 AVSS_n3359 0.001
R13462 AVSS_n3370 AVSS_n3326 0.001
R13463 AVSS_n3362 AVSS_n163 0.001
R13464 AVSS_n3349 AVSS_n3259 0.001
R13465 AVSS_n3289 AVSS_n162 0.001
R13466 AVSS_n3350 AVSS_n3260 0.001
R13467 AVSS_n3301 AVSS_n3260 0.001
R13468 AVSS_n3366 AVSS_n3261 0.001
R13469 AVSS_n3337 AVSS_n160 0.001
R13470 AVSS_n3302 AVSS_n3262 0.001
R13471 AVSS_n3336 AVSS_n159 0.001
R13472 AVSS_n3288 AVSS_n159 0.001
R13473 AVSS_n3335 AVSS_n158 0.001
R13474 AVSS_n3303 AVSS_n3264 0.001
R13475 AVSS_n3334 AVSS_n157 0.001
R13476 AVSS_n3304 AVSS_n3265 0.001
R13477 AVSS_n3333 AVSS_n156 0.001
R13478 AVSS_n3287 AVSS_n156 0.001
R13479 AVSS_n3361 AVSS_n155 0.001
R13480 AVSS_n3351 AVSS_n3267 0.001
R13481 AVSS_n3286 AVSS_n154 0.001
R13482 AVSS_n3352 AVSS_n3268 0.001
R13483 AVSS_n3305 AVSS_n3268 0.001
R13484 AVSS_n3353 AVSS_n3269 0.001
R13485 AVSS_n3285 AVSS_n152 0.001
R13486 AVSS_n3354 AVSS_n3270 0.001
R13487 AVSS_n3284 AVSS_n151 0.001
R13488 AVSS_n3355 AVSS_n3271 0.001
R13489 AVSS_n3306 AVSS_n3271 0.001
R13490 AVSS_n3367 AVSS_n3272 0.001
R13491 AVSS_n3332 AVSS_n149 0.001
R13492 AVSS_n3307 AVSS_n3273 0.001
R13493 AVSS_n3331 AVSS_n148 0.001
R13494 AVSS_n3283 AVSS_n148 0.001
R13495 AVSS_n3330 AVSS_n147 0.001
R13496 AVSS_n3308 AVSS_n3275 0.001
R13497 AVSS_n3329 AVSS_n146 0.001
R13498 AVSS_n3309 AVSS_n3276 0.001
R13499 AVSS_n3328 AVSS_n145 0.001
R13500 AVSS_n3282 AVSS_n145 0.001
R13501 AVSS_n3360 AVSS_n144 0.001
R13502 AVSS_n3356 AVSS_n3278 0.001
R13503 AVSS_n3281 AVSS_n143 0.001
R13504 AVSS_n3357 AVSS_n3279 0.001
R13505 AVSS_n3310 AVSS_n3279 0.001
R13506 AVSS_n3417 AVSS_n3313 0.001
R13507 AVSS_n3314 AVSS_n141 0.001
R13508 AVSS_n3311 AVSS_n9 0.001
R13509 AVSS_n61 AVSS_n60 0.001
R13510 AVSS_n95 AVSS_n61 0.001
R13511 AVSS_n63 AVSS_n62 0.001
R13512 AVSS_n110 AVSS_n58 0.001
R13513 AVSS_n96 AVSS_n64 0.001
R13514 AVSS_n109 AVSS_n57 0.001
R13515 AVSS_n93 AVSS_n57 0.001
R13516 AVSS_n65 AVSS_n56 0.001
R13517 AVSS_n111 AVSS_n67 0.001
R13518 AVSS_n92 AVSS_n55 0.001
R13519 AVSS_n112 AVSS_n68 0.001
R13520 AVSS_n97 AVSS_n68 0.001
R13521 AVSS_n113 AVSS_n69 0.001
R13522 AVSS_n91 AVSS_n53 0.001
R13523 AVSS_n114 AVSS_n70 0.001
R13524 AVSS_n90 AVSS_n52 0.001
R13525 AVSS_n3450 AVSS_n3449 0.001
R13526 AVSS_n3450 AVSS_n98 0.001
R13527 AVSS_n72 AVSS_n71 0.001
R13528 AVSS_n108 AVSS_n50 0.001
R13529 AVSS_n99 AVSS_n73 0.001
R13530 AVSS_n107 AVSS_n49 0.001
R13531 AVSS_n89 AVSS_n49 0.001
R13532 AVSS_n74 AVSS_n48 0.001
R13533 AVSS_n115 AVSS_n76 0.001
R13534 AVSS_n100 AVSS_n76 0.001
R13535 AVSS_n78 AVSS_n77 0.001
R13536 AVSS_n106 AVSS_n46 0.001
R13537 AVSS_n101 AVSS_n79 0.001
R13538 AVSS_n105 AVSS_n45 0.001
R13539 AVSS_n88 AVSS_n45 0.001
R13540 AVSS_n104 AVSS_n44 0.001
R13541 AVSS_n102 AVSS_n81 0.001
R13542 AVSS_n103 AVSS_n43 0.001
R13543 AVSS_n3471 AVSS_n3470 0.001
R13544 AVSS_n127 AVSS_n42 0.001
R13545 AVSS_n127 AVSS_n87 0.001
R13546 AVSS_n82 AVSS_n41 0.001
R13547 AVSS_n116 AVSS_n84 0.001
R13548 AVSS_n86 AVSS_n40 0.001
R13549 AVSS_n117 AVSS_n85 0.001
R13550 AVSS_n3472 AVSS_n85 0.001
R13551 AVSS_n3475 AVSS_n3474 0.001
R13552 AVSS_n3478 AVSS_n36 0.001
R13553 AVSS_n35 AVSS_n18 0.001
R13554 AVSS_n2051 AVSS_n18 0.001
R13555 AVSS_n2054 AVSS_n19 0.001
R13556 AVSS_n2049 AVSS_n16 0.001
R13557 AVSS_n2055 AVSS_n20 0.001
R13558 AVSS_n2048 AVSS_n21 0.001
R13559 AVSS_n2052 AVSS_n21 0.001
R13560 AVSS_n2057 AVSS_n22 0.001
R13561 AVSS_n29 AVSS_n14 0.001
R13562 AVSS_n25 AVSS_n23 0.001
R13563 AVSS_n2053 AVSS_n13 0.001
R13564 AVSS_n27 AVSS_n13 0.001
R13565 AVSS_n28 AVSS_n12 0.001
R13566 AVSS_n2061 AVSS_n2060 0.001
R13567 AVSS_n2013 AVSS_n2012 0.001
R13568 AVSS_n1819 AVSS_n1818 0.001
R13569 AVSS_n1523 AVSS_n1522 0.001
R13570 AVSS_n1485 AVSS_n1455 0.001
R13571 AVSS_n1030 AVSS_n1007 0.001
R13572 AVSS_n849 AVSS_n848 0.001
R13573 AVSS_n2039 AVSS_n1919 0.001
R13574 AVSS_n2025 AVSS_n2024 0.001
R13575 AVSS_n2021 AVSS_n2019 0.001
R13576 AVSS_n2018 AVSS_n2017 0.001
R13577 AVSS_n2015 AVSS_n1931 0.001
R13578 AVSS_n2005 AVSS_n1935 0.001
R13579 AVSS_n1992 AVSS_n1940 0.001
R13580 AVSS_n1988 AVSS_n1943 0.001
R13581 AVSS_n1977 AVSS_n1975 0.001
R13582 AVSS_n1969 AVSS_n1952 0.001
R13583 AVSS_n1960 AVSS_n1958 0.001
R13584 AVSS_n1897 AVSS_n1563 0.001
R13585 AVSS_n1881 AVSS_n1880 0.001
R13586 AVSS_n1873 AVSS_n1872 0.001
R13587 AVSS_n1863 AVSS_n1861 0.001
R13588 AVSS_n1856 AVSS_n1855 0.001
R13589 AVSS_n1852 AVSS_n1850 0.001
R13590 AVSS_n1844 AVSS_n1585 0.001
R13591 AVSS_n1839 AVSS_n1588 0.001
R13592 AVSS_n1835 AVSS_n1589 0.001
R13593 AVSS_n1834 AVSS_n1832 0.001
R13594 AVSS_n1820 AVSS_n1597 0.001
R13595 AVSS_n1811 AVSS_n1601 0.001
R13596 AVSS_n1802 AVSS_n1801 0.001
R13597 AVSS_n1784 AVSS_n1782 0.001
R13598 AVSS_n1773 AVSS_n1772 0.001
R13599 AVSS_n1767 AVSS_n1621 0.001
R13600 AVSS_n1763 AVSS_n1623 0.001
R13601 AVSS_n1756 AVSS_n1754 0.001
R13602 AVSS_n1735 AVSS_n1734 0.001
R13603 AVSS_n1707 AVSS_n1705 0.001
R13604 AVSS_n1689 AVSS_n1659 0.001
R13605 AVSS_n1677 AVSS_n1666 0.001
R13606 AVSS_n2766 AVSS_n1534 0.001
R13607 AVSS_n1455 AVSS_n1448 0.001
R13608 AVSS_n1490 AVSS_n1443 0.001
R13609 AVSS_n1027 AVSS_n1007 0.001
R13610 AVSS_n947 AVSS_n849 0.001
R13611 AVSS_n854 AVSS_n853 0.001
R13612 AVSS_n937 AVSS_n936 0.001
R13613 AVSS_n863 AVSS_n793 0.001
R13614 AVSS_n932 AVSS_n795 0.001
R13615 AVSS_n872 AVSS_n803 0.001
R13616 AVSS_n924 AVSS_n805 0.001
R13617 AVSS_n877 AVSS_n809 0.001
R13618 AVSS_n917 AVSS_n813 0.001
R13619 AVSS_n882 AVSS_n815 0.001
R13620 AVSS_n912 AVSS_n819 0.001
R13621 AVSS_n887 AVSS_n821 0.001
R13622 AVSS_n907 AVSS_n825 0.001
R13623 AVSS_n894 AVSS_n829 0.001
R13624 AVSS_n2065 AVSS_n2046 0.001
R13625 AVSS_n2066 AVSS_n2044 0.001
R13626 AVSS_n2067 AVSS_n2042 0.001
R13627 AVSS_n2068 AVSS_n2040 0.001
R13628 AVSS_n2098 AVSS_n2038 0.001
R13629 AVSS_n2069 AVSS_n2033 0.001
R13630 AVSS_n2070 AVSS_n2031 0.001
R13631 AVSS_n2071 AVSS_n2029 0.001
R13632 AVSS_n2097 AVSS_n1924 0.001
R13633 AVSS_n2072 AVSS_n2025 0.001
R13634 AVSS_n2127 AVSS_n1927 0.001
R13635 AVSS_n2096 AVSS_n1928 0.001
R13636 AVSS_n2073 AVSS_n2018 0.001
R13637 AVSS_n2074 AVSS_n2010 0.001
R13638 AVSS_n2075 AVSS_n2008 0.001
R13639 AVSS_n2076 AVSS_n2006 0.001
R13640 AVSS_n2095 AVSS_n1936 0.001
R13641 AVSS_n2094 AVSS_n1937 0.001
R13642 AVSS_n2093 AVSS_n1938 0.001
R13643 AVSS_n2092 AVSS_n1939 0.001
R13644 AVSS_n2091 AVSS_n1940 0.001
R13645 AVSS_n2077 AVSS_n1991 0.001
R13646 AVSS_n2078 AVSS_n1989 0.001
R13647 AVSS_n2090 AVSS_n1944 0.001
R13648 AVSS_n2089 AVSS_n1945 0.001
R13649 AVSS_n2088 AVSS_n1946 0.001
R13650 AVSS_n2087 AVSS_n1947 0.001
R13651 AVSS_n2086 AVSS_n1948 0.001
R13652 AVSS_n2079 AVSS_n1974 0.001
R13653 AVSS_n2080 AVSS_n1972 0.001
R13654 AVSS_n2081 AVSS_n1970 0.001
R13655 AVSS_n2085 AVSS_n1953 0.001
R13656 AVSS_n2084 AVSS_n1954 0.001
R13657 AVSS_n2083 AVSS_n1955 0.001
R13658 AVSS_n2082 AVSS_n1956 0.001
R13659 AVSS_n2764 AVSS_n1912 0.001
R13660 AVSS_n1906 AVSS_n1558 0.001
R13661 AVSS_n1904 AVSS_n1559 0.001
R13662 AVSS_n1903 AVSS_n1902 0.001
R13663 AVSS_n1901 AVSS_n1900 0.001
R13664 AVSS_n1899 AVSS_n1898 0.001
R13665 AVSS_n1895 AVSS_n1564 0.001
R13666 AVSS_n1893 AVSS_n1565 0.001
R13667 AVSS_n1891 AVSS_n1566 0.001
R13668 AVSS_n1890 AVSS_n1888 0.001
R13669 AVSS_n1885 AVSS_n1884 0.001
R13670 AVSS_n1883 AVSS_n1882 0.001
R13671 AVSS_n2548 AVSS_n1881 0.001
R13672 AVSS_n1878 AVSS_n1570 0.001
R13673 AVSS_n1876 AVSS_n1571 0.001
R13674 AVSS_n1874 AVSS_n1572 0.001
R13675 AVSS_n1871 AVSS_n1870 0.001
R13676 AVSS_n1869 AVSS_n1868 0.001
R13677 AVSS_n1867 AVSS_n1866 0.001
R13678 AVSS_n1865 AVSS_n1864 0.001
R13679 AVSS_n1863 AVSS_n1862 0.001
R13680 AVSS_n1859 AVSS_n1579 0.001
R13681 AVSS_n1857 AVSS_n1580 0.001
R13682 AVSS_n1854 AVSS_n1853 0.001
R13683 AVSS_n1852 AVSS_n1851 0.001
R13684 AVSS_n1848 AVSS_n1584 0.001
R13685 AVSS_n1846 AVSS_n1585 0.001
R13686 AVSS_n1843 AVSS_n1842 0.001
R13687 AVSS_n1841 AVSS_n1840 0.001
R13688 AVSS_n1837 AVSS_n1589 0.001
R13689 AVSS_n1834 AVSS_n1833 0.001
R13690 AVSS_n1830 AVSS_n1592 0.001
R13691 AVSS_n1828 AVSS_n1593 0.001
R13692 AVSS_n1826 AVSS_n1594 0.001
R13693 AVSS_n1824 AVSS_n1595 0.001
R13694 AVSS_n1823 AVSS_n1822 0.001
R13695 AVSS_n1817 AVSS_n1816 0.001
R13696 AVSS_n1814 AVSS_n1599 0.001
R13697 AVSS_n1813 AVSS_n1812 0.001
R13698 AVSS_n1809 AVSS_n1602 0.001
R13699 AVSS_n1807 AVSS_n1603 0.001
R13700 AVSS_n1806 AVSS_n1805 0.001
R13701 AVSS_n1803 AVSS_n1605 0.001
R13702 AVSS_n1799 AVSS_n1606 0.001
R13703 AVSS_n1798 AVSS_n1797 0.001
R13704 AVSS_n1796 AVSS_n1795 0.001
R13705 AVSS_n1793 AVSS_n1609 0.001
R13706 AVSS_n1792 AVSS_n1791 0.001
R13707 AVSS_n1790 AVSS_n1789 0.001
R13708 AVSS_n1787 AVSS_n1612 0.001
R13709 AVSS_n1786 AVSS_n1785 0.001
R13710 AVSS_n1784 AVSS_n1783 0.001
R13711 AVSS_n1781 AVSS_n1780 0.001
R13712 AVSS_n1778 AVSS_n1617 0.001
R13713 AVSS_n1777 AVSS_n1776 0.001
R13714 AVSS_n1774 AVSS_n1619 0.001
R13715 AVSS_n1771 AVSS_n1770 0.001
R13716 AVSS_n1769 AVSS_n1768 0.001
R13717 AVSS_n1765 AVSS_n1623 0.001
R13718 AVSS_n1762 AVSS_n1761 0.001
R13719 AVSS_n1759 AVSS_n1625 0.001
R13720 AVSS_n1757 AVSS_n1626 0.001
R13721 AVSS_n1756 AVSS_n1755 0.001
R13722 AVSS_n1753 AVSS_n1752 0.001
R13723 AVSS_n1751 AVSS_n1750 0.001
R13724 AVSS_n1748 AVSS_n1631 0.001
R13725 AVSS_n1746 AVSS_n1632 0.001
R13726 AVSS_n1745 AVSS_n1744 0.001
R13727 AVSS_n1742 AVSS_n1634 0.001
R13728 AVSS_n1740 AVSS_n1635 0.001
R13729 AVSS_n1739 AVSS_n1738 0.001
R13730 AVSS_n1737 AVSS_n1736 0.001
R13731 AVSS_n1733 AVSS_n1732 0.001
R13732 AVSS_n1731 AVSS_n1730 0.001
R13733 AVSS_n1729 AVSS_n1728 0.001
R13734 AVSS_n1727 AVSS_n1726 0.001
R13735 AVSS_n1725 AVSS_n1724 0.001
R13736 AVSS_n1723 AVSS_n1722 0.001
R13737 AVSS_n1720 AVSS_n1644 0.001
R13738 AVSS_n1719 AVSS_n1718 0.001
R13739 AVSS_n1716 AVSS_n1646 0.001
R13740 AVSS_n1715 AVSS_n1714 0.001
R13741 AVSS_n1713 AVSS_n1712 0.001
R13742 AVSS_n1710 AVSS_n1649 0.001
R13743 AVSS_n1708 AVSS_n1650 0.001
R13744 AVSS_n1707 AVSS_n1706 0.001
R13745 AVSS_n1703 AVSS_n1653 0.001
R13746 AVSS_n1701 AVSS_n1654 0.001
R13747 AVSS_n1699 AVSS_n1655 0.001
R13748 AVSS_n1697 AVSS_n1656 0.001
R13749 AVSS_n1696 AVSS_n1695 0.001
R13750 AVSS_n1694 AVSS_n1693 0.001
R13751 AVSS_n1691 AVSS_n1659 0.001
R13752 AVSS_n1688 AVSS_n1687 0.001
R13753 AVSS_n1686 AVSS_n1685 0.001
R13754 AVSS_n1684 AVSS_n1683 0.001
R13755 AVSS_n1682 AVSS_n1681 0.001
R13756 AVSS_n1679 AVSS_n1664 0.001
R13757 AVSS_n1676 AVSS_n1665 0.001
R13758 AVSS_n1674 AVSS_n1667 0.001
R13759 AVSS_n1672 AVSS_n1668 0.001
R13760 AVSS_n1670 AVSS_n1669 0.001
R13761 AVSS_n1527 AVSS_n1515 0.001
R13762 AVSS_n1525 AVSS_n1520 0.001
R13763 AVSS_n1526 AVSS_n1517 0.001
R13764 AVSS_n1543 AVSS_n1518 0.001
R13765 AVSS_n1492 AVSS_n1487 0.001
R13766 AVSS_n2770 AVSS_n1449 0.001
R13767 AVSS_n1493 AVSS_n1484 0.001
R13768 AVSS_n1494 AVSS_n1483 0.001
R13769 AVSS_n1495 AVSS_n1482 0.001
R13770 AVSS_n1496 AVSS_n1481 0.001
R13771 AVSS_n1506 AVSS_n1460 0.001
R13772 AVSS_n1505 AVSS_n1461 0.001
R13773 AVSS_n1497 AVSS_n1443 0.001
R13774 AVSS_n1504 AVSS_n1464 0.001
R13775 AVSS_n1503 AVSS_n1465 0.001
R13776 AVSS_n1502 AVSS_n1466 0.001
R13777 AVSS_n1501 AVSS_n1467 0.001
R13778 AVSS_n1498 AVSS_n1474 0.001
R13779 AVSS_n1499 AVSS_n1471 0.001
R13780 AVSS_n2393 AVSS_n1470 0.001
R13781 AVSS_n1028 AVSS_n1008 0.001
R13782 AVSS_n1051 AVSS_n1009 0.001
R13783 AVSS_n1025 AVSS_n1010 0.001
R13784 AVSS_n1023 AVSS_n1011 0.001
R13785 AVSS_n1020 AVSS_n1018 0.001
R13786 AVSS_n1017 AVSS_n1016 0.001
R13787 AVSS_n1015 AVSS_n1014 0.001
R13788 AVSS_n953 AVSS_n952 0.001
R13789 AVSS_n954 AVSS_n951 0.001
R13790 AVSS_n955 AVSS_n950 0.001
R13791 AVSS_n956 AVSS_n949 0.001
R13792 AVSS_n957 AVSS_n778 0.001
R13793 AVSS_n958 AVSS_n946 0.001
R13794 AVSS_n959 AVSS_n945 0.001
R13795 AVSS_n998 AVSS_n852 0.001
R13796 AVSS_n997 AVSS_n855 0.001
R13797 AVSS_n996 AVSS_n856 0.001
R13798 AVSS_n995 AVSS_n857 0.001
R13799 AVSS_n994 AVSS_n858 0.001
R13800 AVSS_n993 AVSS_n859 0.001
R13801 AVSS_n992 AVSS_n860 0.001
R13802 AVSS_n960 AVSS_n938 0.001
R13803 AVSS_n991 AVSS_n861 0.001
R13804 AVSS_n961 AVSS_n793 0.001
R13805 AVSS_n990 AVSS_n795 0.001
R13806 AVSS_n962 AVSS_n931 0.001
R13807 AVSS_n989 AVSS_n866 0.001
R13808 AVSS_n963 AVSS_n929 0.001
R13809 AVSS_n988 AVSS_n868 0.001
R13810 AVSS_n987 AVSS_n871 0.001
R13811 AVSS_n2302 AVSS_n803 0.001
R13812 AVSS_n986 AVSS_n805 0.001
R13813 AVSS_n965 AVSS_n923 0.001
R13814 AVSS_n985 AVSS_n875 0.001
R13815 AVSS_n966 AVSS_n809 0.001
R13816 AVSS_n984 AVSS_n879 0.001
R13817 AVSS_n967 AVSS_n920 0.001
R13818 AVSS_n983 AVSS_n813 0.001
R13819 AVSS_n968 AVSS_n815 0.001
R13820 AVSS_n982 AVSS_n884 0.001
R13821 AVSS_n969 AVSS_n915 0.001
R13822 AVSS_n981 AVSS_n819 0.001
R13823 AVSS_n970 AVSS_n821 0.001
R13824 AVSS_n980 AVSS_n889 0.001
R13825 AVSS_n971 AVSS_n910 0.001
R13826 AVSS_n979 AVSS_n825 0.001
R13827 AVSS_n972 AVSS_n906 0.001
R13828 AVSS_n978 AVSS_n892 0.001
R13829 AVSS_n973 AVSS_n829 0.001
R13830 AVSS_n977 AVSS_n896 0.001
R13831 AVSS_n974 AVSS_n903 0.001
R13832 AVSS_n976 AVSS_n898 0.001
R13833 AVSS_n975 AVSS_n901 0.001
R13834 AVSS_n2816 AVSS_n839 0.001
R13835 AVSS_n2762 AVSS_n2101 0.001
R13836 AVSS_n2046 AVSS_n2045 0.001
R13837 AVSS_n2043 AVSS_n1918 0.001
R13838 AVSS_n2041 AVSS_n1919 0.001
R13839 AVSS_n2035 AVSS_n2034 0.001
R13840 AVSS_n2033 AVSS_n2032 0.001
R13841 AVSS_n2031 AVSS_n2030 0.001
R13842 AVSS_n2028 AVSS_n1924 0.001
R13843 AVSS_n2027 AVSS_n2026 0.001
R13844 AVSS_n2126 AVSS_n1926 0.001
R13845 AVSS_n2022 AVSS_n1927 0.001
R13846 AVSS_n2021 AVSS_n2020 0.001
R13847 AVSS_n2014 AVSS_n1930 0.001
R13848 AVSS_n2013 AVSS_n2011 0.001
R13849 AVSS_n2010 AVSS_n2009 0.001
R13850 AVSS_n2008 AVSS_n2007 0.001
R13851 AVSS_n2003 AVSS_n1935 0.001
R13852 AVSS_n2001 AVSS_n1936 0.001
R13853 AVSS_n1999 AVSS_n1937 0.001
R13854 AVSS_n1997 AVSS_n1938 0.001
R13855 AVSS_n1995 AVSS_n1939 0.001
R13856 AVSS_n1994 AVSS_n1993 0.001
R13857 AVSS_n1991 AVSS_n1990 0.001
R13858 AVSS_n1986 AVSS_n1943 0.001
R13859 AVSS_n1984 AVSS_n1944 0.001
R13860 AVSS_n1982 AVSS_n1945 0.001
R13861 AVSS_n1980 AVSS_n1946 0.001
R13862 AVSS_n1978 AVSS_n1947 0.001
R13863 AVSS_n1977 AVSS_n1976 0.001
R13864 AVSS_n1974 AVSS_n1973 0.001
R13865 AVSS_n1972 AVSS_n1971 0.001
R13866 AVSS_n1967 AVSS_n1952 0.001
R13867 AVSS_n1965 AVSS_n1953 0.001
R13868 AVSS_n1963 AVSS_n1954 0.001
R13869 AVSS_n1961 AVSS_n1955 0.001
R13870 AVSS_n1960 AVSS_n1959 0.001
R13871 AVSS_n1908 AVSS_n1558 0.001
R13872 AVSS_n2545 AVSS_n1559 0.001
R13873 AVSS_n2445 AVSS_n1905 0.001
R13874 AVSS_n2446 AVSS_n1903 0.001
R13875 AVSS_n2447 AVSS_n1901 0.001
R13876 AVSS_n2544 AVSS_n1563 0.001
R13877 AVSS_n2543 AVSS_n1564 0.001
R13878 AVSS_n2542 AVSS_n1565 0.001
R13879 AVSS_n2448 AVSS_n1886 0.001
R13880 AVSS_n2449 AVSS_n1885 0.001
R13881 AVSS_n2547 AVSS_n1883 0.001
R13882 AVSS_n2540 AVSS_n1569 0.001
R13883 AVSS_n2539 AVSS_n1570 0.001
R13884 AVSS_n2538 AVSS_n1571 0.001
R13885 AVSS_n2450 AVSS_n1873 0.001
R13886 AVSS_n2451 AVSS_n1871 0.001
R13887 AVSS_n2452 AVSS_n1869 0.001
R13888 AVSS_n2453 AVSS_n1867 0.001
R13889 AVSS_n2537 AVSS_n1577 0.001
R13890 AVSS_n2536 AVSS_n1578 0.001
R13891 AVSS_n2454 AVSS_n1858 0.001
R13892 AVSS_n2455 AVSS_n1856 0.001
R13893 AVSS_n2456 AVSS_n1854 0.001
R13894 AVSS_n2535 AVSS_n1583 0.001
R13895 AVSS_n2534 AVSS_n1584 0.001
R13896 AVSS_n2457 AVSS_n1845 0.001
R13897 AVSS_n2458 AVSS_n1843 0.001
R13898 AVSS_n2533 AVSS_n1588 0.001
R13899 AVSS_n2459 AVSS_n1836 0.001
R13900 AVSS_n2532 AVSS_n1591 0.001
R13901 AVSS_n2531 AVSS_n1592 0.001
R13902 AVSS_n2530 AVSS_n1593 0.001
R13903 AVSS_n2529 AVSS_n1594 0.001
R13904 AVSS_n2460 AVSS_n1823 0.001
R13905 AVSS_n2528 AVSS_n1596 0.001
R13906 AVSS_n2462 AVSS_n1819 0.001
R13907 AVSS_n2527 AVSS_n1599 0.001
R13908 AVSS_n2526 AVSS_n1600 0.001
R13909 AVSS_n2525 AVSS_n1601 0.001
R13910 AVSS_n2524 AVSS_n1602 0.001
R13911 AVSS_n2463 AVSS_n1806 0.001
R13912 AVSS_n2523 AVSS_n1604 0.001
R13913 AVSS_n2464 AVSS_n1802 0.001
R13914 AVSS_n2465 AVSS_n1800 0.001
R13915 AVSS_n2466 AVSS_n1798 0.001
R13916 AVSS_n2522 AVSS_n1609 0.001
R13917 AVSS_n2467 AVSS_n1794 0.001
R13918 AVSS_n2468 AVSS_n1792 0.001
R13919 AVSS_n2469 AVSS_n1790 0.001
R13920 AVSS_n2470 AVSS_n1788 0.001
R13921 AVSS_n2521 AVSS_n1614 0.001
R13922 AVSS_n2520 AVSS_n1615 0.001
R13923 AVSS_n2519 AVSS_n1616 0.001
R13924 AVSS_n2471 AVSS_n1777 0.001
R13925 AVSS_n2518 AVSS_n1618 0.001
R13926 AVSS_n2472 AVSS_n1773 0.001
R13927 AVSS_n2517 AVSS_n1621 0.001
R13928 AVSS_n2516 AVSS_n1622 0.001
R13929 AVSS_n2473 AVSS_n1764 0.001
R13930 AVSS_n2474 AVSS_n1762 0.001
R13931 AVSS_n2475 AVSS_n1760 0.001
R13932 AVSS_n2476 AVSS_n1758 0.001
R13933 AVSS_n2515 AVSS_n1628 0.001
R13934 AVSS_n2514 AVSS_n1629 0.001
R13935 AVSS_n2513 AVSS_n1630 0.001
R13936 AVSS_n2512 AVSS_n1631 0.001
R13937 AVSS_n2477 AVSS_n1745 0.001
R13938 AVSS_n2511 AVSS_n1633 0.001
R13939 AVSS_n2510 AVSS_n1634 0.001
R13940 AVSS_n2478 AVSS_n1739 0.001
R13941 AVSS_n2479 AVSS_n1737 0.001
R13942 AVSS_n2480 AVSS_n1735 0.001
R13943 AVSS_n2481 AVSS_n1733 0.001
R13944 AVSS_n2482 AVSS_n1731 0.001
R13945 AVSS_n2483 AVSS_n1729 0.001
R13946 AVSS_n2484 AVSS_n1727 0.001
R13947 AVSS_n2485 AVSS_n1725 0.001
R13948 AVSS_n2509 AVSS_n1644 0.001
R13949 AVSS_n2486 AVSS_n1721 0.001
R13950 AVSS_n2508 AVSS_n1646 0.001
R13951 AVSS_n2487 AVSS_n1717 0.001
R13952 AVSS_n2488 AVSS_n1715 0.001
R13953 AVSS_n2507 AVSS_n1649 0.001
R13954 AVSS_n2506 AVSS_n1650 0.001
R13955 AVSS_n2505 AVSS_n1651 0.001
R13956 AVSS_n2504 AVSS_n1652 0.001
R13957 AVSS_n2503 AVSS_n1653 0.001
R13958 AVSS_n2502 AVSS_n1654 0.001
R13959 AVSS_n2501 AVSS_n1655 0.001
R13960 AVSS_n2489 AVSS_n1696 0.001
R13961 AVSS_n2490 AVSS_n1694 0.001
R13962 AVSS_n2491 AVSS_n1692 0.001
R13963 AVSS_n2492 AVSS_n1690 0.001
R13964 AVSS_n2493 AVSS_n1688 0.001
R13965 AVSS_n2494 AVSS_n1686 0.001
R13966 AVSS_n2495 AVSS_n1684 0.001
R13967 AVSS_n2500 AVSS_n1664 0.001
R13968 AVSS_n2499 AVSS_n1665 0.001
R13969 AVSS_n2498 AVSS_n1666 0.001
R13970 AVSS_n2497 AVSS_n1667 0.001
R13971 AVSS_n2496 AVSS_n1668 0.001
R13972 AVSS_n1669 AVSS_n1536 0.001
R13973 AVSS_n1532 AVSS_n1515 0.001
R13974 AVSS_n1529 AVSS_n1521 0.001
R13975 AVSS_n1531 AVSS_n1517 0.001
R13976 AVSS_n1542 AVSS_n1519 0.001
R13977 AVSS_n2768 AVSS_n1427 0.001
R13978 AVSS_n1487 AVSS_n1428 0.001
R13979 AVSS_n1486 AVSS_n1429 0.001
R13980 AVSS_n1484 AVSS_n1430 0.001
R13981 AVSS_n1483 AVSS_n1431 0.001
R13982 AVSS_n1482 AVSS_n1432 0.001
R13983 AVSS_n1460 AVSS_n1446 0.001
R13984 AVSS_n1461 AVSS_n1445 0.001
R13985 AVSS_n1462 AVSS_n1444 0.001
R13986 AVSS_n1463 AVSS_n1442 0.001
R13987 AVSS_n1464 AVSS_n1441 0.001
R13988 AVSS_n1465 AVSS_n1440 0.001
R13989 AVSS_n1466 AVSS_n1439 0.001
R13990 AVSS_n1474 AVSS_n1433 0.001
R13991 AVSS_n1468 AVSS_n1438 0.001
R13992 AVSS_n1471 AVSS_n1434 0.001
R13993 AVSS_n1469 AVSS_n1437 0.001
R13994 AVSS_n1470 AVSS_n1436 0.001
R13995 AVSS_n2812 AVSS_n1038 0.001
R13996 AVSS_n1050 AVSS_n1008 0.001
R13997 AVSS_n1036 AVSS_n1009 0.001
R13998 AVSS_n1035 AVSS_n1010 0.001
R13999 AVSS_n1031 AVSS_n1018 0.001
R14000 AVSS_n1032 AVSS_n1017 0.001
R14001 AVSS_n1015 AVSS_n1000 0.001
R14002 AVSS_n2814 AVSS_n773 0.001
R14003 AVSS_n952 AVSS_n774 0.001
R14004 AVSS_n951 AVSS_n775 0.001
R14005 AVSS_n950 AVSS_n776 0.001
R14006 AVSS_n949 AVSS_n777 0.001
R14007 AVSS_n948 AVSS_n779 0.001
R14008 AVSS_n946 AVSS_n780 0.001
R14009 AVSS_n852 AVSS_n781 0.001
R14010 AVSS_n854 AVSS_n783 0.001
R14011 AVSS_n855 AVSS_n784 0.001
R14012 AVSS_n856 AVSS_n785 0.001
R14013 AVSS_n857 AVSS_n786 0.001
R14014 AVSS_n858 AVSS_n787 0.001
R14015 AVSS_n859 AVSS_n788 0.001
R14016 AVSS_n938 AVSS_n789 0.001
R14017 AVSS_n937 AVSS_n791 0.001
R14018 AVSS_n935 AVSS_n792 0.001
R14019 AVSS_n864 AVSS_n794 0.001
R14020 AVSS_n933 AVSS_n796 0.001
R14021 AVSS_n931 AVSS_n797 0.001
R14022 AVSS_n930 AVSS_n798 0.001
R14023 AVSS_n929 AVSS_n799 0.001
R14024 AVSS_n928 AVSS_n800 0.001
R14025 AVSS_n870 AVSS_n801 0.001
R14026 AVSS_n927 AVSS_n802 0.001
R14027 AVSS_n873 AVSS_n804 0.001
R14028 AVSS_n925 AVSS_n806 0.001
R14029 AVSS_n923 AVSS_n807 0.001
R14030 AVSS_n922 AVSS_n808 0.001
R14031 AVSS_n878 AVSS_n810 0.001
R14032 AVSS_n879 AVSS_n811 0.001
R14033 AVSS_n880 AVSS_n812 0.001
R14034 AVSS_n918 AVSS_n814 0.001
R14035 AVSS_n883 AVSS_n816 0.001
R14036 AVSS_n884 AVSS_n817 0.001
R14037 AVSS_n885 AVSS_n818 0.001
R14038 AVSS_n913 AVSS_n820 0.001
R14039 AVSS_n888 AVSS_n822 0.001
R14040 AVSS_n889 AVSS_n823 0.001
R14041 AVSS_n890 AVSS_n824 0.001
R14042 AVSS_n908 AVSS_n826 0.001
R14043 AVSS_n906 AVSS_n827 0.001
R14044 AVSS_n905 AVSS_n828 0.001
R14045 AVSS_n895 AVSS_n830 0.001
R14046 AVSS_n896 AVSS_n831 0.001
R14047 AVSS_n897 AVSS_n832 0.001
R14048 AVSS_n898 AVSS_n833 0.001
R14049 AVSS_n899 AVSS_n834 0.001
R14050 AVSS_n2817 AVSS_n2816 0.001
R14051 AVSS_n2817 AVSS_n836 0.001
R14052 AVSS_n900 AVSS_n839 0.001
R14053 AVSS_n900 AVSS_n834 0.001
R14054 AVSS_n975 AVSS_n899 0.001
R14055 AVSS_n901 AVSS_n833 0.001
R14056 AVSS_n976 AVSS_n902 0.001
R14057 AVSS_n902 AVSS_n832 0.001
R14058 AVSS_n974 AVSS_n897 0.001
R14059 AVSS_n903 AVSS_n831 0.001
R14060 AVSS_n977 AVSS_n904 0.001
R14061 AVSS_n904 AVSS_n830 0.001
R14062 AVSS_n895 AVSS_n894 0.001
R14063 AVSS_n973 AVSS_n893 0.001
R14064 AVSS_n893 AVSS_n828 0.001
R14065 AVSS_n978 AVSS_n905 0.001
R14066 AVSS_n892 AVSS_n827 0.001
R14067 AVSS_n972 AVSS_n891 0.001
R14068 AVSS_n891 AVSS_n826 0.001
R14069 AVSS_n908 AVSS_n907 0.001
R14070 AVSS_n979 AVSS_n909 0.001
R14071 AVSS_n909 AVSS_n824 0.001
R14072 AVSS_n971 AVSS_n890 0.001
R14073 AVSS_n910 AVSS_n823 0.001
R14074 AVSS_n980 AVSS_n911 0.001
R14075 AVSS_n911 AVSS_n822 0.001
R14076 AVSS_n888 AVSS_n887 0.001
R14077 AVSS_n970 AVSS_n886 0.001
R14078 AVSS_n886 AVSS_n820 0.001
R14079 AVSS_n913 AVSS_n912 0.001
R14080 AVSS_n981 AVSS_n914 0.001
R14081 AVSS_n914 AVSS_n818 0.001
R14082 AVSS_n969 AVSS_n885 0.001
R14083 AVSS_n915 AVSS_n817 0.001
R14084 AVSS_n982 AVSS_n916 0.001
R14085 AVSS_n916 AVSS_n816 0.001
R14086 AVSS_n883 AVSS_n882 0.001
R14087 AVSS_n968 AVSS_n881 0.001
R14088 AVSS_n881 AVSS_n814 0.001
R14089 AVSS_n918 AVSS_n917 0.001
R14090 AVSS_n983 AVSS_n919 0.001
R14091 AVSS_n919 AVSS_n812 0.001
R14092 AVSS_n967 AVSS_n880 0.001
R14093 AVSS_n920 AVSS_n811 0.001
R14094 AVSS_n984 AVSS_n921 0.001
R14095 AVSS_n921 AVSS_n810 0.001
R14096 AVSS_n878 AVSS_n877 0.001
R14097 AVSS_n966 AVSS_n876 0.001
R14098 AVSS_n876 AVSS_n808 0.001
R14099 AVSS_n985 AVSS_n922 0.001
R14100 AVSS_n875 AVSS_n807 0.001
R14101 AVSS_n965 AVSS_n874 0.001
R14102 AVSS_n874 AVSS_n806 0.001
R14103 AVSS_n925 AVSS_n924 0.001
R14104 AVSS_n986 AVSS_n926 0.001
R14105 AVSS_n926 AVSS_n804 0.001
R14106 AVSS_n873 AVSS_n872 0.001
R14107 AVSS_n2304 AVSS_n2302 0.001
R14108 AVSS_n2304 AVSS_n802 0.001
R14109 AVSS_n987 AVSS_n927 0.001
R14110 AVSS_n871 AVSS_n801 0.001
R14111 AVSS_n870 AVSS_n800 0.001
R14112 AVSS_n988 AVSS_n928 0.001
R14113 AVSS_n868 AVSS_n799 0.001
R14114 AVSS_n963 AVSS_n867 0.001
R14115 AVSS_n867 AVSS_n798 0.001
R14116 AVSS_n989 AVSS_n930 0.001
R14117 AVSS_n866 AVSS_n797 0.001
R14118 AVSS_n962 AVSS_n865 0.001
R14119 AVSS_n865 AVSS_n796 0.001
R14120 AVSS_n933 AVSS_n932 0.001
R14121 AVSS_n990 AVSS_n934 0.001
R14122 AVSS_n934 AVSS_n794 0.001
R14123 AVSS_n864 AVSS_n863 0.001
R14124 AVSS_n961 AVSS_n862 0.001
R14125 AVSS_n862 AVSS_n792 0.001
R14126 AVSS_n991 AVSS_n935 0.001
R14127 AVSS_n861 AVSS_n791 0.001
R14128 AVSS_n936 AVSS_n790 0.001
R14129 AVSS_n960 AVSS_n790 0.001
R14130 AVSS_n860 AVSS_n789 0.001
R14131 AVSS_n992 AVSS_n939 0.001
R14132 AVSS_n939 AVSS_n788 0.001
R14133 AVSS_n993 AVSS_n940 0.001
R14134 AVSS_n940 AVSS_n787 0.001
R14135 AVSS_n994 AVSS_n941 0.001
R14136 AVSS_n941 AVSS_n786 0.001
R14137 AVSS_n995 AVSS_n942 0.001
R14138 AVSS_n942 AVSS_n785 0.001
R14139 AVSS_n996 AVSS_n943 0.001
R14140 AVSS_n943 AVSS_n784 0.001
R14141 AVSS_n997 AVSS_n944 0.001
R14142 AVSS_n944 AVSS_n783 0.001
R14143 AVSS_n853 AVSS_n782 0.001
R14144 AVSS_n998 AVSS_n782 0.001
R14145 AVSS_n945 AVSS_n781 0.001
R14146 AVSS_n959 AVSS_n851 0.001
R14147 AVSS_n851 AVSS_n780 0.001
R14148 AVSS_n958 AVSS_n850 0.001
R14149 AVSS_n850 AVSS_n779 0.001
R14150 AVSS_n948 AVSS_n947 0.001
R14151 AVSS_n848 AVSS_n778 0.001
R14152 AVSS_n957 AVSS_n847 0.001
R14153 AVSS_n847 AVSS_n777 0.001
R14154 AVSS_n956 AVSS_n846 0.001
R14155 AVSS_n846 AVSS_n776 0.001
R14156 AVSS_n955 AVSS_n845 0.001
R14157 AVSS_n845 AVSS_n775 0.001
R14158 AVSS_n954 AVSS_n844 0.001
R14159 AVSS_n844 AVSS_n774 0.001
R14160 AVSS_n953 AVSS_n843 0.001
R14161 AVSS_n843 AVSS_n773 0.001
R14162 AVSS_n2814 AVSS_n1000 0.001
R14163 AVSS_n1014 AVSS_n1013 0.001
R14164 AVSS_n1032 AVSS_n1013 0.001
R14165 AVSS_n1016 AVSS_n1012 0.001
R14166 AVSS_n1031 AVSS_n1012 0.001
R14167 AVSS_n1022 AVSS_n1020 0.001
R14168 AVSS_n1024 AVSS_n1023 0.001
R14169 AVSS_n1035 AVSS_n1024 0.001
R14170 AVSS_n1026 AVSS_n1025 0.001
R14171 AVSS_n1036 AVSS_n1026 0.001
R14172 AVSS_n1053 AVSS_n1051 0.001
R14173 AVSS_n1053 AVSS_n1050 0.001
R14174 AVSS_n1029 AVSS_n1028 0.001
R14175 AVSS_n1029 AVSS_n1027 0.001
R14176 AVSS_n2812 AVSS_n1030 0.001
R14177 AVSS_n1059 AVSS_n1038 0.001
R14178 AVSS_n1436 AVSS_n1059 0.001
R14179 AVSS_n2395 AVSS_n2393 0.001
R14180 AVSS_n2395 AVSS_n1437 0.001
R14181 AVSS_n1499 AVSS_n1469 0.001
R14182 AVSS_n1473 AVSS_n1434 0.001
R14183 AVSS_n1473 AVSS_n1438 0.001
R14184 AVSS_n1498 AVSS_n1468 0.001
R14185 AVSS_n1467 AVSS_n1433 0.001
R14186 AVSS_n1501 AVSS_n1475 0.001
R14187 AVSS_n1475 AVSS_n1439 0.001
R14188 AVSS_n1502 AVSS_n1476 0.001
R14189 AVSS_n1476 AVSS_n1440 0.001
R14190 AVSS_n1503 AVSS_n1477 0.001
R14191 AVSS_n1477 AVSS_n1441 0.001
R14192 AVSS_n1504 AVSS_n1478 0.001
R14193 AVSS_n1478 AVSS_n1442 0.001
R14194 AVSS_n1490 AVSS_n1463 0.001
R14195 AVSS_n1497 AVSS_n1462 0.001
R14196 AVSS_n1479 AVSS_n1444 0.001
R14197 AVSS_n1505 AVSS_n1479 0.001
R14198 AVSS_n1480 AVSS_n1445 0.001
R14199 AVSS_n1506 AVSS_n1480 0.001
R14200 AVSS_n1481 AVSS_n1446 0.001
R14201 AVSS_n1496 AVSS_n1459 0.001
R14202 AVSS_n1459 AVSS_n1432 0.001
R14203 AVSS_n1495 AVSS_n1458 0.001
R14204 AVSS_n1458 AVSS_n1431 0.001
R14205 AVSS_n1494 AVSS_n1457 0.001
R14206 AVSS_n1457 AVSS_n1430 0.001
R14207 AVSS_n1493 AVSS_n1456 0.001
R14208 AVSS_n1456 AVSS_n1429 0.001
R14209 AVSS_n1486 AVSS_n1485 0.001
R14210 AVSS_n2770 AVSS_n1448 0.001
R14211 AVSS_n1454 AVSS_n1449 0.001
R14212 AVSS_n1454 AVSS_n1428 0.001
R14213 AVSS_n1492 AVSS_n1453 0.001
R14214 AVSS_n1453 AVSS_n1427 0.001
R14215 AVSS_n1546 AVSS_n1543 0.001
R14216 AVSS_n1546 AVSS_n1542 0.001
R14217 AVSS_n1526 AVSS_n1519 0.001
R14218 AVSS_n1531 AVSS_n1520 0.001
R14219 AVSS_n1525 AVSS_n1516 0.001
R14220 AVSS_n1529 AVSS_n1516 0.001
R14221 AVSS_n1527 AVSS_n1521 0.001
R14222 AVSS_n1532 AVSS_n1522 0.001
R14223 AVSS_n1523 AVSS_n1514 0.001
R14224 AVSS_n1534 AVSS_n1514 0.001
R14225 AVSS_n2766 AVSS_n1536 0.001
R14226 AVSS_n1671 AVSS_n1670 0.001
R14227 AVSS_n2496 AVSS_n1671 0.001
R14228 AVSS_n1673 AVSS_n1672 0.001
R14229 AVSS_n2497 AVSS_n1673 0.001
R14230 AVSS_n1675 AVSS_n1674 0.001
R14231 AVSS_n2498 AVSS_n1675 0.001
R14232 AVSS_n1678 AVSS_n1677 0.001
R14233 AVSS_n1678 AVSS_n1676 0.001
R14234 AVSS_n2499 AVSS_n1680 0.001
R14235 AVSS_n1680 AVSS_n1679 0.001
R14236 AVSS_n2500 AVSS_n1682 0.001
R14237 AVSS_n1681 AVSS_n1663 0.001
R14238 AVSS_n2495 AVSS_n1663 0.001
R14239 AVSS_n1683 AVSS_n1662 0.001
R14240 AVSS_n2494 AVSS_n1662 0.001
R14241 AVSS_n1685 AVSS_n1661 0.001
R14242 AVSS_n2493 AVSS_n1661 0.001
R14243 AVSS_n1687 AVSS_n1660 0.001
R14244 AVSS_n2492 AVSS_n1660 0.001
R14245 AVSS_n1690 AVSS_n1689 0.001
R14246 AVSS_n1692 AVSS_n1691 0.001
R14247 AVSS_n2491 AVSS_n1658 0.001
R14248 AVSS_n1693 AVSS_n1658 0.001
R14249 AVSS_n2490 AVSS_n1657 0.001
R14250 AVSS_n1695 AVSS_n1657 0.001
R14251 AVSS_n2489 AVSS_n1656 0.001
R14252 AVSS_n1698 AVSS_n1697 0.001
R14253 AVSS_n2501 AVSS_n1698 0.001
R14254 AVSS_n1700 AVSS_n1699 0.001
R14255 AVSS_n2502 AVSS_n1700 0.001
R14256 AVSS_n1702 AVSS_n1701 0.001
R14257 AVSS_n2503 AVSS_n1702 0.001
R14258 AVSS_n1704 AVSS_n1703 0.001
R14259 AVSS_n2504 AVSS_n1704 0.001
R14260 AVSS_n1705 AVSS_n1652 0.001
R14261 AVSS_n1706 AVSS_n1651 0.001
R14262 AVSS_n2505 AVSS_n1709 0.001
R14263 AVSS_n1709 AVSS_n1708 0.001
R14264 AVSS_n2506 AVSS_n1711 0.001
R14265 AVSS_n1711 AVSS_n1710 0.001
R14266 AVSS_n2507 AVSS_n1713 0.001
R14267 AVSS_n1712 AVSS_n1648 0.001
R14268 AVSS_n2488 AVSS_n1648 0.001
R14269 AVSS_n1714 AVSS_n1647 0.001
R14270 AVSS_n2487 AVSS_n1647 0.001
R14271 AVSS_n1717 AVSS_n1716 0.001
R14272 AVSS_n2508 AVSS_n1719 0.001
R14273 AVSS_n1718 AVSS_n1645 0.001
R14274 AVSS_n2486 AVSS_n1645 0.001
R14275 AVSS_n1721 AVSS_n1720 0.001
R14276 AVSS_n2509 AVSS_n1723 0.001
R14277 AVSS_n1722 AVSS_n1643 0.001
R14278 AVSS_n2485 AVSS_n1643 0.001
R14279 AVSS_n1724 AVSS_n1642 0.001
R14280 AVSS_n2484 AVSS_n1642 0.001
R14281 AVSS_n1726 AVSS_n1641 0.001
R14282 AVSS_n2483 AVSS_n1641 0.001
R14283 AVSS_n1728 AVSS_n1640 0.001
R14284 AVSS_n2482 AVSS_n1640 0.001
R14285 AVSS_n1730 AVSS_n1639 0.001
R14286 AVSS_n2481 AVSS_n1639 0.001
R14287 AVSS_n1732 AVSS_n1638 0.001
R14288 AVSS_n2480 AVSS_n1638 0.001
R14289 AVSS_n1734 AVSS_n1637 0.001
R14290 AVSS_n1736 AVSS_n1637 0.001
R14291 AVSS_n2479 AVSS_n1636 0.001
R14292 AVSS_n1738 AVSS_n1636 0.001
R14293 AVSS_n2478 AVSS_n1635 0.001
R14294 AVSS_n1741 AVSS_n1740 0.001
R14295 AVSS_n2510 AVSS_n1741 0.001
R14296 AVSS_n1743 AVSS_n1742 0.001
R14297 AVSS_n2511 AVSS_n1743 0.001
R14298 AVSS_n1744 AVSS_n1633 0.001
R14299 AVSS_n2477 AVSS_n1632 0.001
R14300 AVSS_n1747 AVSS_n1746 0.001
R14301 AVSS_n2512 AVSS_n1747 0.001
R14302 AVSS_n1749 AVSS_n1748 0.001
R14303 AVSS_n2513 AVSS_n1749 0.001
R14304 AVSS_n1750 AVSS_n1630 0.001
R14305 AVSS_n2514 AVSS_n1751 0.001
R14306 AVSS_n1752 AVSS_n1629 0.001
R14307 AVSS_n2515 AVSS_n1753 0.001
R14308 AVSS_n1754 AVSS_n1628 0.001
R14309 AVSS_n1755 AVSS_n1627 0.001
R14310 AVSS_n2476 AVSS_n1627 0.001
R14311 AVSS_n1758 AVSS_n1757 0.001
R14312 AVSS_n2475 AVSS_n1626 0.001
R14313 AVSS_n1760 AVSS_n1759 0.001
R14314 AVSS_n2474 AVSS_n1625 0.001
R14315 AVSS_n1761 AVSS_n1624 0.001
R14316 AVSS_n2473 AVSS_n1624 0.001
R14317 AVSS_n1764 AVSS_n1763 0.001
R14318 AVSS_n1766 AVSS_n1765 0.001
R14319 AVSS_n2516 AVSS_n1766 0.001
R14320 AVSS_n1768 AVSS_n1622 0.001
R14321 AVSS_n1769 AVSS_n1767 0.001
R14322 AVSS_n2517 AVSS_n1771 0.001
R14323 AVSS_n1770 AVSS_n1620 0.001
R14324 AVSS_n2472 AVSS_n1620 0.001
R14325 AVSS_n1772 AVSS_n1619 0.001
R14326 AVSS_n1775 AVSS_n1774 0.001
R14327 AVSS_n2518 AVSS_n1775 0.001
R14328 AVSS_n1776 AVSS_n1618 0.001
R14329 AVSS_n2471 AVSS_n1617 0.001
R14330 AVSS_n1779 AVSS_n1778 0.001
R14331 AVSS_n2519 AVSS_n1779 0.001
R14332 AVSS_n1780 AVSS_n1616 0.001
R14333 AVSS_n2520 AVSS_n1781 0.001
R14334 AVSS_n1783 AVSS_n1615 0.001
R14335 AVSS_n1782 AVSS_n1614 0.001
R14336 AVSS_n2521 AVSS_n1786 0.001
R14337 AVSS_n1785 AVSS_n1613 0.001
R14338 AVSS_n2470 AVSS_n1613 0.001
R14339 AVSS_n1788 AVSS_n1787 0.001
R14340 AVSS_n2469 AVSS_n1612 0.001
R14341 AVSS_n1789 AVSS_n1611 0.001
R14342 AVSS_n2468 AVSS_n1611 0.001
R14343 AVSS_n1791 AVSS_n1610 0.001
R14344 AVSS_n2467 AVSS_n1610 0.001
R14345 AVSS_n1794 AVSS_n1793 0.001
R14346 AVSS_n2522 AVSS_n1796 0.001
R14347 AVSS_n1795 AVSS_n1608 0.001
R14348 AVSS_n2466 AVSS_n1608 0.001
R14349 AVSS_n1797 AVSS_n1607 0.001
R14350 AVSS_n2465 AVSS_n1607 0.001
R14351 AVSS_n1800 AVSS_n1799 0.001
R14352 AVSS_n2464 AVSS_n1606 0.001
R14353 AVSS_n1801 AVSS_n1605 0.001
R14354 AVSS_n1804 AVSS_n1803 0.001
R14355 AVSS_n2523 AVSS_n1804 0.001
R14356 AVSS_n1805 AVSS_n1604 0.001
R14357 AVSS_n2463 AVSS_n1603 0.001
R14358 AVSS_n1808 AVSS_n1807 0.001
R14359 AVSS_n2524 AVSS_n1808 0.001
R14360 AVSS_n1810 AVSS_n1809 0.001
R14361 AVSS_n2525 AVSS_n1810 0.001
R14362 AVSS_n1813 AVSS_n1811 0.001
R14363 AVSS_n1812 AVSS_n1600 0.001
R14364 AVSS_n2526 AVSS_n1815 0.001
R14365 AVSS_n1815 AVSS_n1814 0.001
R14366 AVSS_n2527 AVSS_n1817 0.001
R14367 AVSS_n1816 AVSS_n1598 0.001
R14368 AVSS_n2462 AVSS_n1598 0.001
R14369 AVSS_n1818 AVSS_n1597 0.001
R14370 AVSS_n1821 AVSS_n1820 0.001
R14371 AVSS_n2528 AVSS_n1821 0.001
R14372 AVSS_n1822 AVSS_n1596 0.001
R14373 AVSS_n2460 AVSS_n1595 0.001
R14374 AVSS_n1825 AVSS_n1824 0.001
R14375 AVSS_n2529 AVSS_n1825 0.001
R14376 AVSS_n1827 AVSS_n1826 0.001
R14377 AVSS_n2530 AVSS_n1827 0.001
R14378 AVSS_n1829 AVSS_n1828 0.001
R14379 AVSS_n2531 AVSS_n1829 0.001
R14380 AVSS_n1831 AVSS_n1830 0.001
R14381 AVSS_n2532 AVSS_n1831 0.001
R14382 AVSS_n1832 AVSS_n1591 0.001
R14383 AVSS_n1833 AVSS_n1590 0.001
R14384 AVSS_n2459 AVSS_n1590 0.001
R14385 AVSS_n1836 AVSS_n1835 0.001
R14386 AVSS_n1838 AVSS_n1837 0.001
R14387 AVSS_n2533 AVSS_n1838 0.001
R14388 AVSS_n1841 AVSS_n1839 0.001
R14389 AVSS_n1840 AVSS_n1587 0.001
R14390 AVSS_n2458 AVSS_n1587 0.001
R14391 AVSS_n1842 AVSS_n1586 0.001
R14392 AVSS_n2457 AVSS_n1586 0.001
R14393 AVSS_n1845 AVSS_n1844 0.001
R14394 AVSS_n1847 AVSS_n1846 0.001
R14395 AVSS_n2534 AVSS_n1847 0.001
R14396 AVSS_n1849 AVSS_n1848 0.001
R14397 AVSS_n2535 AVSS_n1849 0.001
R14398 AVSS_n1850 AVSS_n1583 0.001
R14399 AVSS_n1851 AVSS_n1582 0.001
R14400 AVSS_n2456 AVSS_n1582 0.001
R14401 AVSS_n1853 AVSS_n1581 0.001
R14402 AVSS_n2455 AVSS_n1581 0.001
R14403 AVSS_n1855 AVSS_n1580 0.001
R14404 AVSS_n1858 AVSS_n1857 0.001
R14405 AVSS_n2454 AVSS_n1579 0.001
R14406 AVSS_n1860 AVSS_n1859 0.001
R14407 AVSS_n2536 AVSS_n1860 0.001
R14408 AVSS_n1862 AVSS_n1578 0.001
R14409 AVSS_n1861 AVSS_n1577 0.001
R14410 AVSS_n2537 AVSS_n1865 0.001
R14411 AVSS_n1864 AVSS_n1576 0.001
R14412 AVSS_n2453 AVSS_n1576 0.001
R14413 AVSS_n1866 AVSS_n1575 0.001
R14414 AVSS_n2452 AVSS_n1575 0.001
R14415 AVSS_n1868 AVSS_n1574 0.001
R14416 AVSS_n2451 AVSS_n1574 0.001
R14417 AVSS_n1870 AVSS_n1573 0.001
R14418 AVSS_n2450 AVSS_n1573 0.001
R14419 AVSS_n1872 AVSS_n1572 0.001
R14420 AVSS_n1875 AVSS_n1874 0.001
R14421 AVSS_n2538 AVSS_n1875 0.001
R14422 AVSS_n1877 AVSS_n1876 0.001
R14423 AVSS_n2539 AVSS_n1877 0.001
R14424 AVSS_n1879 AVSS_n1878 0.001
R14425 AVSS_n2540 AVSS_n1879 0.001
R14426 AVSS_n1880 AVSS_n1569 0.001
R14427 AVSS_n2550 AVSS_n2548 0.001
R14428 AVSS_n2550 AVSS_n2547 0.001
R14429 AVSS_n1882 AVSS_n1568 0.001
R14430 AVSS_n2449 AVSS_n1568 0.001
R14431 AVSS_n1884 AVSS_n1567 0.001
R14432 AVSS_n2448 AVSS_n1567 0.001
R14433 AVSS_n1888 AVSS_n1886 0.001
R14434 AVSS_n1892 AVSS_n1891 0.001
R14435 AVSS_n2542 AVSS_n1892 0.001
R14436 AVSS_n1894 AVSS_n1893 0.001
R14437 AVSS_n2543 AVSS_n1894 0.001
R14438 AVSS_n1896 AVSS_n1895 0.001
R14439 AVSS_n2544 AVSS_n1896 0.001
R14440 AVSS_n1899 AVSS_n1897 0.001
R14441 AVSS_n1898 AVSS_n1562 0.001
R14442 AVSS_n2447 AVSS_n1562 0.001
R14443 AVSS_n1900 AVSS_n1561 0.001
R14444 AVSS_n2446 AVSS_n1561 0.001
R14445 AVSS_n1902 AVSS_n1560 0.001
R14446 AVSS_n2445 AVSS_n1560 0.001
R14447 AVSS_n1905 AVSS_n1904 0.001
R14448 AVSS_n2545 AVSS_n1907 0.001
R14449 AVSS_n1907 AVSS_n1906 0.001
R14450 AVSS_n2764 AVSS_n1908 0.001
R14451 AVSS_n1957 AVSS_n1912 0.001
R14452 AVSS_n1959 AVSS_n1957 0.001
R14453 AVSS_n1958 AVSS_n1956 0.001
R14454 AVSS_n2082 AVSS_n1962 0.001
R14455 AVSS_n1962 AVSS_n1961 0.001
R14456 AVSS_n2083 AVSS_n1964 0.001
R14457 AVSS_n1964 AVSS_n1963 0.001
R14458 AVSS_n2084 AVSS_n1966 0.001
R14459 AVSS_n1966 AVSS_n1965 0.001
R14460 AVSS_n2085 AVSS_n1968 0.001
R14461 AVSS_n1968 AVSS_n1967 0.001
R14462 AVSS_n1970 AVSS_n1969 0.001
R14463 AVSS_n2081 AVSS_n1951 0.001
R14464 AVSS_n1971 AVSS_n1951 0.001
R14465 AVSS_n2080 AVSS_n1950 0.001
R14466 AVSS_n1973 AVSS_n1950 0.001
R14467 AVSS_n2079 AVSS_n1949 0.001
R14468 AVSS_n1976 AVSS_n1949 0.001
R14469 AVSS_n1975 AVSS_n1948 0.001
R14470 AVSS_n2086 AVSS_n1979 0.001
R14471 AVSS_n1979 AVSS_n1978 0.001
R14472 AVSS_n2087 AVSS_n1981 0.001
R14473 AVSS_n1981 AVSS_n1980 0.001
R14474 AVSS_n2088 AVSS_n1983 0.001
R14475 AVSS_n1983 AVSS_n1982 0.001
R14476 AVSS_n2089 AVSS_n1985 0.001
R14477 AVSS_n1985 AVSS_n1984 0.001
R14478 AVSS_n2090 AVSS_n1987 0.001
R14479 AVSS_n1987 AVSS_n1986 0.001
R14480 AVSS_n1989 AVSS_n1988 0.001
R14481 AVSS_n2078 AVSS_n1942 0.001
R14482 AVSS_n1990 AVSS_n1942 0.001
R14483 AVSS_n2077 AVSS_n1941 0.001
R14484 AVSS_n1993 AVSS_n1941 0.001
R14485 AVSS_n1994 AVSS_n1992 0.001
R14486 AVSS_n2091 AVSS_n1996 0.001
R14487 AVSS_n1996 AVSS_n1995 0.001
R14488 AVSS_n2092 AVSS_n1998 0.001
R14489 AVSS_n1998 AVSS_n1997 0.001
R14490 AVSS_n2093 AVSS_n2000 0.001
R14491 AVSS_n2000 AVSS_n1999 0.001
R14492 AVSS_n2094 AVSS_n2002 0.001
R14493 AVSS_n2002 AVSS_n2001 0.001
R14494 AVSS_n2095 AVSS_n2004 0.001
R14495 AVSS_n2004 AVSS_n2003 0.001
R14496 AVSS_n2006 AVSS_n2005 0.001
R14497 AVSS_n2076 AVSS_n1934 0.001
R14498 AVSS_n2007 AVSS_n1934 0.001
R14499 AVSS_n2075 AVSS_n1933 0.001
R14500 AVSS_n2009 AVSS_n1933 0.001
R14501 AVSS_n2074 AVSS_n1932 0.001
R14502 AVSS_n2011 AVSS_n1932 0.001
R14503 AVSS_n2012 AVSS_n1931 0.001
R14504 AVSS_n2016 AVSS_n2015 0.001
R14505 AVSS_n2016 AVSS_n2014 0.001
R14506 AVSS_n2017 AVSS_n1930 0.001
R14507 AVSS_n2073 AVSS_n1929 0.001
R14508 AVSS_n2020 AVSS_n1929 0.001
R14509 AVSS_n2019 AVSS_n1928 0.001
R14510 AVSS_n2096 AVSS_n2023 0.001
R14511 AVSS_n2023 AVSS_n2022 0.001
R14512 AVSS_n2129 AVSS_n2127 0.001
R14513 AVSS_n2129 AVSS_n2126 0.001
R14514 AVSS_n2024 AVSS_n1926 0.001
R14515 AVSS_n2072 AVSS_n1925 0.001
R14516 AVSS_n2026 AVSS_n1925 0.001
R14517 AVSS_n2097 AVSS_n2027 0.001
R14518 AVSS_n2029 AVSS_n2028 0.001
R14519 AVSS_n2071 AVSS_n1923 0.001
R14520 AVSS_n2030 AVSS_n1923 0.001
R14521 AVSS_n2070 AVSS_n1922 0.001
R14522 AVSS_n2032 AVSS_n1922 0.001
R14523 AVSS_n2069 AVSS_n1921 0.001
R14524 AVSS_n2034 AVSS_n1921 0.001
R14525 AVSS_n2098 AVSS_n2035 0.001
R14526 AVSS_n2068 AVSS_n1920 0.001
R14527 AVSS_n2040 AVSS_n2039 0.001
R14528 AVSS_n2042 AVSS_n2041 0.001
R14529 AVSS_n2067 AVSS_n1918 0.001
R14530 AVSS_n2044 AVSS_n2043 0.001
R14531 AVSS_n2066 AVSS_n1917 0.001
R14532 AVSS_n2045 AVSS_n1917 0.001
R14533 AVSS_n2065 AVSS_n1916 0.001
R14534 AVSS_n2101 AVSS_n1916 0.001
R14535 AVSS_n1240 AVSS_n1202 0.001
R14536 AVSS_n1240 AVSS_n1192 0.001
R14537 AVSS_n2805 AVSS_n1062 0.001
R14538 AVSS_n2806 AVSS_n2805 0.001
R14539 AVSS_n1228 AVSS_n1225 0.001
R14540 AVSS_n1225 AVSS_n1211 0.001
R14541 AVSS_n2799 AVSS_n1103 0.001
R14542 AVSS_n2799 AVSS_n1107 0.001
R14543 AVSS_n1279 AVSS_n1278 0.001
R14544 AVSS_n1279 AVSS_n1245 0.001
R14545 AVSS_n1343 AVSS_n1325 0.001
R14546 AVSS_n1343 AVSS_n1331 0.001
R14547 AVSS_n1385 AVSS_n1359 0.001
R14548 AVSS_n1385 AVSS_n1367 0.001
R14549 AVSS_n2802 AVSS_n1074 0.001
R14550 AVSS_n2802 AVSS_n1088 0.001
R14551 AVSS_n2237 AVSS_n2220 0.001
R14552 AVSS_n2221 AVSS_n2220 0.001
R14553 AVSS_n1413 AVSS_n1410 0.001
R14554 AVSS_n1410 AVSS_n1392 0.001
R14555 AVSS_n2780 AVSS_n1285 0.001
R14556 AVSS_n2781 AVSS_n2780 0.001
R14557 AVSS_n2426 AVSS_n2421 0.001
R14558 AVSS_n2422 AVSS_n2421 0.001
R14559 AVSS_n2781 AVSS_n1284 0.001
R14560 AVSS_n1285 AVSS_n1284 0.001
R14561 AVSS_n1418 AVSS_n1392 0.001
R14562 AVSS_n1418 AVSS_n1413 0.001
R14563 AVSS_n2240 AVSS_n2221 0.001
R14564 AVSS_n2240 AVSS_n2237 0.001
R14565 AVSS_n1088 AVSS_n1072 0.001
R14566 AVSS_n1074 AVSS_n1072 0.001
R14567 AVSS_n1382 AVSS_n1367 0.001
R14568 AVSS_n1382 AVSS_n1359 0.001
R14569 AVSS_n1341 AVSS_n1331 0.001
R14570 AVSS_n1341 AVSS_n1325 0.001
R14571 AVSS_n2786 AVSS_n1245 0.001
R14572 AVSS_n2786 AVSS_n1278 0.001
R14573 AVSS_n1107 AVSS_n1101 0.001
R14574 AVSS_n1103 AVSS_n1101 0.001
R14575 AVSS_n1231 AVSS_n1211 0.001
R14576 AVSS_n1231 AVSS_n1228 0.001
R14577 AVSS_n2806 AVSS_n1061 0.001
R14578 AVSS_n1062 AVSS_n1061 0.001
R14579 AVSS_n2791 AVSS_n1192 0.001
R14580 AVSS_n2791 AVSS_n1202 0.001
R14581 AVSS_n485 AVSS_n461 0.001
R14582 AVSS_n486 AVSS_n461 0.001
R14583 AVSS_n488 AVSS_n459 0.001
R14584 AVSS_n632 AVSS_n454 0.001
R14585 AVSS_n519 AVSS_n454 0.001
R14586 AVSS_n488 AVSS_n458 0.001
R14587 AVSS_n486 AVSS_n460 0.001
R14588 AVSS_n485 AVSS_n457 0.001
R14589 AVSS_n762 AVSS_n355 0.001
R14590 AVSS_n762 AVSS_n360 0.001
R14591 AVSS_n443 AVSS_n396 0.001
R14592 AVSS_n443 AVSS_n372 0.001
R14593 AVSS_n566 AVSS_n565 0.001
R14594 AVSS_n565 AVSS_n559 0.001
R14595 AVSS_n618 AVSS_n617 0.001
R14596 AVSS_n618 AVSS_n545 0.001
R14597 AVSS_n605 AVSS_n571 0.001
R14598 AVSS_n605 AVSS_n574 0.001
R14599 AVSS_n765 AVSS_n312 0.001
R14600 AVSS_n766 AVSS_n765 0.001
R14601 AVSS_n448 AVSS_n424 0.001
R14602 AVSS_n448 AVSS_n429 0.001
R14603 AVSS_n752 AVSS_n402 0.001
R14604 AVSS_n752 AVSS_n407 0.001
R14605 AVSS_n641 AVSS_n639 0.001
R14606 AVSS_n639 AVSS_n514 0.001
R14607 AVSS_n731 AVSS_n497 0.001
R14608 AVSS_n731 AVSS_n503 0.001
R14609 AVSS_n602 AVSS_n587 0.001
R14610 AVSS_n602 AVSS_n567 0.001
R14611 AVSS_n734 AVSS_n464 0.001
R14612 AVSS_n734 AVSS_n475 0.001
R14613 AVSS_n633 AVSS_n519 0.001
R14614 AVSS_n633 AVSS_n632 0.001
R14615 AVSS_n494 AVSS_n475 0.001
R14616 AVSS_n494 AVSS_n464 0.001
R14617 AVSS_n585 AVSS_n567 0.001
R14618 AVSS_n587 AVSS_n585 0.001
R14619 AVSS_n503 AVSS_n495 0.001
R14620 AVSS_n497 AVSS_n495 0.001
R14621 AVSS_n643 AVSS_n514 0.001
R14622 AVSS_n643 AVSS_n641 0.001
R14623 AVSS_n407 AVSS_n401 0.001
R14624 AVSS_n402 AVSS_n401 0.001
R14625 AVSS_n446 AVSS_n429 0.001
R14626 AVSS_n446 AVSS_n424 0.001
R14627 AVSS_n766 AVSS_n311 0.001
R14628 AVSS_n312 AVSS_n311 0.001
R14629 AVSS_n574 AVSS_n570 0.001
R14630 AVSS_n571 AVSS_n570 0.001
R14631 AVSS_n622 AVSS_n545 0.001
R14632 AVSS_n622 AVSS_n617 0.001
R14633 AVSS_n609 AVSS_n559 0.001
R14634 AVSS_n609 AVSS_n566 0.001
R14635 AVSS_n755 AVSS_n372 0.001
R14636 AVSS_n755 AVSS_n396 0.001
R14637 AVSS_n360 AVSS_n352 0.001
R14638 AVSS_n355 AVSS_n352 0.001
C0 VPWR gain_sel[2] 0.32306f
C1 pn114 pn101 0.44684f
C2 pn97 a_89198_9382_ 0.02407f
C3 pn127 pn110 3.52716f
C4 pn118 pn50 0.29505f
C5 pn207 pn41 0.05122f
C6 pn53 pn54 13.8506f
C7 VPWR pn55 0.22546f
C8 pn200 pn15 0.17144f
C9 AVDD pn92 0.52671f
C10 pn53 pn70 0.16246f
C11 VPWR pn72 0.17881f
C12 pn7 pn147 0.01292f
C13 pn5 pn186 0.19677f
C14 pn131 pn58 0.01999f
C15 pn111 pn120 0.12863f
C16 a_95786_21556_ pn150 0.03044f
C17 a_47077_45655_ pn170 0.02758f
C18 pn13 VPWR 0.09352f
C19 pn96 pn143 0.71856f
C20 pn8 a_57562_18659_ 0.05536f
C21 pn160 pn225 0.57521f
C22 VPWR pn67 0.18168f
C23 pn114 pn109 2.40722f
C24 pn199 pn193 0.02857f
C25 pn212 a_60595_18659_ 0.04583f
C26 AVDD pn55 0.49371f
C27 VPWR pn15 0.28043f
C28 pn200 pn54 0.15424f
C29 VPWR pn71 0.17881f
C30 a_52037_46392_ pn55 0.13296f
C31 pn10 pn11 12.3717f
C32 pn193 pn179 0.08119f
C33 pn132 pn56 0.01102f
C34 pn6 pn186 0.11162f
C35 pn133 pn52 0.03046f
C36 pn131 pn57 0.05431f
C37 pn104 pn120 1.35215f
C38 a_47077_45655_ pn90 0.08729f
C39 pn12 VPWR 0.07008f
C40 pn221 pn225 0.19957f
C41 pn227 pn153 0.44685f
C42 pn107 a_89198_9382_ 0.0326f
C43 pn122 pn50 0.06281f
C44 pn189 pn47 0.01731f
C45 pn197 pn193 0.01122f
C46 VPWR pn54 0.29586f
C47 AVDD pn15 1.08793f
C48 pn200 pn53 2.49423f
C49 VPWR pn70 0.1784f
C50 pn209 pn121 0.24359f
C51 pn51 pn186 0.36544f
C52 pn131 pn56 0.02323f
C53 pn48 pn69 0.18794f
C54 pn130 pn57 0.01097f
C55 pn132 pn52 0.82786f
C56 pn129 pn143 2.00138f
C57 pn11 VPWR 0.13753f
C58 pn227 pn225 0.0288f
C59 pn198 pn50 0.26243f
C60 VPWR pn53 0.1882f
C61 AVDD pn54 0.4617f
C62 pn140 a_60595_18659_ 0.01344f
C63 VPWR pn69 0.20185f
C64 pn32 pn16 0.15432f
C65 pn50 pn186 0.20919f
C66 pn130 pn56 0.0318f
C67 pn51 pn205 0.06016f
C68 pn133 pn66 0.01678f
C69 pn209 pn203 0.04716f
C70 pn178 pn120 0.29706f
C71 pn119 pn125 0.02394f
C72 pn10 VPWR 0.11399f
C73 pn11 AVDD 0.60079f
C74 pn31 pn182 0.01012f
C75 pn87 pn155 0.97386f
C76 pn227 pn160 2.40691f
C77 pn175 a_89198_9382_ 0.01599f
C78 pn212 pn106 0.28864f
C79 pn111 pn176 0.30114f
C80 AVDD pn53 0.52839f
C81 VPWR pn200 0.35663f
C82 pn128 a_60595_18659_ 0.07357f
C83 VPWR pn48 0.12425f
C84 pn51 pn204 0.19562f
C85 pn38 pn69 0.04482f
C86 pn42 pn48 0.0837f
C87 pn133 pn76 0.01851f
C88 pn5 pn203 0.18527f
C89 pn50 pn205 0.19232f
C90 pn130 pn52 0.02331f
C91 pn209 pn179 0.02658f
C92 a_96098_12142_ pn143 0.02756f
C93 pn10 AVDD 1.01001f
C94 pn116 VPWR 0.07873f
C95 pn180 pn179 0.018f
C96 pn11 a_44486_19396_ 0.13296f
C97 pn227 pn221 2.92399f
C98 pn161 pn224 0.03986f
C99 pn104 pn176 1.4573f
C100 pn212 pn101 0.01973f
C101 pn100 a_89198_9382_ 0.03938f
C102 pn197 pn209 0.01512f
C103 AVDD pn200 0.84853f
C104 pn215 a_60595_18659_ 0.024f
C105 VPWR pn42 0.57536f
C106 pn9 pn11 0.21236f
C107 pn63 pn71 0.18685f
C108 pn50 pn204 0.15068f
C109 pn51 pn121 0.06495f
C110 pn133 pn182 0.16202f
C111 pn64 pn70 0.1814f
C112 pn6 pn203 0.0632f
C113 pn5 pn179 0.44072f
C114 pn38 pn48 0.15066f
C115 pn209 pn35 0.23535f
C116 a_89198_25050_ pn148 0.02407f
C117 pn16 pn133 0.25509f
C118 pn161 pn226 1.99073f
C119 pn104 pn111 0.57012f
C120 pn2 pn176 0.20503f
C121 pn212 pn109 0.18495f
C122 pn9 pn10 13.0612f
C123 pn8 pn11 0.22122f
C124 VPWR pn38 1.05589f
C125 pn200 pn65 0.03251f
C126 pn53 pn64 0.02152f
C127 pn38 pn42 0.12879f
C128 pn65 pn48 0.02843f
C129 pn64 pn69 0.0198f
C130 pn50 pn121 1.11635f
C131 pn5 pn35 0.07116f
C132 pn6 pn179 0.23208f
C133 pn132 pn182 0.0268f
C134 pn63 pn70 0.02437f
C135 a_89198_25050_ pn152 0.0326f
C136 pn161 pn120 0.02443f
C137 pn55 IBIAS_IA 0.05359f
C138 pn83 pn82 11.6269f
C139 pn2 pn111 0.27056f
C140 pn53 pn63 0.18957f
C141 VPWR pn65 0.29518f
C142 pn7 pn11 0.60877f
C143 pn51 pn179 0.25438f
C144 pn50 pn203 0.02123f
C145 pn62 pn72 0.18279f
C146 pn5 pn187 0.14613f
C147 pn65 pn42 0.40551f
C148 pn8 pn10 0.17446f
C149 pn32 pn13 0.01185f
C150 pn64 pn48 0.01726f
C151 pn208 pn125 0.01713f
C152 pn9 VPWR 0.15204f
C153 pn32 pn15 0.06854f
C154 pn83 pn220 0.06237f
C155 pn161 pn153 0.01973f
C156 pn87 pn159 0.22442f
C157 pn15 IBIAS_IA 0.0499f
C158 pn178 pn111 0.1344f
C159 pn2 pn104 0.20728f
C160 pn199 pn50 0.02066f
C161 pn139 a_51830_18659_ 0.01262f
C162 VPWR pn64 0.2897f
C163 pn7 pn10 0.19995f
C164 pn30 pn14 0.15437f
C165 pn31 pn13 0.01326f
C166 pn51 pn35 0.11442f
C167 pn50 pn179 0.46558f
C168 pn6 pn187 0.07684f
C169 pn62 pn71 0.02497f
C170 pn131 pn75 0.19392f
C171 pn65 pn38 0.01093f
C172 a_89198_14152_ AVDD 0.0251f
C173 pn9 AVDD 0.38892f
C174 pn31 pn15 0.1565f
C175 pn8 VPWR 0.11383f
C176 pn161 pn225 0.28864f
C177 pn14 pn133 0.02464f
C178 pn87 pn223 1.44764f
C179 pn83 pn84 8.44431f
C180 pn54 IBIAS_IA 0.0499f
C181 pn178 pn104 0.11688f
C182 pn114 pn111 0.03386f
C183 VPWR pn63 0.31425f
C184 pn54 pn62 0.02542f
C185 pn51 pn187 0.12677f
C186 pn132 pn73 0.19692f
C187 pn50 pn35 0.43804f
C188 pn64 pn38 0.05611f
C189 pn30 pn13 0.07369f
C190 pn6 pn123 0.03193f
C191 pn131 pn74 0.02743f
C192 pn193 pn52 0.05345f
C193 pn11 IBIAS_IA 0.6215f
C194 pn212 pn120 0.01322f
C195 a_89198_25050_ pn219 0.01599f
C196 pn208 pn119 0.20358f
C197 pn110 a_62475_13119_ 0.04987f
C198 pn7 VPWR 0.13748f
C199 pn8 AVDD 0.49164f
C200 pn161 pn160 0.1856f
C201 pn87 VCM 0.123f
C202 pn53 IBIAS_IA 0.05219f
C203 pn178 pn2 0.82491f
C204 pn114 pn104 0.04281f
C205 pn15 pn133 0.1369f
C206 pn55 pn132 0.02848f
C207 pn29 pn13 0.15754f
C208 pn53 pn62 0.34087f
C209 VPWR pn136 0.08114f
C210 pn63 pn38 0.06049f
C211 pn64 pn65 0.0197f
C212 pn132 pn72 0.0226f
C213 pn130 pn74 0.19672f
C214 pn10 IBIAS_IA 0.0294f
C215 a_89198_25050_ pn150 0.03938f
C216 pn208 pn46 0.01126f
C217 pn118 pn201 0.01708f
C218 pn7 AVDD 1.11363f
C219 pn200 IBIAS_IA 0.05588f
C220 pn161 pn221 1.7346f
C221 pn212 pn110 0.02443f
C222 pn102 a_51011_7855_ 0.06289f
C223 pn212 a_51830_18659_ 0.17196f
C224 pn55 pn131 0.0229f
C225 a_52037_46952_ pn55 0.22971f
C226 pn29 pn12 0.06357f
C227 pn130 pn73 0.02295f
C228 pn8 pn9 11.8542f
C229 pn62 pn48 0.09948f
C230 pn118 pn119 0.02515f
C231 pn208 pn202 0.0993f
C232 pn32 VPWR 0.17777f
C233 pn7 a_44486_19396_ 0.04347f
C234 pn161 pn227 0.42047f
C235 pn87 pn154 0.02504f
C236 pn114 pn178 2.92399f
C237 pn7 pn9 0.20102f
C238 pn28 pn12 0.15509f
C239 pn15 pn131 0.02168f
C240 VPWR pn62 0.27842f
C241 pn53 pn133 0.37621f
C242 pn62 pn42 0.01251f
C243 pn63 pn64 0.88376f
C244 pn128 pn120 0.02038f
C245 pn33 pn202 0.07682f
C246 a_82482_46078_ pn173 0.0326f
C247 pn31 VPWR 0.20302f
C248 pn161 pn165 0.01621f
C249 AVDD IBIAS_IA 0.27118f
C250 pn87 pn86 0.89516f
C251 pn53 pn132 0.022f
C252 pn54 pn131 0.34104f
C253 VPWR pn211 0.40812f
C254 pn15 pn130 0.01202f
C255 pn200 pn133 0.21498f
C256 pn28 pn11 0.06355f
C257 pn62 pn38 0.05972f
C258 pn7 pn8 4.80805f
C259 pn133 pn48 0.39398f
C260 a_82482_46078_ pn229 0.02407f
C261 pn30 VPWR 0.17942f
C262 pn87 pn158 0.12863f
C263 pn161 pn164 0.07109f
C264 AVDD pn149 0.51457f
C265 pn188 pn194 0.07336f
C266 pn128 a_51830_18659_ 0.1755f
C267 VPWR pn133 0.5488f
C268 pn27 pn11 0.15509f
C269 pn53 pn131 0.37382f
C270 pn200 pn132 0.12877f
C271 pn132 pn48 0.21236f
C272 pn133 pn42 0.17129f
C273 pn131 pn69 0.01653f
C274 pn9 IBIAS_IA 0.01919f
C275 pn198 pn119 0.19428f
C276 pn29 VPWR 0.17829f
C277 pn11 a_44486_19956_ 0.22971f
C278 pn119 pn186 0.24431f
C279 AVDD pn148 0.48122f
C280 pn4 pn211 0.02423f
C281 pn161 pn163 0.06486f
C282 pn10 pn131 0.01097f
C283 pn87 pn224 1.35215f
C284 pn212 pn104 0.04037f
C285 pn53 pn130 0.02246f
C286 VPWR pn132 0.43679f
C287 pn131 pn48 0.07318f
C288 pn27 pn10 0.06353f
C289 pn132 pn42 0.64379f
C290 pn133 pn38 0.23267f
C291 pn62 pn64 0.89781f
C292 pn28 VPWR 0.17829f
C293 pn83 VCM 0.33019f
C294 AVDD pn152 6.57517f
C295 pn161 pn167 0.04558f
C296 pn212 pn2 1.99073f
C297 pn214 a_51830_18659_ 0.02602f
C298 VPWR pn131 0.81627f
C299 pn26 pn10 0.15509f
C300 pn200 pn130 0.45416f
C301 pn62 pn63 0.15098f
C302 pn50 pn52 0.03109f
C303 pn130 pn48 0.04694f
C304 pn133 pn65 0.09623f
C305 pn131 pn42 0.1904f
C306 pn132 pn38 0.02109f
C307 pn198 pn202 0.02842f
C308 pn27 VPWR 0.17883f
C309 pn118 pn188 0.01347f
C310 pn161 pn166 0.05f
C311 pn19 pn131 0.01856f
C312 AVDD pn151 10.0553f
C313 pn212 pn178 1.73461f
C314 pn213 a_51830_18659_ 0.08325f
C315 VPWR pn130 0.45143f
C316 pn132 pn65 0.13703f
C317 pn130 pn42 0.10593f
C318 pn181 pn48 0.19355f
C319 pn62 pn136 0.01182f
C320 pn131 pn38 0.9208f
C321 pn133 pn64 0.01345f
C322 pn98 AVDD 0.47516f
C323 pn11 pn82 0.05491f
C324 gain_sel[0] pn5 0.03029f
C325 pn26 VPWR 0.20229f
C326 pn119 pn121 0.38058f
C327 AVDD VINN 10.5946f
C328 pn171 pn167 0.01044f
C329 pn87 pn153 0.02167f
C330 gain_sel[0] pn22 0.19688f
C331 pn186 pn194 0.14596f
C332 a_44396_15660_ pn120 0.02152f
C333 pn212 pn114 0.42054f
C334 VPWR pn181 0.87502f
C335 pn181 pn42 0.20904f
C336 pn132 pn64 0.08852f
C337 pn41 pn48 0.157f
C338 pn131 pn65 0.0171f
C339 pn130 pn38 0.29524f
C340 gain_sel[0] pn6 0.01102f
C341 pn97 AVDD 0.48122f
C342 pn21 pn5 0.15674f
C343 pn144 pn120 0.01339f
C344 pn122 pn33 0.03046f
C345 pn25 VPWR 0.18055f
C346 pn87 pn225 0.07765f
C347 pn12 pn193 0.03261f
C348 pn9 pn131 0.04025f
C349 pn169 pn161 0.07725f
C350 pn116 pn41 0.0245f
C351 AVDD pn219 2.39907f
C352 pn212 pn138 0.05f
C353 pn205 pn194 0.06238f
C354 VPWR pn41 0.7016f
C355 pn54 pn193 0.01506f
C356 pn131 pn64 0.06705f
C357 pn181 pn38 0.29496f
C358 pn130 pn65 0.02321f
C359 pn41 pn42 1.08754f
C360 pn60 pn48 0.01316f
C361 pn211 pn61 0.01834f
C362 pn11 pn84 0.02384f
C363 pn122 pn118 0.16232f
C364 pn24 VPWR 0.18f
C365 pn170 pn166 0.01136f
C366 pn171 pn161 0.32634f
C367 AVDD pn150 0.9236f
C368 pn212 pn139 0.04561f
C369 pn35 pn191 0.02857f
C370 pn204 pn194 0.21063f
C371 pn186 pn188 0.85375f
C372 pn184 pn10 0.03698f
C373 VPWR pn60 0.3764f
C374 pn211 pn62 0.02535f
C375 pn60 pn42 0.02559f
C376 pn131 pn63 1.36005f
C377 pn50 pn182 0.49608f
C378 pn181 pn65 0.09774f
C379 pn41 pn38 0.05827f
C380 pn107 AVDD 6.57471f
C381 pn197 pn119 0.01813f
C382 pn198 pn118 0.04251f
C383 a_82482_46078_ VOUT 0.03938f
C384 pn23 VPWR 0.19919f
C385 pn118 pn186 0.02355f
C386 pn119 pn35 0.22023f
C387 pn32 pn133 0.20292f
C388 AVDD pn82 9.71296f
C389 pn87 pn221 0.29706f
C390 pn170 pn161 0.35357f
C391 pn212 pn79 0.06486f
C392 pn204 pn40 0.01126f
C393 pn35 pn190 0.02331f
C394 pn121 pn194 0.03328f
C395 VPWR pn135 0.10238f
C396 pn200 pn193 0.06033f
C397 pn25 pn9 0.15509f
C398 pn193 pn48 0.60185f
C399 pn60 pn38 0.05005f
C400 pn41 pn65 0.40644f
C401 pn130 pn63 0.03074f
C402 pn133 pn62 1.06192f
C403 pn105 AVDD 9.98974f
C404 pn148 pn149 0.73237f
C405 pn212 a_62475_13119_ 0.04968f
C406 a_82482_46078_ pn228 0.01599f
C407 a_52037_46672_ pn90 0.07866f
C408 pn7 a_44486_19956_ 0.10961f
C409 pn184 VPWR 0.29294f
C410 pn31 pn133 0.01905f
C411 pn117 pn50 0.02442f
C412 pn90 pn161 1.16105f
C413 AVDD pn220 3.05973f
C414 pn88 pn165 0.0127f
C415 pn204 pn188 0.01069f
C416 pn212 pn78 0.07109f
C417 a_62827_42656_ pn90 0.01807f
C418 VPWR pn193 0.61886f
C419 pn25 pn8 0.06351f
C420 pn130 pn136 0.01732f
C421 pn193 pn42 0.02809f
C422 pn132 pn62 0.03642f
C423 pn175 AVDD 2.38664f
C424 pn183 VPWR 0.01784f
C425 pn202 pn35 0.01818f
C426 pn11 pn209 0.01318f
C427 pn88 pn164 0.02484f
C428 AVDD pn84 31.0576f
C429 pn90 pn169 0.02022f
C430 pn172 pn163 0.01065f
C431 pn215 pn138 0.01136f
C432 pn121 pn188 0.0638f
C433 pn186 pn36 0.01437f
C434 pn24 pn8 0.15509f
C435 pn184 pn4 0.06831f
C436 pn131 pn62 0.03418f
C437 pn181 pn136 0.02421f
C438 pn193 pn38 0.61541f
C439 pn100 AVDD 0.90237f
C440 pn152 pn148 0.03272f
C441 pn151 pn149 1.99542f
C442 pn18 VPWR 0.28729f
C443 pn198 pn186 0.01306f
C444 pn17 pn181 0.01559f
C445 pn118 pn121 0.10348f
C446 pn14 pn50 0.52098f
C447 pn55 VCM 0.05438f
C448 pn89 pn165 0.0183f
C449 pn90 pn171 0.03213f
C450 gain_sel[2] pn50 0.04459f
C451 pn101 a_51011_7855_ 0.01072f
C452 pn77 pn212 0.01621f
C453 pn128 a_44486_19676_ 0.07866f
C454 VPWR pn134 0.14501f
C455 pn184 pn9 0.01134f
C456 pn24 pn7 0.0635f
C457 pn130 pn62 0.12438f
C458 pn132 pn133 0.07019f
C459 pn193 pn65 0.11225f
C460 pn108 AVDD 1.80944f
C461 VINN pn149 0.35076f
C462 a_47077_45655_ pn53 0.05536f
C463 pn115 VPWR 0.08556f
C464 pn208 pn35 0.17849f
C465 pn7 pn60 0.05716f
C466 pn90 pn170 0.04412f
C467 pn15 VCM 0.05058f
C468 pn13 pn50 0.01033f
C469 gain_sel[2] pn68 0.19581f
C470 pn67 pn50 0.15557f
C471 pn214 pn139 0.01044f
C472 pn140 pn212 0.07726f
C473 pn179 pn188 0.04106f
C474 VPWR pn209 1.20555f
C475 pn184 pn8 0.01011f
C476 pn18 pn4 0.03452f
C477 pn15 pn50 0.05678f
C478 pn23 pn7 0.1544f
C479 pn131 pn133 0.02833f
C480 pn181 pn62 0.01947f
C481 pn209 pn42 0.37465f
C482 pn99 AVDD 0.81214f
C483 a_51438_33170_ pn85 0.0275f
C484 VINN pn148 1.8247f
C485 pn219 pn149 0.21172f
C486 a_52037_46672_ pn172 0.03272f
C487 pn33 pn35 0.216f
C488 pn172 pn161 0.32072f
C489 pn54 VCM 0.05058f
C490 pn128 pn212 1.16105f
C491 a_50103_45655_ pn167 0.01262f
C492 VPWR pn5 1.3048f
C493 pn184 pn7 0.01006f
C494 pn130 pn133 0.51311f
C495 pn131 pn132 0.13338f
C496 pn209 pn38 0.01579f
C497 pn181 pn211 0.18341f
C498 pn11 VCM 0.08901f
C499 VINP AVDD 10.4543f
C500 pn219 pn148 0.23321f
C501 pn82 IBIAS_IA 10.5209f
C502 pn150 pn149 0.01413f
C503 VINN pn152 0.04787f
C504 a_52037_46672_ pn88 0.05954f
C505 pn22 VPWR 0.18934f
C506 pn198 pn121 0.04003f
C507 pn118 pn35 0.75607f
C508 pn4 pn209 0.08761f
C509 pn53 VCM 0.05293f
C510 AVDD pn156 4.1116f
C511 pn88 pn161 0.28573f
C512 pn213 pn79 0.01065f
C513 pn215 pn212 0.35357f
C514 pn121 pn186 0.02058f
C515 pn213 a_44486_19676_ 0.03272f
C516 pn18 pn8 0.02737f
C517 VPWR pn6 0.96995f
C518 pn130 pn132 0.56399f
C519 pn5 pn38 0.18783f
C520 pn209 pn65 0.02069f
C521 pn60 pn62 0.04678f
C522 pn41 pn211 0.43426f
C523 pn113 AVDD 1.04622f
C524 a_51438_33170_ pn156 0.01527f
C525 VINN pn151 0.53951f
C526 pn219 pn152 0.04323f
C527 pn82 pn149 0.01701f
C528 pn150 pn148 3.52716f
C529 a_47077_45655_ AVDD 0.02943f
C530 pn9 pn209 0.02794f
C531 pn119 pn52 0.13675f
C532 pn45 pn121 0.01559f
C533 pn87 pn161 0.01327f
C534 pn200 VCM 0.05673f
C535 AVDD pn159 6.00111f
C536 pn128 pn140 0.02022f
C537 pn214 pn212 0.32634f
C538 a_50103_45655_ pn161 0.17196f
C539 a_62827_42656_ pn87 0.01853f
C540 pn141 a_44486_19676_ 0.05954f
C541 VPWR pn51 0.76568f
C542 pn200 pn50 0.06385f
C543 pn60 pn211 0.06015f
C544 pn6 pn38 0.22964f
C545 pn130 pn131 0.12373f
C546 pn51 pn42 0.0123f
C547 pn181 pn132 0.01727f
C548 pn1 AVDD 0.83763f
C549 pn199 pn198 0.06213f
C550 pn219 pn151 1.25816f
C551 pn150 pn152 1.00666f
C552 pn84 IBIAS_IA 1.98583f
C553 pn97 pn98 0.73237f
C554 a_60595_18659_ AVDD 0.01852f
C555 pn122 pn35 0.20014f
C556 pn229 pn173 0.03272f
C557 pn89 pn161 0.18577f
C558 AVDD pn223 0.83763f
C559 pn26 pn131 0.03244f
C560 gain_sel[1] gain_sel[0] 1.44029f
C561 pn213 pn212 0.32072f
C562 pn141 pn78 0.02484f
C563 pn121 pn204 0.01572f
C564 pn179 pn186 0.14028f
C565 pn142 a_44486_19676_ 0.02317f
C566 VPWR pn50 1.7244f
C567 pn51 pn38 0.06835f
C568 pn193 pn62 0.07617f
C569 pn41 pn132 0.05173f
C570 pn50 pn42 0.20507f
C571 pn3 AVDD 6.00095f
C572 pn150 pn151 0.02733f
C573 pn197 pn198 0.15437f
C574 pn219 VINN 1.2457f
C575 a_52037_46672_ pn174 0.02317f
C576 pn184 pn211 0.13755f
C577 pn198 pn35 0.02303f
C578 pn197 pn186 0.18963f
C579 gain_sel[1] pn21 0.19912f
C580 AVDD VCM 20.3337f
C581 pn172 pn90 0.46679f
C582 pn215 pn128 0.04412f
C583 pn141 pn212 0.28573f
C584 pn35 pn186 0.2606f
C585 a_50103_45655_ pn171 0.02602f
C586 pn125 pn16 0.01479f
C587 VPWR pn68 0.18561f
C588 pn50 pn38 0.06709f
C589 pn41 pn131 0.3466f
C590 pn193 pn211 0.02033f
C591 pn112 AVDD 6.57471f
C592 pn150 VINN 0.02823f
C593 pn82 pn151 0.75179f
C594 pn88 pn90 0.76119f
C595 pn162 pn229 0.73237f
C596 AVDD pn222 1.80953f
C597 pn141 pn77 0.0127f
C598 pn214 pn128 0.03213f
C599 pn103 pn220 0.01519f
C600 pn8 a_60595_18659_ 0.01977f
C601 pn193 pn133 0.22004f
C602 pn41 pn130 0.07396f
C603 pn106 AVDD 5.10986f
C604 pn82 VINN 0.1344f
C605 pn150 pn219 0.32339f
C606 pn105 pn98 1.9952f
C607 pn107 pn97 0.03272f
C608 pn119 pn182 0.02847f
C609 pn29 pn193 0.1941f
C610 pn18 pn211 0.01454f
C611 AVDD pn154 0.81214f
C612 pn213 pn128 0.46679f
C613 pn112 a_89198_14152_ 0.0326f
C614 pn144 pn212 0.18577f
C615 a_50103_45655_ pn90 0.1755f
C616 pn60 pn130 0.12192f
C617 pn193 pn132 0.03395f
C618 pn41 pn181 0.54524f
C619 gain_sel[1] gain_sel[2] 1.04898f
C620 a_51438_33170_ pn154 0.13861f
C621 pn101 AVDD 2.04699f
C622 pn156 IBIAS_IA 0.04144f
C623 pn82 pn219 0.31071f
C624 pn175 pn98 0.21172f
C625 pn197 pn121 0.02262f
C626 pn28 pn193 0.01791f
C627 pn184 pn131 0.0679f
C628 AVDD pn86 1.18142f
C629 pn89 pn90 2.27021f
C630 pn87 pn173 0.04787f
C631 pn141 pn128 0.76119f
C632 pn144 pn77 0.0183f
C633 pn184 pn27 0.19563f
C634 pn60 pn181 0.13605f
C635 pn209 pn211 0.16314f
C636 pn193 pn131 0.015f
C637 pn11 pn120 0.0767f
C638 pn109 AVDD 19.1712f
C639 a_51438_33170_ pn86 0.0609f
C640 pn82 pn150 0.38963f
C641 pn207 pn43 0.01126f
C642 pn99 pn95 0.01817f
C643 pn100 pn98 0.01413f
C644 pn175 pn97 0.23321f
C645 AVDD pn158 5.28473f
C646 pn87 pn229 1.8247f
C647 pn104 a_51011_7855_ 0.0438f
C648 pn184 pn26 0.03223f
C649 pn60 pn41 0.04284f
C650 pn193 pn130 1.46641f
C651 pn177 AVDD 2.39983f
C652 pn10 pn120 0.07075f
C653 pn128 a_44396_15660_ 0.01807f
C654 pn99 pn103 0.01521f
C655 pn100 pn97 3.52716f
C656 pn24 pn60 0.18511f
C657 pn168 pn161 0.38761f
C658 pn87 pn162 0.35036f
C659 AVDD pn224 6.27803f
C660 pn144 pn128 2.27021f
C661 pn105 pn82 0.23089f
C662 pn202 pn117 0.03235f
C663 pn119 pn14 0.64907f
C664 pn193 pn181 0.07429f
C665 pn100 a_72766_6326_ 0.03753f
C666 pn96 AVDD 10.9177f
C667 VCM IBIAS_IA 3.38329f
C668 pn220 pn82 0.2298f
C669 pn175 pn107 0.04323f
C670 pn122 pn52 0.01079f
C671 pn23 pn60 0.02814f
C672 AVDD pn226 0.70879f
C673 VOUT pn173 0.76358f
C674 pn168 pn169 0.0797f
C675 pn15 pn221 0.01021f
C676 pn177 a_89198_14152_ 0.01599f
C677 gain_sel[3] gain_sel[2] 0.87014f
C678 a_50103_45655_ pn172 0.08325f
C679 pn175 pn82 0.29344f
C680 pn10 a_51830_18659_ 0.0202f
C681 pn209 pn131 0.1699f
C682 pn193 pn41 0.04002f
C683 pn51 pn211 0.09772f
C684 a_51438_33170_ pn226 0.036f
C685 pn126 AVDD 1.0407f
C686 pn84 pn82 0.75068f
C687 pn175 pn105 1.25816f
C688 VINP pn98 0.35076f
C689 pn100 pn107 1.00663f
C690 pn119 pn15 0.2233f
C691 pn33 pn182 0.0136f
C692 pn31 pn50 0.01118f
C693 pn55 pn165 0.07887f
C694 AVDD pn120 3.11794f
C695 pn15 pn227 0.14562f
C696 pn228 pn173 0.04323f
C697 VOUT pn229 3.5274f
C698 gain_sel[3] pn67 0.19269f
C699 VPWR pn124 0.07622f
C700 pn80 pn212 0.38781f
C701 pn142 pn213 0.02561f
C702 pn187 pn35 0.25043f
C703 pn100 pn82 0.03536f
C704 pn202 pn14 0.01778f
C705 pn184 pn23 0.04411f
C706 pn119 pn12 0.01283f
C707 pn18 pn25 0.18785f
C708 pn193 pn60 0.63156f
C709 pn209 pn130 0.01692f
C710 pn95 a_55785_6174_ 0.0275f
C711 pn50 pn211 0.02671f
C712 pn129 AVDD 0.5152f
C713 pn138 a_57562_18659_ 0.01195f
C714 pn84 pn220 4.97468f
C715 VINP pn97 1.8247f
C716 a_82482_46078_ AVDD 0.0251f
C717 gain_sel[1] VPWR 0.27006f
C718 pn100 pn105 0.02733f
C719 VOUT pn162 2.00704f
C720 AVDD pn153 2.04699f
C721 pn228 pn229 0.23321f
C722 pn89 pn88 0.45979f
C723 pn55 pn164 0.06011f
C724 pn174 pn172 0.02561f
C725 a_45396_45655_ pn161 0.04583f
C726 pn119 pn11 0.02086f
C727 pn18 pn24 0.02606f
C728 pn193 pn135 0.02537f
C729 pn209 pn181 0.06059f
C730 pn9 pn120 0.07075f
C731 pn110 AVDD 0.91005f
C732 a_51830_18659_ AVDD 0.01197f
C733 pn100 pn175 0.32339f
C734 pn202 pn15 0.03252f
C735 pn125 VPWR 0.12787f
C736 pn18 pn60 0.01439f
C737 pn25 pn209 0.02758f
C738 AVDD pn225 5.10986f
C739 pn53 pn227 0.02074f
C740 pn228 pn162 0.21172f
C741 pn15 pn164 0.07915f
C742 pn168 pn90 0.04589f
C743 pn80 pn140 0.07922f
C744 pn144 pn141 0.45979f
C745 a_96098_12142_ AVDD 0.1198f
C746 a_45396_45655_ pn169 0.01344f
C747 pn112 pn152 0.04693f
C748 pn183 pn184 0.01087f
C749 pn5 pn181 0.23147f
C750 pn209 pn41 0.21541f
C751 pn8 pn120 0.07512f
C752 pn127 AVDD 0.48122f
C753 a_44486_19396_ a_51830_18659_ 0.1345f
C754 VINP pn107 0.04787f
C755 pn119 pn200 0.02031f
C756 pn122 pn182 0.02f
C757 pn200 pn227 0.05441f
C758 AVDD pn160 19.1691f
C759 pn15 pn163 0.14144f
C760 pn80 pn128 0.04589f
C761 pn110 a_89198_14152_ 0.03938f
C762 pn38 pn192 0.01306f
C763 pn52 pn121 0.01313f
C764 pn99 pn220 0.3157f
C765 VINP pn82 0.05023f
C766 pn9 a_51830_18659_ 0.04148f
C767 pn18 pn184 0.5516f
C768 pn6 pn181 0.16229f
C769 pn50 pn131 0.02228f
C770 pn209 pn60 0.38588f
C771 pn7 pn120 0.08218f
C772 pn176 AVDD 1.18142f
C773 VCM VINN 0.13371f
C774 pn106 pn103 0.1093f
C775 pn101 pn95 0.67514f
C776 VINP pn105 0.54019f
C777 pn119 VPWR 0.38042f
C778 pn208 pn15 0.03984f
C779 pn198 pn182 0.02451f
C780 pn23 pn209 0.02387f
C781 pn83 pn162 0.02781f
C782 VOUT pn87 0.65721f
C783 pn54 pn163 0.08378f
C784 a_72766_21992_ pn150 0.0375f
C785 pn15 pn167 0.0142f
C786 AVDD pn221 11.0694f
C787 pn127 a_89198_14152_ 0.02407f
C788 VPWR pn190 0.01364f
C789 a_45396_45655_ pn170 0.024f
C790 pn48 pn189 0.22459f
C791 VPWR gain_sel[3] 0.24522f
C792 pn198 pn16 0.0329f
C793 pn118 pn14 0.20639f
C794 pn51 pn181 0.10982f
C795 pn50 pn130 0.01147f
C796 pn111 AVDD 5.28473f
C797 pn156 pn220 3.90221f
C798 pn212 a_57562_18659_ 0.08845f
C799 a_52037_46672_ pn55 0.14571f
C800 VINP pn175 1.2457f
C801 pn55 pn161 0.53533f
C802 AVDD pn227 46.8698f
C803 pn54 pn167 0.04661f
C804 pn184 pn209 0.22898f
C805 pn228 pn87 1.2457f
C806 pn112 a_72766_16118_ 0.03212f
C807 VPWR pn189 0.3153f
C808 pn146 pn128 0.01211f
C809 pn10 pn178 0.01021f
C810 a_45396_45655_ pn90 0.07357f
C811 pn42 pn189 0.10923f
C812 pn118 pn13 0.10462f
C813 pn50 pn181 1.33156f
C814 pn209 pn193 0.04683f
C815 pn51 pn41 0.34007f
C816 pn104 AVDD 6.27803f
C817 pn120 IBIAS_IA 0.11613f
C818 pn156 pn84 3.65533f
C819 VINP pn100 0.02823f
C820 pn202 VPWR 0.3186f
C821 pn119 pn65 0.21198f
C822 pn197 pn52 0.01012f
C823 pn15 pn161 0.26269f
C824 AVDD pn165 0.46548f
C825 pn53 pn167 0.08461f
C826 VPWR pn206 0.16761f
C827 pn58 pn59 0.27543f
C828 pn10 pn114 0.14562f
C829 pn52 pn35 0.48473f
C830 pn42 pn206 0.16056f
C831 AVDD pn143 10.088f
C832 pn118 pn12 0.45215f
C833 pn5 pn193 0.12329f
C834 pn50 pn41 0.04133f
C835 pn209 pn210 0.01357f
C836 pn2 AVDD 0.70879f
C837 VCM pn82 2.64292f
C838 pn112 pn107 0.10766f
C839 a_55785_6174_ pn220 0.01757f
C840 pn54 pn161 1.00914f
C841 pn53 pn166 0.0161f
C842 pn83 pn87 0.15653f
C843 pn91 pn90 0.01211f
C844 AVDD pn164 0.46357f
C845 pn18 pn209 0.21354f
C846 VPWR pn194 0.52146f
C847 pn57 pn59 0.14877f
C848 pn118 pn11 0.02809f
C849 pn198 pn14 0.19599f
C850 pn50 pn60 0.19495f
C851 pn209 pn134 0.02126f
C852 pn178 AVDD 11.0694f
C853 VCM pn220 1.58397f
C854 pn128 a_57562_18659_ 0.08729f
C855 pn101 pn102 0.10851f
C856 pn208 VPWR 0.18905f
C857 AVDD pn163 0.46516f
C858 pn228 VOUT 1.58528f
C859 pn200 pn166 0.07862f
C860 pn53 pn161 0.48256f
C861 pn57 pn58 0.17236f
C862 pn56 pn59 0.03039f
C863 pn10 pn139 0.0142f
C864 pn11 a_44486_19676_ 0.14571f
C865 pn198 pn13 0.30808f
C866 pn118 pn10 0.02589f
C867 pn51 pn193 0.11334f
C868 pn114 AVDD 46.8666f
C869 pn4 pn194 0.05032f
C870 pn116 pn188 0.03221f
C871 pn215 a_57562_18659_ 0.02758f
C872 pn156 pn157 0.01526f
C873 VCM pn84 0.34388f
C874 pn118 pn200 0.04455f
C875 pn33 VPWR 0.28662f
C876 pn198 pn15 0.03076f
C877 pn200 pn161 0.29222f
C878 pn55 pn90 1.76737f
C879 pn54 pn171 0.01759f
C880 AVDD pn167 0.41824f
C881 pn10 pn79 0.14144f
C882 pn11 pn78 0.06011f
C883 VPWR pn188 0.5326f
C884 pn56 pn58 0.20303f
C885 pn198 pn12 0.02845f
C886 pn6 pn134 0.02264f
C887 pn50 pn193 0.17193f
C888 pn5 pn209 0.15693f
C889 pn138 AVDD 0.51423f
C890 pn214 a_57562_18659_ 0.02425f
C891 pn113 VINP 0.05024f
C892 pn1 pn99 1.07882f
C893 pn118 VPWR 0.25319f
C894 pn115 pn6 0.02233f
C895 pn185 pn48 0.10134f
C896 pn83 VOUT 0.30777f
C897 AVDD pn166 0.51423f
C898 pn53 pn171 0.029f
C899 pn15 pn90 0.096f
C900 pn200 pn169 0.10066f
C901 pn38 pn188 0.02817f
C902 pn11 pn212 0.53533f
C903 pn182 pn35 0.40463f
C904 pn10 pn78 0.0794f
C905 pn56 pn57 0.17394f
C906 pn101 pn220 0.18368f
C907 pn126 VINN 0.05024f
C908 pn108 VCM 0.01565f
C909 pn99 a_55785_6174_ 0.12859f
C910 pn6 pn209 0.85196f
C911 pn96 a_72766_6326_ 0.03044f
C912 a_44748_40115_ pn120 0.04968f
C913 pn139 AVDD 0.41824f
C914 pn11 pn186 0.0117f
C915 pn185 VPWR 0.20248f
C916 pn125 pn133 0.01107f
C917 a_52037_46672_ a_52037_46392_ 1.17654f
C918 AVDD pn161 9.78449f
C919 pn22 pn5 0.06954f
C920 pn54 pn90 0.20396f
C921 pn83 pn228 0.2972f
C922 pn53 pn170 0.01763f
C923 pn8 pn114 0.02074f
C924 pn11 pn77 0.07913f
C925 pn10 pn212 0.26269f
C926 pn109 pn220 0.3852f
C927 pn177 pn82 0.31197f
C928 pn99 VCM 0.04431f
C929 pn6 pn5 2.48202f
C930 pn51 pn209 0.11984f
C931 pn79 AVDD 0.46516f
C932 pn13 pn121 0.04497f
C933 pn96 pn107 0.03438f
C934 pn122 VPWR 0.17666f
C935 pn22 pn6 0.15674f
C936 pn115 pn50 0.02308f
C937 pn200 pn170 0.01635f
C938 pn53 pn90 0.71669f
C939 AVDD pn169 0.45264f
C940 pn76 pn59 0.15674f
C941 pn145 pn218 0.02469f
C942 pn8 pn138 0.0161f
C943 pn7 pn114 0.05441f
C944 pn9 pn139 0.04661f
C945 pn102 pn120 0.97386f
C946 pn96 pn82 0.83757f
C947 pn118 pn9 0.02615f
C948 pn51 pn5 0.19132f
C949 pn50 pn209 0.85089f
C950 pn78 AVDD 0.46357f
C951 pn154 pn85 0.01807f
C952 pn223 pn159 0.20624f
C953 VCM pn156 0.72654f
C954 a_44486_19676_ a_44486_19396_ 1.17654f
C955 pn101 pn108 0.0148f
C956 pn96 pn105 0.43592f
C957 pn198 VPWR 0.2147f
C958 pn106 pn99 0.04234f
C959 pn176 pn103 0.09267f
C960 pn119 pn133 0.2087f
C961 AVDD pn171 0.04028f
C962 pn55 pn172 0.29311f
C963 pn200 pn90 0.01079f
C964 pn110 a_72766_16118_ 0.04634f
C965 pn9 pn79 0.08404f
C966 pn11 pn128 1.76737f
C967 pn7 pn138 0.07862f
C968 pn8 pn139 0.08434f
C969 VPWR pn186 1.01389f
C970 pn145 pn217 0.02805f
C971 pn76 pn58 0.06211f
C972 pn113 VCM 0.08908f
C973 pn202 pn31 0.1941f
C974 pn118 pn8 0.02582f
C975 pn51 pn6 1.93821f
C976 pn50 pn5 0.14198f
C977 pn212 AVDD 9.61286f
C978 pn14 pn35 0.237f
C979 VCM pn159 0.01993f
C980 pn16 pn59 0.60026f
C981 pn154 pn157 0.01521f
C982 pn101 pn99 0.19451f
C983 pn96 pn175 0.0161f
C984 pn3 pn1 0.20624f
C985 pn109 pn108 0.02568f
C986 pn111 pn103 0.01014f
C987 pn15 pn172 0.01101f
C988 pn55 pn88 0.14375f
C989 AVDD pn170 0.04282f
C990 VPWR pn205 0.16254f
C991 pn182 pn58 0.01856f
C992 pn10 pn128 0.096f
C993 pn211 pn206 0.02087f
C994 pn41 pn124 0.01206f
C995 pn1 VCM 1.68139f
C996 pn129 pn82 0.06312f
C997 pn119 pn28 0.19806f
C998 pn118 pn7 0.09172f
C999 pn50 pn6 0.05618f
C1000 pn77 AVDD 0.46548f
C1001 pn13 pn35 0.03823f
C1002 pn224 pn155 0.16069f
C1003 pn86 pn157 0.09267f
C1004 VCM pn223 1.68139f
C1005 pn154 pn156 0.3157f
C1006 pn109 pn99 1.59468f
C1007 pn96 pn100 6.47428f
C1008 pn198 pn65 0.02181f
C1009 pn202 pn133 0.01186f
C1010 AVDD pn90 0.19316f
C1011 pn54 pn172 0.03694f
C1012 pn152 pn143 0.03447f
C1013 pn15 pn35 0.0795f
C1014 pn146 pn216 0.01299f
C1015 pn9 pn212 1.00914f
C1016 pn200 pn121 0.01129f
C1017 pn145 pn80 0.01894f
C1018 VPWR pn204 0.22794f
C1019 a_52037_46392_ pn90 0.20416f
C1020 pn65 pn186 0.01927f
C1021 pn75 pn58 0.15484f
C1022 pn132 pn189 0.02068f
C1023 pn41 pn195 0.01605f
C1024 pn211 pn194 0.21846f
C1025 pn48 pn121 0.01435f
C1026 pn110 pn82 0.03536f
C1027 pn7 a_44486_19676_ 0.06397f
C1028 pn3 VCM 0.02564f
C1029 pn119 pn27 0.01905f
C1030 pn50 pn51 0.90403f
C1031 pn140 AVDD 0.44304f
C1032 pn158 pn157 0.01014f
C1033 pn86 pn156 0.14684f
C1034 pn120 pn84 0.0422f
C1035 pn12 pn35 0.61638f
C1036 pn106 pn1 1.1511f
C1037 a_96098_12142_ pn82 0.10957f
C1038 AVDD pn173 6.60498f
C1039 pn55 pn89 0.13948f
C1040 VPWR pn121 0.66824f
C1041 pn42 pn121 0.08628f
C1042 pn146 pn80 0.02699f
C1043 pn75 pn57 0.06426f
C1044 pn8 pn212 0.48256f
C1045 pn11 pn213 0.29311f
C1046 a_50103_45655_ pn15 0.0202f
C1047 pn110 pn220 0.19402f
C1048 pn68 pn51 0.15504f
C1049 pn128 AVDD 0.14235f
C1050 pn11 pn35 0.22448f
C1051 pn16 pn56 0.12564f
C1052 pn154 pn223 1.07882f
C1053 pn158 pn156 0.10035f
C1054 pn222 VCM 0.01565f
C1055 pn86 pn159 0.42393f
C1056 pn106 pn3 0.10314f
C1057 pn101 pn1 0.34986f
C1058 pn199 pn200 0.17392f
C1059 pn196 pn42 0.01515f
C1060 pn55 pn174 0.04204f
C1061 AVDD pn229 0.48122f
C1062 pn11 pn141 0.14375f
C1063 pn10 pn213 0.01101f
C1064 pn7 pn212 0.29222f
C1065 pn55 pn59 0.02521f
C1066 pn146 pn145 0.32428f
C1067 pn147 pn80 0.08038f
C1068 VPWR pn203 0.19068f
C1069 pn182 pn52 0.1477f
C1070 a_50103_45655_ pn54 0.04148f
C1071 pn38 pn121 0.05788f
C1072 pn211 pn188 0.01568f
C1073 pn74 pn57 0.15674f
C1074 pn106 VCM 0.3573f
C1075 pn68 pn50 0.07345f
C1076 pn215 AVDD 0.04166f
C1077 pn128 a_44486_19396_ 0.20416f
C1078 pn158 pn159 0.01193f
C1079 pn154 VCM 0.04431f
C1080 pn16 pn52 0.02731f
C1081 pn153 pn155 0.10851f
C1082 pn86 pn223 0.3585f
C1083 pn10 pn35 0.04894f
C1084 pn96 VINP 0.08548f
C1085 pn104 pn102 0.16069f
C1086 pn199 VPWR 0.17935f
C1087 pn101 pn3 0.39181f
C1088 a_72766_16118_ pn143 0.06135f
C1089 pn118 pn211 0.01688f
C1090 a_56212_34851_ pn155 0.06289f
C1091 AVDD pn162 0.47516f
C1092 pn15 pn59 0.08966f
C1093 pn55 pn58 0.03044f
C1094 VPWR pn179 0.62532f
C1095 pn147 pn145 0.11576f
C1096 pn181 pn189 0.09053f
C1097 pn9 pn128 0.20396f
C1098 pn65 pn121 0.7263f
C1099 pn38 pn203 0.15152f
C1100 pn74 pn56 0.06563f
C1101 pn11 pn142 0.04204f
C1102 pn101 VCM 0.13481f
C1103 pn176 pn220 0.14676f
C1104 pn99 pn120 0.02504f
C1105 pn118 pn30 0.04855f
C1106 pn214 AVDD 0.04028f
C1107 pn86 VCM 0.02242f
C1108 pn153 pn85 0.67514f
C1109 pn224 pn159 0.73924f
C1110 pn158 pn223 0.01692f
C1111 pn197 VPWR 0.21201f
C1112 AVDD pn172 0.03448f
C1113 pn93 pn168 0.08063f
C1114 pn150 pn143 6.18368f
C1115 a_52037_46392_ pn172 0.26159f
C1116 pn11 pn144 0.13948f
C1117 pn147 pn146 0.20241f
C1118 pn7 pn140 0.10066f
C1119 pn55 pn57 0.03043f
C1120 pn8 pn128 0.71669f
C1121 pn54 pn59 0.02397f
C1122 pn15 pn58 0.29265f
C1123 VPWR pn35 0.72461f
C1124 pn73 pn56 0.15674f
C1125 pn38 pn179 0.10733f
C1126 pn41 pn189 0.12985f
C1127 pn111 pn220 0.10035f
C1128 pn109 VCM 0.56665f
C1129 pn213 AVDD 0.03448f
C1130 pn224 pn223 0.52945f
C1131 pn158 VCM 0.14897f
C1132 pn226 pn159 0.11326f
C1133 pn120 pn156 0.23793f
C1134 pn126 pn113 0.01318f
C1135 pn207 VPWR 0.23099f
C1136 pn101 pn106 0.06846f
C1137 pn207 pn42 0.21208f
C1138 pn199 pn65 0.18443f
C1139 pn118 pn132 0.02297f
C1140 pn91 pn168 0.02724f
C1141 AVDD pn88 0.04637f
C1142 pn82 pn143 1.21406f
C1143 pn55 pn56 0.16595f
C1144 pn53 pn59 0.01447f
C1145 VPWR pn187 0.38429f
C1146 pn54 pn58 0.02605f
C1147 pn181 pn194 0.05733f
C1148 a_52037_46392_ pn88 0.25617f
C1149 pn7 pn128 0.022f
C1150 pn9 pn214 0.01759f
C1151 pn41 pn206 0.02814f
C1152 pn131 pn188 0.10015f
C1153 pn8 pn215 0.01763f
C1154 pn182 pn76 0.19464f
C1155 pn198 pn31 0.01042f
C1156 pn141 AVDD 0.04637f
C1157 pn14 pn52 0.1489f
C1158 pn16 pn76 0.01117f
C1159 pn213 a_44486_19396_ 0.26159f
C1160 pn225 pn157 0.1093f
C1161 pn224 VCM 0.29697f
C1162 pn158 pn222 0.17186f
C1163 pn226 pn223 0.31876f
C1164 pn153 pn156 0.18368f
C1165 pn86 pn154 0.13716f
C1166 pn109 pn106 0.57521f
C1167 pn177 pn112 0.04323f
C1168 a_52037_46952_ a_52037_46672_ 1.17654f
C1169 pn119 pn193 0.05716f
C1170 pn197 pn65 0.02319f
C1171 pn118 pn131 0.01825f
C1172 AVDD pn87 12.4349f
C1173 pn91 pn232 0.01299f
C1174 pn92 pn168 0.01905f
C1175 VPWR pn123 0.16447f
C1176 pn9 pn213 0.03694f
C1177 pn8 pn214 0.029f
C1178 pn7 pn215 0.01635f
C1179 pn54 pn57 0.02669f
C1180 pn211 pn186 0.02487f
C1181 a_50103_45655_ AVDD 0.01197f
C1182 pn41 pn194 0.01248f
C1183 pn1 pn120 1.44764f
C1184 a_52037_46392_ a_50103_45655_ 0.1345f
C1185 a_44748_40115_ pn161 0.04968f
C1186 pn141 a_44486_19396_ 0.25617f
C1187 pn26 pn188 0.18369f
C1188 pn153 pn159 0.39181f
C1189 pn16 pn182 0.02079f
C1190 pn226 VCM 0.45405f
C1191 pn9 pn35 0.05811f
C1192 pn158 pn154 0.18634f
C1193 pn109 pn101 1.33154f
C1194 pn96 pn112 0.04787f
C1195 pn176 pn99 0.13716f
C1196 pn111 pn108 0.17235f
C1197 pn198 pn133 0.02628f
C1198 pn207 pn65 0.018f
C1199 pn55 pn168 1.01634f
C1200 AVDD pn89 0.05776f
C1201 pn54 pn56 0.02669f
C1202 VPWR pn59 0.11981f
C1203 pn15 pn52 0.02282f
C1204 pn181 pn188 0.06076f
C1205 a_52037_46392_ pn89 0.01316f
C1206 pn75 pn182 0.01662f
C1207 pn126 VCM 0.09727f
C1208 pn3 pn120 0.22442f
C1209 pn198 pn29 0.01202f
C1210 pn21 gain_sel[0] 0.02188f
C1211 a_89198_9382_ AVDD 0.0251f
C1212 pn144 AVDD 0.05776f
C1213 pn8 pn35 0.0369f
C1214 pn153 pn223 0.34986f
C1215 pn158 pn86 0.30114f
C1216 a_44486_19956_ a_44486_19676_ 1.17654f
C1217 pn160 pn156 0.3852f
C1218 pn120 VCM 0.88032f
C1219 pn225 pn159 0.10314f
C1220 pn111 pn99 0.18634f
C1221 pn15 pn168 0.17259f
C1222 pn92 pn231 0.02805f
C1223 VPWR pn58 0.12472f
C1224 pn7 pn213 0.01584f
C1225 pn70 pn52 0.06354f
C1226 pn41 pn188 0.02965f
C1227 pn51 pn124 0.04634f
C1228 pn114 pn220 0.63956f
C1229 pn11 pn83 0.12747f
C1230 pn144 a_44486_19396_ 0.01316f
C1231 pn7 pn35 0.03645f
C1232 pn184 pn194 0.01605f
C1233 pn20 pn182 0.0158f
C1234 pn28 pn186 0.01776f
C1235 pn226 pn154 1.06048f
C1236 pn153 VCM 0.13481f
C1237 pn225 pn223 1.1511f
C1238 pn224 pn86 1.4573f
C1239 pn185 pn181 0.07416f
C1240 pn92 pn230 0.02469f
C1241 pn54 pn168 0.11984f
C1242 AVDD VOUT 11.2599f
C1243 pn91 pn93 0.20241f
C1244 pn11 pn80 1.01623f
C1245 pn7 pn141 0.02137f
C1246 VPWR pn57 0.14516f
C1247 pn131 pn186 0.02812f
C1248 pn69 pn52 0.1544f
C1249 pn60 pn188 0.03159f
C1250 pn211 pn121 0.01491f
C1251 pn110 VCM 0.27857f
C1252 pn106 pn120 0.07765f
C1253 pn218 AVDD 0.0137f
C1254 pn27 pn186 0.01207f
C1255 pn183 pn194 0.01178f
C1256 pn30 pn121 0.18943f
C1257 pn14 pn182 0.01709f
C1258 pn226 pn86 0.20503f
C1259 pn224 pn158 0.57012f
C1260 pn225 VCM 0.3573f
C1261 pn221 pn159 0.02725f
C1262 pn153 pn222 0.0148f
C1263 pn227 pn156 0.63956f
C1264 pn2 pn99 1.06048f
C1265 pn110 pn112 0.5261f
C1266 pn176 pn1 0.3585f
C1267 pn185 pn41 0.04618f
C1268 pn118 pn60 0.01356f
C1269 a_96098_12142_ VCM 0.04533f
C1270 AVDD pn228 2.38827f
C1271 pn92 pn93 0.11576f
C1272 pn53 pn168 0.12018f
C1273 VPWR pn56 0.1478f
C1274 pn200 pn52 0.1967f
C1275 pn15 pn76 0.02344f
C1276 pn14 pn16 0.02812f
C1277 pn11 pn145 0.05319f
C1278 pn10 pn80 0.17252f
C1279 a_52037_46952_ pn90 0.04536f
C1280 pn209 pn189 0.11055f
C1281 pn101 pn120 0.02167f
C1282 pn118 pn23 0.19816f
C1283 pn176 a_55785_6174_ 0.05891f
C1284 pn16 pn55 0.15064f
C1285 pn18 pn194 0.04673f
C1286 pn153 pn154 0.19451f
C1287 pn226 pn158 0.27056f
C1288 pn184 pn188 0.24265f
C1289 pn29 pn121 0.02388f
C1290 pn26 pn186 0.01044f
C1291 pn221 pn223 0.52777f
C1292 pn13 pn182 0.01233f
C1293 pn160 VCM 0.56665f
C1294 pn127 pn112 0.03272f
C1295 pn111 pn1 0.01692f
C1296 pn176 pn3 0.42393f
C1297 pn96 pn177 1.27773f
C1298 pn114 pn108 0.02269f
C1299 pn92 pn91 0.32428f
C1300 pn200 pn168 0.6109f
C1301 pn13 pn16 0.01194f
C1302 pn11 pn146 0.18513f
C1303 pn10 pn145 0.03081f
C1304 pn15 pn182 0.24904f
C1305 VPWR pn52 0.08682f
C1306 pn42 pn52 0.10325f
C1307 pn132 pn121 0.01255f
C1308 pn48 pn137 0.03225f
C1309 pn209 pn206 0.04545f
C1310 pn181 pn186 0.05865f
C1311 pn193 pn188 0.03071f
C1312 pn176 VCM 0.02242f
C1313 pn118 pn184 0.33223f
C1314 pn16 pn15 0.03447f
C1315 pn221 VCM 1.39878f
C1316 pn160 pn222 0.02718f
C1317 pn226 pn224 0.20728f
C1318 pn225 pn154 0.04234f
C1319 pn104 pn1 0.52945f
C1320 pn114 pn99 0.03972f
C1321 pn111 pn3 0.01193f
C1322 pn44 pn130 0.0187f
C1323 pn105 a_95787_5888_ 0.03044f
C1324 pn55 pn91 0.18512f
C1325 AVDD pn83 3.77399f
C1326 VPWR pn137 0.07828f
C1327 pn53 pn76 0.01058f
C1328 pn15 pn75 0.0127f
C1329 pn10 pn146 0.07253f
C1330 pn41 pn186 0.01826f
C1331 pn131 pn121 0.02756f
C1332 pn38 pn52 0.2442f
C1333 pn42 pn137 0.02235f
C1334 pn193 pn39 0.01836f
C1335 pn209 pn194 0.16855f
C1336 pn181 pn205 0.04605f
C1337 pn111 VCM 0.14897f
C1338 a_72766_21992_ pn143 0.03044f
C1339 pn80 AVDD 0.41182f
C1340 pn16 pn54 0.02535f
C1341 pn128 a_44486_19956_ 0.04536f
C1342 pn18 pn188 0.8394f
C1343 pn30 pn35 0.02331f
C1344 pn160 pn154 1.59468f
C1345 pn225 pn86 0.59982f
C1346 pn153 pn158 0.01743f
C1347 pn227 VCM 0.10604f
C1348 pn176 pn106 0.59982f
C1349 pn104 pn3 0.73924f
C1350 pn2 pn1 0.31876f
C1351 pn129 pn177 0.21172f
C1352 pn119 pn50 0.13002f
C1353 pn15 pn91 0.07235f
C1354 AVDD pn168 1.35442f
C1355 pn55 pn92 0.0529f
C1356 pn55 pn73 0.06565f
C1357 pn53 pn182 0.0173f
C1358 a_45396_45655_ pn53 0.01977f
C1359 pn130 pn121 0.01371f
C1360 pn41 pn205 0.16038f
C1361 pn60 pn186 0.02899f
C1362 pn65 pn52 0.17587f
C1363 pn104 VCM 0.29697f
C1364 pn118 pn18 0.02055f
C1365 gain_sel[3] pn50 0.01012f
C1366 pn2 a_55785_6174_ 0.036f
C1367 pn145 AVDD 0.44972f
C1368 pn16 pn53 0.02854f
C1369 pn153 pn224 0.81654f
C1370 pn225 pn158 0.46747f
C1371 pn227 pn222 0.02269f
C1372 pn111 pn106 0.46747f
C1373 pn2 pn3 0.11326f
C1374 pn178 pn1 0.52777f
C1375 pn129 pn96 0.35654f
C1376 pn110 pn177 0.32339f
C1377 pn100 a_95787_5888_ 0.03044f
C1378 pn15 pn92 0.03022f
C1379 a_56212_34851_ pn224 0.0438f
C1380 VPWR pn76 0.17692f
C1381 pn55 pn72 0.15674f
C1382 pn200 pn182 0.55131f
C1383 a_52037_46952_ pn172 0.01325f
C1384 pn9 pn80 0.11992f
C1385 pn13 pn14 0.01007f
C1386 pn209 pn188 0.04743f
C1387 pn64 pn52 0.02499f
C1388 pn181 pn121 1.57737f
C1389 pn51 pn206 0.18638f
C1390 pn2 VCM 0.45405f
C1391 pn67 gain_sel[2] 0.02459f
C1392 pn16 pn200 0.02774f
C1393 pn14 pn15 0.01988f
C1394 pn146 AVDD 0.25632f
C1395 pn112 pn143 0.15075f
C1396 pn225 pn224 0.16354f
C1397 pn227 pn154 0.03972f
C1398 pn153 pn226 0.54154f
C1399 pn184 pn186 0.05264f
C1400 pn160 pn158 0.3042f
C1401 pn110 pn96 0.02823f
C1402 pn104 pn106 0.16354f
C1403 pn111 pn101 0.01743f
C1404 pn178 pn3 0.02725f
C1405 pn127 pn177 0.23321f
C1406 pn202 pn50 0.19526f
C1407 pn207 pn132 0.19261f
C1408 pn198 pn193 0.24183f
C1409 pn118 pn209 0.14984f
C1410 pn15 pn55 14.3547f
C1411 pn54 pn92 0.12004f
C1412 a_52037_46952_ pn88 0.01602f
C1413 pn9 pn145 0.12109f
C1414 VPWR pn182 0.40621f
C1415 pn8 pn80 0.1204f
C1416 pn193 pn186 0.01191f
C1417 pn41 pn121 0.8778f
C1418 gain_sel[0] VPWR 0.70097f
C1419 pn50 pn206 0.05147f
C1420 pn51 pn194 0.06184f
C1421 pn178 VCM 1.39878f
C1422 pn96 a_96098_12142_ 0.12304f
C1423 a_47077_45655_ pn166 0.01195f
C1424 pn213 a_44486_19956_ 0.01325f
C1425 pn147 AVDD 0.28378f
C1426 pn16 VPWR 0.15964f
C1427 pn225 pn226 1.06987f
C1428 pn160 pn224 0.52315f
C1429 pn221 pn158 0.1344f
C1430 pn127 pn96 1.8247f
C1431 pn111 pn109 0.3042f
C1432 pn2 pn106 1.06987f
C1433 pn104 pn101 0.81654f
C1434 pn54 pn55 0.26733f
C1435 pn53 pn92 0.15914f
C1436 AVDD pn230 0.01478f
C1437 VPWR pn75 0.17825f
C1438 pn54 pn72 0.06632f
C1439 pn8 pn145 0.16132f
C1440 pn12 pn13 0.28026f
C1441 pn7 pn80 0.69819f
C1442 a_45396_45655_ AVDD 0.02724f
C1443 pn181 pn179 0.0943f
C1444 pn133 pn59 0.01096f
C1445 pn60 pn121 0.01001f
C1446 pn21 VPWR 0.18f
C1447 pn50 pn194 0.14536f
C1448 pn114 VCM 0.10604f
C1449 a_95786_21556_ pn151 0.03044f
C1450 a_47077_45655_ pn161 0.08845f
C1451 pn117 VPWR 0.07803f
C1452 a_89198_25050_ AVDD 0.0251f
C1453 pn141 a_44486_19956_ 0.01602f
C1454 pn18 pn186 0.1329f
C1455 pn221 pn224 0.11688f
C1456 pn227 pn158 0.03181f
C1457 pn178 pn106 0.19957f
C1458 pn2 pn101 0.54154f
C1459 pn104 pn109 0.52315f
C1460 pn110 pn129 0.01413f
C1461 pn208 pn50 0.12583f
C1462 a_56212_34851_ pn153 0.01072f
C1463 pn53 pn55 0.1656f
C1464 pn200 pn92 0.04253f
C1465 pn54 pn15 15.1936f
C1466 AVDD pn93 0.28809f
C1467 a_52037_46952_ pn89 0.02044f
C1468 a_57562_18659_ AVDD 0.02943f
C1469 VPWR pn74 0.17774f
C1470 pn7 pn145 0.16336f
C1471 pn54 pn71 0.15674f
C1472 pn142 a_44486_19956_ 0.02317f
C1473 pn83 IBIAS_IA 1.06411f
C1474 pn227 pn224 0.04374f
C1475 pn225 pn153 0.06846f
C1476 pn221 pn226 0.82491f
C1477 pn114 pn106 0.0288f
C1478 pn127 pn129 0.73237f
C1479 pn33 pn50 0.14943f
C1480 pn207 pn181 0.1315f
C1481 pn53 pn15 0.15741f
C1482 AVDD pn91 0.27687f
C1483 pn200 pn55 0.18307f
C1484 VPWR pn73 0.17846f
C1485 pn53 pn71 0.06825f
C1486 a_52037_46952_ pn174 0.02317f
C1487 pn11 pn12 0.26337f
C1488 pn7 pn146 0.02623f
C1489 pn193 pn121 0.0652f
C1490 pn209 pn186 2.26902f
C1491 pn176 pn120 0.89516f
C1492 pn14 VPWR 0.20204f
C1493 a_47077_45655_ pn171 0.02425f
C1494 pn177 pn143 1.25816f
C1495 pn144 a_44486_19956_ 0.02044f
C1496 pn160 pn153 1.33154f
C1497 pn95 VGND 4.2024f
C1498 pn102 VGND 6.70652f
C1499 pn107 VGND 21.57622f
C1500 pn175 VGND 6.4492f
C1501 pn100 VGND 27.85649f
C1502 VINP VGND 7.1866f
C1503 pn1 VGND 10.94772f
C1504 pn3 VGND 3.37121f
C1505 pn112 VGND 21.19229f
C1506 pn177 VGND 6.6974f
C1507 pn96 VGND 23.36218f
C1508 pn110 VGND 17.86632f
C1509 pn176 VGND 3.12573f
C1510 pn104 VGND 4.92502f
C1511 pn2 VGND 6.31201f
C1512 pn178 VGND 4.86999f
C1513 pn79 VGND 0.77223f
C1514 pn78 VGND 0.74289f
C1515 pn212 VGND 8.77649f
C1516 pn77 VGND 0.78531f
C1517 pn128 VGND 9.09453f
C1518 pn215 VGND 0.99547f
C1519 pn214 VGND 1.00386f
C1520 pn213 VGND 2.54013f
C1521 pn141 VGND 6.16009f
C1522 pn142 VGND 3.07639f
C1523 pn144 VGND 6.08196f
C1524 pn81 VGND 0.34588f
C1525 pn218 VGND 0.04462f
C1526 pn217 VGND 0.17768f
C1527 pn216 VGND 0.15064f
C1528 pn80 VGND 2.49827f
C1529 pn16 VGND 1.68543f
C1530 pn117 VGND 0.18952f
C1531 pn20 VGND 0.28179f
C1532 pn14 VGND 1.18312f
C1533 pn13 VGND 0.85051f
C1534 pn12 VGND 1.37482f
C1535 pn11 VGND 18.06442f
C1536 pn10 VGND 10.88148f
C1537 pn116 VGND 0.19398f
C1538 pn19 VGND 0.03086f
C1539 pn4 VGND 0.51151f
C1540 pn9 VGND 9.29006f
C1541 pn8 VGND 10.72425f
C1542 pn7 VGND 18.26755f
C1543 pn17 VGND 0.2307f
C1544 pn32 VGND 0.69934f
C1545 pn31 VGND 0.36433f
C1546 pn30 VGND 0.5342f
C1547 pn29 VGND 0.8864f
C1548 pn28 VGND 0.95278f
C1549 pn27 VGND 0.23492f
C1550 pn26 VGND 0.80446f
C1551 pn25 VGND 0.63499f
C1552 pn24 VGND 0.23533f
C1553 pn23 VGND 1.14986f
C1554 pn184 VGND 0.48017f
C1555 pn183 VGND 0.05076f
C1556 pn18 VGND 0.5762f
C1557 pn115 VGND 0.18449f
C1558 pn180 VGND 0.28799f
C1559 pn22 VGND 0.5661f
C1560 gain_sel[0] VGND 5.22742f
C1561 pn21 VGND 0.58599f
C1562 gain_sel[1] VGND 4.22149f
C1563 pn125 VGND 0.33348f
C1564 pn201 VGND 0.02485f
C1565 pn46 VGND 0.25686f
C1566 pn202 VGND 0.32881f
C1567 pn34 VGND 0.03011f
C1568 pn208 VGND 0.47805f
C1569 pn33 VGND 0.19951f
C1570 pn185 VGND 0.28265f
C1571 pn198 VGND 1.54832f
C1572 pn45 VGND 0.48083f
C1573 pn44 VGND 0.47322f
C1574 pn43 VGND 0.30598f
C1575 pn196 VGND 0.02909f
C1576 pn199 VGND 0.77656f
C1577 pn197 VGND 0.96165f
C1578 pn207 VGND 0.33388f
C1579 pn49 VGND 0.31133f
C1580 pn47 VGND 0.27207f
C1581 pn124 VGND 0.18878f
C1582 pn195 VGND 0.18935f
C1583 pn192 VGND 0.02484f
C1584 pn191 VGND 0.19353f
C1585 pn190 VGND 0.05267f
C1586 pn189 VGND 0.8374f
C1587 pn206 VGND 0.4312f
C1588 pn194 VGND 0.46754f
C1589 pn40 VGND 0.28532f
C1590 pn188 VGND 1.02373f
C1591 pn39 VGND 0.43915f
C1592 pn37 VGND 0.03376f
C1593 pn36 VGND 0.02862f
C1594 pn186 VGND 0.92084f
C1595 pn205 VGND 0.2787f
C1596 pn204 VGND 0.44656f
C1597 pn203 VGND 0.29368f
C1598 pn179 VGND 0.65392f
C1599 pn35 VGND 2.56113f
C1600 pn187 VGND 0.73092f
C1601 pn123 VGND 0.32079f
C1602 pn59 VGND 1.36288f
C1603 pn58 VGND 1.16494f
C1604 pn57 VGND 1.59662f
C1605 pn56 VGND 1.27834f
C1606 pn52 VGND 1.79153f
C1607 pn137 VGND 0.19276f
C1608 pn66 VGND 0.03457f
C1609 pn76 VGND 0.25988f
C1610 pn182 VGND 0.6245f
C1611 pn75 VGND 0.24285f
C1612 pn74 VGND 0.24219f
C1613 pn73 VGND 0.24342f
C1614 pn72 VGND 0.24319f
C1615 pn71 VGND 0.24169f
C1616 pn70 VGND 0.24143f
C1617 pn69 VGND 0.25407f
C1618 pn48 VGND 0.63211f
C1619 pn42 VGND 1.22829f
C1620 pn38 VGND 2.02393f
C1621 pn65 VGND 0.97439f
C1622 pn64 VGND 0.94897f
C1623 pn63 VGND 1.13542f
C1624 pn136 VGND 0.18632f
C1625 pn61 VGND 0.03139f
C1626 pn62 VGND 1.06453f
C1627 pn211 VGND 1.17418f
C1628 pn181 VGND 1.11683f
C1629 pn41 VGND 1.00651f
C1630 pn60 VGND 0.7066f
C1631 pn135 VGND 0.1846f
C1632 pn193 VGND 1.17356f
C1633 pn210 VGND 0.39377f
C1634 pn134 VGND 0.31771f
C1635 pn209 VGND 1.48867f
C1636 pn5 VGND 1.7734f
C1637 pn6 VGND 1.45594f
C1638 pn51 VGND 1.75624f
C1639 pn50 VGND 2.81896f
C1640 pn68 VGND 0.25782f
C1641 gain_sel[2] VGND 4.97252f
C1642 pn67 VGND 0.28868f
C1643 gain_sel[3] VGND 5.2295f
C1644 pn143 VGND 17.68813f
C1645 IBIAS_IA VGND 68.52367f
C1646 pn152 VGND 22.06107f
C1647 VINN VGND 7.284f
C1648 pn219 VGND 1.07447f
C1649 pn150 VGND 27.35535f
C1650 pn82 VGND 27.25312f
C1651 pn220 VGND 17.03716f
C1652 pn84 VGND 13.49696f
C1653 pn155 VGND 6.7214f
C1654 pn85 VGND 8.74168f
C1655 pn223 VGND 7.92498f
C1656 VCM VGND 51.50901f
C1657 pn222 VGND 0.11377f
C1658 pn86 VGND 4.36173f
C1659 pn224 VGND 9.24403f
C1660 pn226 VGND 4.68881f
C1661 pn120 VGND 27.99464f
C1662 pn225 VGND 5.90261f
C1663 pn221 VGND 1.07173f
C1664 pn227 VGND 7.03122f
C1665 pn161 VGND 9.18897f
C1666 pn171 VGND 1.49801f
C1667 pn170 VGND 1.05924f
C1668 pn90 VGND 7.29839f
C1669 pn173 VGND 22.55321f
C1670 pn229 VGND 13.93035f
C1671 pn172 VGND 5.7334f
C1672 pn88 VGND 3.08835f
C1673 pn87 VGND 26.01114f
C1674 pn89 VGND 1.92687f
C1675 pn174 VGND 3.07404f
C1676 VOUT VGND 49.27236f
C1677 pn228 VGND 4.41259f
C1678 pn94 VGND 0.2873f
C1679 pn83 VGND 15.71223f
C1680 pn232 VGND 0.26942f
C1681 pn231 VGND 0.04003f
C1682 pn230 VGND 0.0431f
C1683 pn93 VGND 0.46195f
C1684 pn91 VGND 0.47291f
C1685 pn92 VGND 1.18559f
C1686 pn55 VGND 19.09011f
C1687 pn15 VGND 10.57571f
C1688 pn54 VGND 8.93499f
C1689 pn53 VGND 12.82187f
C1690 pn200 VGND 19.98384f
C1691 VPWR VGND 65.6578f
C1692 AVDD VGND 0.23444p
C1693 VGND_t258 VGND 0.35247f
C1694 VGND_t89 VGND 0.49292f
C1695 VGND_t495 VGND 0.16934f
C1696 VGND_t303 VGND 0.2223f
C1697 VGND_t353 VGND 0.01038f
C1698 VGND_t525 VGND 0.27249f
C1699 VGND_t347 VGND 0.02096f
C1700 VGND_t345 VGND 0.02096f
C1701 VGND_t366 VGND 0.02096f
C1702 VGND_t333 VGND 0.02096f
C1703 VGND_t332 VGND 0.02096f
C1704 VGND_t355 VGND 0.02096f
C1705 VGND_t254 VGND 0.07387f
C1706 VGND_t270 VGND 0.08149f
C1707 VGND_t356 VGND 0.02096f
C1708 VGND_t360 VGND 0.02096f
C1709 VGND_t327 VGND 0.02096f
C1710 VGND_t328 VGND 0.02096f
C1711 VGND_t361 VGND 0.02096f
C1712 VGND_t368 VGND 0.02096f
C1713 VGND_t338 VGND 0.02096f
C1714 VGND_t54 VGND 0.14372f
C1715 VGND_t340 VGND 0.02096f
C1716 VGND_t277 VGND 0.17006f
C1717 VGND_t343 VGND 0.02096f
C1718 VGND_t87 VGND 0.24691f
C1719 VGND_t74 VGND 0.19174f
C1720 VGND_t348 VGND 0.02096f
C1721 VGND_t352 VGND 0.01038f
C1722 VGND_t117 VGND 0.14589f
C1723 VGND_t120 VGND 0.09662f
C1724 VGND_t529 VGND 0.60761f
C1725 VGND_t423 VGND 0.17832f
C1726 VGND_t83 VGND 0.66177f
C1727 VGND_t20 VGND 0.245f
C1728 VGND_t455 VGND 0.53573f
C1729 VGND_t402 VGND 0.24334f
C1730 VGND_t24 VGND 0.20906f
C1731 VGND_t265 VGND 0.08776f
C1732 VGND_t404 VGND 0.2032f
C1733 VGND_t507 VGND 0.08534f
C1734 VGND_t128 VGND 0.0911f
C1735 VGND_t10 VGND 0.08593f
C1736 VGND_t419 VGND 0.1784f
C1737 VGND_t323 VGND 0.17527f
C1738 VGND_t430 VGND 0.08678f
C1739 VGND_t268 VGND 0.08689f
C1740 VGND_t319 VGND 0.09441f
C1741 VGND_t38 VGND 0.0868f
C1742 VGND_t325 VGND 0.11202f
C1743 VGND_t299 VGND 0.0884f
C1744 VGND_t111 VGND 0.18299f
C1745 VGND_t394 VGND 0.01038f
C1746 VGND_t393 VGND 0.01038f
C1747 VGND_t391 VGND 0.02096f
C1748 VGND_t389 VGND 0.02096f
C1749 VGND_t72 VGND 0.20074f
C1750 VGND_t383 VGND 0.02096f
C1751 VGND_t381 VGND 0.02096f
C1752 VGND_t376 VGND 0.02096f
C1753 VGND_t375 VGND 0.02096f
C1754 VGND_t371 VGND 0.02096f
C1755 VGND_t370 VGND 0.02096f
C1756 VGND_t288 VGND 0.39538f
C1757 VGND_t61 VGND 0.37544f
C1758 VGND_t385 VGND 0.01038f
C1759 VGND_t386 VGND 0.01038f
C1760 VGND_t122 VGND 0.2377f
C1761 VGND_t52 VGND 0.49203f
C1762 VGND_t6 VGND 0.9109f
C1763 VGND_t59 VGND 0.08596f
C1764 VGND_t296 VGND 0.48648f
C1765 VGND_t85 VGND 0.55815f
C1766 VGND_t40 VGND 0.08542f
C1767 VGND_t28 VGND 0.80414f
C1768 VGND_t497 VGND 0.65125f
C1769 VGND_t45 VGND 0.29545f
C1770 VGND_t321 VGND 0.1066f
C1771 VGND_t36 VGND 0.21007f
C1772 VGND_t91 VGND 0.53544f
C1773 AVDD_n11 VGND 0.11592f
C1774 AVDD_t95 VGND 0.59128f
C1775 AVDD_t93 VGND 3.18596f
C1776 AVDD_n24 VGND 0.15002f
C1777 AVDD_n29 VGND 0.23651f
C1778 AVDD_t219 VGND 2.69641f
C1779 AVDD_n30 VGND 0.04029f
C1780 AVDD_n32 VGND 0.23651f
C1781 AVDD_t54 VGND 0.23651f
C1782 AVDD_t101 VGND 0.47303f
C1783 AVDD_n40 VGND 0.14279f
C1784 AVDD_n42 VGND 0.2538f
C1785 AVDD_n43 VGND 0.23651f
C1786 AVDD_n44 VGND 0.23651f
C1787 AVDD_n45 VGND 0.23651f
C1788 AVDD_t107 VGND 0.27825f
C1789 AVDD_n46 VGND 0.23651f
C1790 AVDD_t222 VGND 0.55998f
C1791 AVDD_n47 VGND 0.23651f
C1792 AVDD_n48 VGND 0.23651f
C1793 AVDD_n49 VGND 0.23651f
C1794 AVDD_n50 VGND 0.23651f
C1795 AVDD_n51 VGND 0.23651f
C1796 AVDD_n52 VGND 0.23651f
C1797 AVDD_n53 VGND 0.23651f
C1798 AVDD_t220 VGND 0.65737f
C1799 AVDD_n54 VGND 0.23651f
C1800 AVDD_n55 VGND 0.23651f
C1801 AVDD_n56 VGND 0.23651f
C1802 AVDD_n57 VGND 0.23651f
C1803 AVDD_n58 VGND 0.23651f
C1804 AVDD_t97 VGND 0.53911f
C1805 AVDD_t218 VGND 0.23651f
C1806 AVDD_n59 VGND 0.23651f
C1807 AVDD_t99 VGND 0.47303f
C1808 AVDD_n60 VGND 0.23651f
C1809 AVDD_n61 VGND 0.23651f
C1810 AVDD_n62 VGND 0.23651f
C1811 AVDD_n64 VGND 0.23651f
C1812 AVDD_n66 VGND 0.23651f
C1813 AVDD_t105 VGND 0.70954f
C1814 AVDD_n70 VGND 0.23651f
C1815 AVDD_n72 VGND 0.19477f
C1816 AVDD_n74 VGND 0.23651f
C1817 AVDD_n76 VGND 0.23651f
C1818 AVDD_n78 VGND 0.23651f
C1819 AVDD_t108 VGND 1.31078f
C1820 AVDD_t106 VGND 1.31076f
C1821 AVDD_t104 VGND 1.31076f
C1822 AVDD_t102 VGND 1.31076f
C1823 AVDD_t100 VGND 1.31076f
C1824 AVDD_t98 VGND 1.31076f
C1825 AVDD_t96 VGND 1.31076f
C1826 AVDD_t94 VGND 1.31785f
C1827 AVDD_n80 VGND 0.02697f
C1828 AVDD_n81 VGND 0.01932f
C1829 AVDD_n82 VGND 0.01931f
C1830 AVDD_n83 VGND 0.01931f
C1831 AVDD_n84 VGND 0.01932f
C1832 AVDD_n85 VGND 0.01931f
C1833 AVDD_n86 VGND 0.01642f
C1834 AVDD_n87 VGND 0.01365f
C1835 AVDD_n88 VGND 0.01719f
C1836 AVDD_n89 VGND 0.08477f
C1837 AVDD_n91 VGND 0.03652f
C1838 AVDD_n100 VGND 0.26498f
C1839 AVDD_n105 VGND 0.04152f
C1840 AVDD_n107 VGND 0.02227f
C1841 AVDD_n108 VGND 0.47303f
C1842 AVDD_n110 VGND 0.47303f
C1843 AVDD_n112 VGND 0.47303f
C1844 AVDD_n114 VGND 0.47303f
C1845 AVDD_t3 VGND 0.5565f
C1846 AVDD_n117 VGND 0.70954f
C1847 AVDD_n118 VGND 0.47303f
C1848 AVDD_n138 VGND 0.02302f
C1849 AVDD_n149 VGND 0.47303f
C1850 AVDD_n151 VGND 0.70954f
C1851 AVDD_n159 VGND 0.0185f
C1852 AVDD_n164 VGND 0.21952f
C1853 AVDD_n165 VGND 0.01291f
C1854 AVDD_t119 VGND 1.32817f
C1855 AVDD_t118 VGND 1.31076f
C1856 AVDD_t117 VGND 1.31076f
C1857 AVDD_t116 VGND 1.31076f
C1858 AVDD_t115 VGND 1.31076f
C1859 AVDD_t113 VGND 1.31076f
C1860 AVDD_t111 VGND 1.31076f
C1861 AVDD_t109 VGND 1.31786f
C1862 AVDD_n166 VGND 0.02697f
C1863 AVDD_n167 VGND 0.01932f
C1864 AVDD_n168 VGND 0.01931f
C1865 AVDD_n169 VGND 0.01931f
C1866 AVDD_n170 VGND 0.01931f
C1867 AVDD_n171 VGND 0.01932f
C1868 AVDD_n172 VGND 0.01641f
C1869 AVDD_n173 VGND 0.47303f
C1870 AVDD_n174 VGND 0.03473f
C1871 AVDD_n180 VGND 0.18398f
C1872 AVDD_n181 VGND 0.23651f
C1873 AVDD_n182 VGND 0.07471f
C1874 AVDD_n183 VGND 0.23651f
C1875 AVDD_n190 VGND 0.23651f
C1876 AVDD_t46 VGND 0.23651f
C1877 AVDD_t47 VGND 1.11835f
C1878 AVDD_n193 VGND 0.04326f
C1879 AVDD_n196 VGND 0.23651f
C1880 AVDD_n197 VGND 0.09338f
C1881 AVDD_n198 VGND 0.03261f
C1882 AVDD_n199 VGND 0.0342f
C1883 AVDD_n201 VGND 0.23651f
C1884 AVDD_n202 VGND 0.23651f
C1885 AVDD_t67 VGND 0.05423f
C1886 AVDD_t70 VGND 0.05395f
C1887 AVDD_t65 VGND 1.01063f
C1888 AVDD_n204 VGND 0.03303f
C1889 AVDD_n205 VGND 0.03152f
C1890 AVDD_t110 VGND 0.23651f
C1891 AVDD_t69 VGND 0.23651f
C1892 AVDD_n210 VGND 0.23651f
C1893 AVDD_t68 VGND 0.23651f
C1894 AVDD_n212 VGND 0.23651f
C1895 AVDD_n214 VGND 0.23651f
C1896 AVDD_n215 VGND 0.23651f
C1897 AVDD_t66 VGND 0.23651f
C1898 AVDD_t64 VGND 0.23651f
C1899 AVDD_n217 VGND 0.23651f
C1900 AVDD_n219 VGND 0.23651f
C1901 AVDD_n220 VGND 0.47303f
C1902 AVDD_n222 VGND 0.17594f
C1903 AVDD_n223 VGND 0.28173f
C1904 AVDD_n225 VGND 0.23651f
C1905 AVDD_t112 VGND 0.17043f
C1906 AVDD_n228 VGND 0.3026f
C1907 AVDD_t230 VGND 0.27129f
C1908 AVDD_n229 VGND 0.23651f
C1909 AVDD_n231 VGND 0.04794f
C1910 AVDD_t48 VGND 1.78011f
C1911 AVDD_n232 VGND 0.15595f
C1912 AVDD_n233 VGND 0.11392f
C1913 AVDD_t229 VGND 0.04319f
C1914 AVDD_n234 VGND 0.01928f
C1915 AVDD_n235 VGND 0.07171f
C1916 AVDD_t55 VGND 0.32592f
C1917 AVDD_n237 VGND 0.10072f
C1918 AVDD_t227 VGND 0.49303f
C1919 AVDD_n239 VGND 0.03523f
C1920 AVDD_n244 VGND 0.70954f
C1921 AVDD_n245 VGND 0.12081f
C1922 AVDD_n246 VGND 0.06551f
C1923 AVDD_n247 VGND 0.02778f
C1924 AVDD_n248 VGND 0.02803f
C1925 AVDD_n249 VGND 0.04142f
C1926 AVDD_n250 VGND 0.02897f
C1927 AVDD_n251 VGND 0.03087f
C1928 AVDD_n253 VGND 0.01716f
C1929 AVDD_n255 VGND 0.03127f
C1930 AVDD_t225 VGND 0.06188f
C1931 AVDD_t226 VGND 4.40198f
C1932 AVDD_n256 VGND 0.03715f
C1933 AVDD_n257 VGND 0.03772f
C1934 AVDD_n258 VGND 0.01431f
C1935 AVDD_n259 VGND 0.02454f
C1936 AVDD_n261 VGND 0.02286f
C1937 AVDD_n263 VGND 0.0387f
C1938 AVDD_n264 VGND 0.04677f
C1939 AVDD_n265 VGND 0.0244f
C1940 AVDD_n266 VGND 0.04803f
C1941 AVDD_n267 VGND 0.04507f
C1942 AVDD_n268 VGND 0.02674f
C1943 AVDD_n269 VGND 0.03995f
C1944 AVDD_n270 VGND 0.01112f
C1945 AVDD_n271 VGND 0.03533f
C1946 AVDD_n272 VGND 0.04091f
C1947 AVDD_n273 VGND 0.03349f
C1948 AVDD_n274 VGND 0.02363f
C1949 AVDD_n275 VGND 0.01675f
C1950 AVDD_n276 VGND 0.59128f
C1951 AVDD_n277 VGND 0.18398f
C1952 AVDD_n279 VGND 0.36173f
C1953 AVDD_n280 VGND 0.10072f
C1954 AVDD_t114 VGND 3.5524f
C1955 AVDD_n283 VGND 0.03103f
C1956 AVDD_n284 VGND 0.12543f
C1957 AVDD_n285 VGND 0.03975f
C1958 AVDD_n286 VGND 0.01802f
C1959 AVDD_n287 VGND 0.01741f
C1960 AVDD_n292 VGND 0.04174f
C1961 AVDD_n293 VGND 0.02945f
C1962 AVDD_n294 VGND 0.02393f
C1963 AVDD_n295 VGND 1.53741f
C1964 AVDD_n296 VGND 0.13249f
C1965 AVDD_n297 VGND 0.47303f
C1966 AVDD_n299 VGND 0.70954f
C1967 AVDD_n302 VGND 1.48168f
C1968 AVDD_n303 VGND 0.19403f
C1969 AVDD_n304 VGND 0.01383f
C1970 AVDD_n312 VGND 0.1497f
C1971 AVDD_t221 VGND 1.39299f
C1972 AVDD_n313 VGND 0.03596f
C1973 AVDD_n314 VGND 0.01745f
C1974 AVDD_n315 VGND 0.02994f
C1975 AVDD_n316 VGND 0.03413f
C1976 AVDD_n317 VGND 0.03087f
C1977 AVDD_n318 VGND 0.03272f
C1978 AVDD_t223 VGND 0.05036f
C1979 AVDD_t224 VGND 2.15202f
C1980 AVDD_n319 VGND 0.02725f
C1981 AVDD_n320 VGND 0.02583f
C1982 AVDD_n322 VGND 0.02957f
C1983 AVDD_n323 VGND 0.05775f
C1984 AVDD_n324 VGND 0.04509f
C1985 AVDD_n325 VGND 0.02383f
C1986 AVDD_n326 VGND 0.03445f
C1987 AVDD_n327 VGND 0.0267f
C1988 AVDD_n328 VGND 0.03837f
C1989 AVDD_n330 VGND 0.17682f
C1990 AVDD_t103 VGND 1.76341f
C1991 AVDD_n331 VGND 0.20759f
C1992 AVDD_n333 VGND 0.47303f
C1993 AVDD_n334 VGND 0.04483f
C1994 AVDD_n335 VGND 0.04223f
C1995 AVDD_n336 VGND 0.01722f
C1996 AVDD_n346 VGND 0.02626f
C1997 AVDD_n347 VGND 0.02656f
C1998 AVDD_t5 VGND 0.05757f
C1999 AVDD_n348 VGND 0.01486f
C2000 AVDD_t4 VGND 0.35195f
C2001 AVDD_n350 VGND 0.01963f
C2002 AVDD_n351 VGND 0.02163f
C2003 AVDD_n352 VGND 0.01235f
C2004 AVDD_t77 VGND 0.2837f
C2005 AVDD_n355 VGND 0.02103f
C2006 AVDD_t39 VGND 0.13975f
C2007 AVDD_n356 VGND 0.01087f
C2008 AVDD_n357 VGND 0.01192f
C2009 AVDD_t0 VGND 0.2673f
C2010 AVDD_n360 VGND 0.03626f
C2011 AVDD_n361 VGND 0.01323f
C2012 AVDD_t43 VGND 0.16926f
C2013 AVDD_n362 VGND 0.01248f
C2014 AVDD_n363 VGND 0.01274f
C2015 AVDD_n364 VGND 0.01206f
C2016 AVDD_t38 VGND 0.23046f
C2017 AVDD_n366 VGND 0.01508f
C2018 AVDD_n367 VGND 0.11936f
C2019 AVDD_t1 VGND 0.27475f
C2020 AVDD_n368 VGND 0.05547f
C2021 AVDD_t60 VGND 0.25835f
C2022 AVDD_n369 VGND 0.05773f
C2023 AVDD_t44 VGND 0.25391f
C2024 AVDD_n370 VGND 0.05773f
C2025 AVDD_t50 VGND 0.25613f
C2026 AVDD_n371 VGND 0.07062f
C2027 AVDD_n372 VGND 0.75965f
C2028 AVDD_n373 VGND 0.4539f
C2029 AVDD_n374 VGND 0.49772f
C2030 AVDD_n375 VGND 0.38804f
C2031 AVDD_n376 VGND 0.1655f
C2032 AVDD_n377 VGND 0.16645f
C2033 AVDD_n378 VGND 5.99588f
C2034 AVDD_n379 VGND 22.3923f
C2035 AVDD_n380 VGND 0.55519f
C2036 AVDD_t89 VGND 0.30974f
C2037 AVDD_n382 VGND 0.01756f
C2038 AVDD_n383 VGND 0.01003f
C2039 AVDD_n384 VGND 0.01003f
C2040 AVDD_n385 VGND 0.01003f
C2041 AVDD_n386 VGND 0.01003f
C2042 AVDD_n387 VGND 0.01003f
C2043 AVDD_n388 VGND 0.09329f
C2044 AVDD_n389 VGND 0.01003f
C2045 AVDD_n390 VGND 1.14292f
C2046 AVDD_n391 VGND 0.01003f
C2047 AVDD_n392 VGND 0.05567f
C2048 AVDD_t79 VGND 4.75374f
C2049 AVDD_n393 VGND 0.02936f
C2050 AVDD_n394 VGND 0.02811f
C2051 AVDD_n395 VGND 0.07496f
C2052 AVDD_n396 VGND 0.02654f
C2053 AVDD_n397 VGND 0.02782f
C2054 AVDD_t63 VGND 3.57816f
C2055 AVDD_n398 VGND 1.81188f
C2056 AVDD_n399 VGND 12.9189f
C2057 AVDD_n400 VGND 2.30699f
C2058 AVDD_t62 VGND 8.23077f
C2059 AVDD_t61 VGND 8.23077f
C2060 AVDD_t184 VGND 0.21995f
C2061 AVDD_n401 VGND 0.05567f
C2062 AVDD_n402 VGND 0.01003f
C2063 AVDD_n403 VGND 0.01003f
C2064 AVDD_n404 VGND 0.02931f
C2065 AVDD_n405 VGND 0.02826f
C2066 AVDD_n406 VGND 0.01756f
C2067 AVDD_n407 VGND 0.01003f
C2068 AVDD_n408 VGND 0.01003f
C2069 AVDD_n409 VGND 0.01003f
C2070 AVDD_n410 VGND 0.01003f
C2071 AVDD_n411 VGND 0.01003f
C2072 AVDD_n412 VGND 0.02784f
C2073 AVDD_n413 VGND 0.07496f
C2074 AVDD_n414 VGND 0.0264f
C2075 AVDD_n415 VGND 0.10881f
C2076 AVDD_n416 VGND 0.05567f
C2077 AVDD_n417 VGND 0.01003f
C2078 AVDD_n418 VGND 0.01003f
C2079 AVDD_n419 VGND 0.02931f
C2080 AVDD_n420 VGND 0.02826f
C2081 AVDD_n421 VGND 0.01756f
C2082 AVDD_n422 VGND 0.01003f
C2083 AVDD_n423 VGND 0.01003f
C2084 AVDD_n424 VGND 0.01003f
C2085 AVDD_n425 VGND 0.01003f
C2086 AVDD_n426 VGND 0.01003f
C2087 AVDD_t167 VGND 0.21907f
C2088 AVDD_n427 VGND 0.02784f
C2089 AVDD_n428 VGND 0.07496f
C2090 AVDD_n429 VGND 0.02639f
C2091 AVDD_n430 VGND 0.10882f
C2092 AVDD_n431 VGND 11.1056f
C2093 AVDD_n432 VGND 2.18343f
C2094 AVDD_n433 VGND 2.45494f
C2095 AVDD_t75 VGND 0.75126f
C2096 AVDD_n434 VGND 5.53586f
C2097 AVDD_t71 VGND 8.23079f
C2098 AVDD_n435 VGND 0.05567f
C2099 AVDD_n436 VGND 0.01003f
C2100 AVDD_t157 VGND 0.21907f
C2101 AVDD_n437 VGND 0.01003f
C2102 AVDD_n438 VGND 0.02931f
C2103 AVDD_n439 VGND 0.02826f
C2104 AVDD_n440 VGND 0.01756f
C2105 AVDD_n441 VGND 0.01003f
C2106 AVDD_n442 VGND 0.01003f
C2107 AVDD_n443 VGND 0.01003f
C2108 AVDD_n444 VGND 0.01003f
C2109 AVDD_n445 VGND 0.01003f
C2110 AVDD_n446 VGND 0.02784f
C2111 AVDD_n447 VGND 0.07496f
C2112 AVDD_n448 VGND 0.0264f
C2113 AVDD_n449 VGND 0.10881f
C2114 AVDD_n450 VGND 2.1756f
C2115 AVDD_n451 VGND 2.26427f
C2116 AVDD_t37 VGND 0.0172f
C2117 AVDD_n452 VGND 0.03518f
C2118 AVDD_t24 VGND 0.0172f
C2119 AVDD_t22 VGND 1.98713f
C2120 AVDD_t23 VGND 0.01702f
C2121 AVDD_t21 VGND 0.0172f
C2122 AVDD_t20 VGND 0.0172f
C2123 AVDD_t19 VGND 0.0172f
C2124 AVDD_t17 VGND 2.97011f
C2125 AVDD_t18 VGND 0.01702f
C2126 AVDD_t15 VGND 0.0172f
C2127 AVDD_t14 VGND 0.0172f
C2128 AVDD_t13 VGND 8.6197f
C2129 AVDD_t11 VGND 2.97011f
C2130 AVDD_t12 VGND 0.01702f
C2131 AVDD_t10 VGND 0.0172f
C2132 AVDD_t9 VGND 0.0172f
C2133 AVDD_t8 VGND 0.0172f
C2134 AVDD_t16 VGND 0.01722f
C2135 AVDD_n453 VGND 0.03068f
C2136 AVDD_t29 VGND 8.55035f
C2137 AVDD_t30 VGND 0.0172f
C2138 AVDD_t31 VGND 0.0172f
C2139 AVDD_t32 VGND 0.01702f
C2140 AVDD_t33 VGND 0.0172f
C2141 AVDD_t34 VGND 0.0172f
C2142 AVDD_t35 VGND 0.0172f
C2143 AVDD_t36 VGND 0.01702f
C2144 AVDD_n455 VGND 0.01902f
C2145 AVDD_n456 VGND 0.02233f
C2146 AVDD_n457 VGND 0.03083f
C2147 AVDD_n458 VGND 0.0309f
C2148 AVDD_n459 VGND 0.02965f
C2149 AVDD_n461 VGND 0.01902f
C2150 AVDD_n462 VGND 0.02234f
C2151 AVDD_n463 VGND 0.03083f
C2152 AVDD_n464 VGND 0.0309f
C2153 AVDD_n465 VGND 0.02965f
C2154 AVDD_t28 VGND 0.01702f
C2155 AVDD_t26 VGND 0.0172f
C2156 AVDD_t27 VGND 0.0172f
C2157 AVDD_t25 VGND 0.0172f
C2158 AVDD_n466 VGND 0.02965f
C2159 AVDD_n467 VGND 0.0309f
C2160 AVDD_n468 VGND 0.03083f
C2161 AVDD_n469 VGND 0.02234f
C2162 AVDD_n470 VGND 0.01902f
C2163 AVDD_t6 VGND 3.38645f
C2164 AVDD_t7 VGND 0.01722f
C2165 AVDD_n472 VGND 0.03068f
C2166 AVDD_n473 VGND 0.02965f
C2167 AVDD_n474 VGND 0.0309f
C2168 AVDD_n475 VGND 0.03083f
C2169 AVDD_n476 VGND 0.02233f
C2170 AVDD_n477 VGND 0.01902f
C2171 AVDD_n478 VGND 0.02965f
C2172 AVDD_n479 VGND 0.0309f
C2173 AVDD_n480 VGND 0.03083f
C2174 AVDD_n481 VGND 0.02233f
C2175 AVDD_n482 VGND 0.01902f
C2176 AVDD_n483 VGND 0.02965f
C2177 AVDD_n484 VGND 0.0309f
C2178 AVDD_n485 VGND 0.03083f
C2179 AVDD_n486 VGND 0.02233f
C2180 AVDD_n487 VGND 0.01902f
C2181 AVDD_n488 VGND 0.05566f
C2182 AVDD_n489 VGND 0.04643f
C2183 AVDD_n490 VGND 0.21987f
C2184 AVDD_n498 VGND 0.19403f
C2185 AVDD_n502 VGND 0.47303f
C2186 AVDD_n503 VGND 0.02392f
C2187 AVDD_n505 VGND 0.02883f
C2188 AVDD_n507 VGND 0.47303f
C2189 AVDD_n508 VGND 0.47303f
C2190 AVDD_n509 VGND 0.47303f
C2191 AVDD_n510 VGND 0.47303f
C2192 AVDD_n511 VGND 0.47303f
C2193 AVDD_n512 VGND 0.49389f
C2194 AVDD_t56 VGND 0.53563f
C2195 AVDD_n513 VGND 0.47303f
C2196 AVDD_n514 VGND 0.70954f
C2197 AVDD_n515 VGND 0.47303f
C2198 AVDD_n516 VGND 0.47303f
C2199 AVDD_n517 VGND 0.05731f
C2200 AVDD_t128 VGND 1.07427f
C2201 AVDD_t127 VGND 1.07327f
C2202 AVDD_n518 VGND 0.02725f
C2203 AVDD_n519 VGND 0.03124f
C2204 AVDD_t130 VGND 1.39304f
C2205 AVDD_n520 VGND 0.03652f
C2206 AVDD_t207 VGND 0.23651f
C2207 AVDD_t120 VGND 0.23651f
C2208 AVDD_t129 VGND 0.23303f
C2209 AVDD_n525 VGND 0.42433f
C2210 AVDD_t209 VGND 0.47303f
C2211 AVDD_n528 VGND 0.01745f
C2212 AVDD_n531 VGND 0.10072f
C2213 AVDD_n532 VGND 0.06468f
C2214 AVDD_t132 VGND 0.49303f
C2215 AVDD_n533 VGND 0.03476f
C2216 AVDD_n537 VGND 0.23651f
C2217 AVDD_n539 VGND 0.23651f
C2218 AVDD_n540 VGND 0.23651f
C2219 AVDD_t133 VGND 0.3026f
C2220 AVDD_n542 VGND 0.40694f
C2221 AVDD_n543 VGND 0.23651f
C2222 AVDD_n545 VGND 0.47303f
C2223 AVDD_n546 VGND 0.15004f
C2224 AVDD_t205 VGND 1.40864f
C2225 AVDD_n547 VGND 0.47303f
C2226 AVDD_n552 VGND 0.01382f
C2227 AVDD_n554 VGND 0.47303f
C2228 AVDD_n556 VGND 0.23651f
C2229 AVDD_n558 VGND 0.47303f
C2230 AVDD_n560 VGND 0.23651f
C2231 AVDD_t203 VGND 0.47303f
C2232 AVDD_n563 VGND 0.23651f
C2233 AVDD_n565 VGND 0.23651f
C2234 AVDD_t125 VGND 0.67823f
C2235 AVDD_n568 VGND 0.23651f
C2236 AVDD_n570 VGND 0.23651f
C2237 AVDD_t201 VGND 0.47303f
C2238 AVDD_n573 VGND 0.23651f
C2239 AVDD_n575 VGND 0.23651f
C2240 AVDD_n577 VGND 0.23651f
C2241 AVDD_n579 VGND 0.23651f
C2242 AVDD_n580 VGND 0.23651f
C2243 AVDD_n582 VGND 0.23651f
C2244 AVDD_n584 VGND 0.2538f
C2245 AVDD_t136 VGND 0.04319f
C2246 AVDD_n585 VGND 0.01927f
C2247 AVDD_n586 VGND 0.15595f
C2248 AVDD_n587 VGND 0.0476f
C2249 AVDD_n600 VGND 0.17594f
C2250 AVDD_n601 VGND 0.18398f
C2251 AVDD_n617 VGND 0.02036f
C2252 AVDD_n631 VGND 0.04505f
C2253 AVDD_n632 VGND 0.23651f
C2254 AVDD_n633 VGND 0.35477f
C2255 AVDD_t187 VGND 0.82779f
C2256 AVDD_t198 VGND 0.18434f
C2257 AVDD_n635 VGND 0.39998f
C2258 AVDD_n636 VGND 0.23651f
C2259 AVDD_n637 VGND 0.24347f
C2260 AVDD_t196 VGND 0.23651f
C2261 AVDD_n638 VGND 0.23651f
C2262 AVDD_t190 VGND 3.90717f
C2263 AVDD_n639 VGND 0.47303f
C2264 AVDD_t40 VGND 0.27129f
C2265 AVDD_n640 VGND 0.47303f
C2266 AVDD_n641 VGND 0.23651f
C2267 AVDD_n643 VGND 0.23651f
C2268 AVDD_t191 VGND 4.0388f
C2269 AVDD_t192 VGND 1.31071f
C2270 AVDD_t193 VGND 1.31071f
C2271 AVDD_t194 VGND 1.31071f
C2272 AVDD_t195 VGND 1.31071f
C2273 AVDD_t197 VGND 1.31071f
C2274 AVDD_t199 VGND 1.31071f
C2275 AVDD_t200 VGND 1.31782f
C2276 AVDD_n644 VGND 0.02697f
C2277 AVDD_n645 VGND 0.01931f
C2278 AVDD_n646 VGND 0.01932f
C2279 AVDD_n647 VGND 0.01931f
C2280 AVDD_n648 VGND 0.01932f
C2281 AVDD_n649 VGND 0.01931f
C2282 AVDD_n650 VGND 0.03731f
C2283 AVDD_n651 VGND 0.1356f
C2284 AVDD_n653 VGND 0.23651f
C2285 AVDD_n655 VGND 0.23651f
C2286 AVDD_t51 VGND 1.5895f
C2287 AVDD_n658 VGND 0.07485f
C2288 AVDD_n661 VGND 0.0479f
C2289 AVDD_t53 VGND 1.13819f
C2290 AVDD_n662 VGND 0.04515f
C2291 AVDD_n663 VGND 0.0264f
C2292 AVDD_n664 VGND 0.03972f
C2293 AVDD_n665 VGND 0.01172f
C2294 AVDD_n666 VGND 0.03525f
C2295 AVDD_n667 VGND 0.04162f
C2296 AVDD_n668 VGND 0.01673f
C2297 AVDD_t52 VGND 1.11906f
C2298 AVDD_n672 VGND 0.04229f
C2299 AVDD_n674 VGND 0.09321f
C2300 AVDD_t186 VGND 0.05423f
C2301 AVDD_t188 VGND 1.01058f
C2302 AVDD_t185 VGND 0.05395f
C2303 AVDD_n675 VGND 0.03304f
C2304 AVDD_n676 VGND 0.03121f
C2305 AVDD_n678 VGND 0.01358f
C2306 AVDD_n680 VGND 0.03469f
C2307 AVDD_n681 VGND 0.03268f
C2308 AVDD_n687 VGND 0.10072f
C2309 AVDD_n688 VGND 0.03431f
C2310 AVDD_n689 VGND 0.0333f
C2311 AVDD_n690 VGND 0.0231f
C2312 AVDD_n692 VGND 0.18398f
C2313 AVDD_n695 VGND 0.23651f
C2314 AVDD_n697 VGND 0.23651f
C2315 AVDD_n698 VGND 0.27626f
C2316 AVDD_n699 VGND 0.03288f
C2317 AVDD_n700 VGND 0.04578f
C2318 AVDD_n701 VGND 0.02445f
C2319 AVDD_n718 VGND 1.65559f
C2320 AVDD_n720 VGND 0.26498f
C2321 AVDD_n721 VGND 0.0244f
C2322 AVDD_n722 VGND 0.0472f
C2323 AVDD_t126 VGND 5.47608f
C2324 AVDD_t131 VGND 0.05658f
C2325 AVDD_n723 VGND 0.03713f
C2326 AVDD_n724 VGND 0.03814f
C2327 AVDD_n725 VGND 0.11429f
C2328 AVDD_n726 VGND 0.03842f
C2329 AVDD_n728 VGND 0.02222f
C2330 AVDD_n730 VGND 0.02455f
C2331 AVDD_n731 VGND 0.03113f
C2332 AVDD_n732 VGND 0.07183f
C2333 AVDD_n733 VGND 0.23651f
C2334 AVDD_n734 VGND 0.23651f
C2335 AVDD_n735 VGND 0.23651f
C2336 AVDD_n737 VGND 0.23651f
C2337 AVDD_n739 VGND 0.02787f
C2338 AVDD_n740 VGND 0.02809f
C2339 AVDD_n741 VGND 0.04154f
C2340 AVDD_n742 VGND 0.02897f
C2341 AVDD_n743 VGND 0.03089f
C2342 AVDD_t121 VGND 0.36177f
C2343 AVDD_n744 VGND 0.01786f
C2344 AVDD_n746 VGND 0.14279f
C2345 AVDD_n748 VGND 0.23651f
C2346 AVDD_n752 VGND 0.15999f
C2347 AVDD_t134 VGND 1.62873f
C2348 AVDD_n754 VGND 0.04144f
C2349 AVDD_n755 VGND 0.03371f
C2350 AVDD_n756 VGND 0.02879f
C2351 AVDD_n758 VGND 0.23651f
C2352 AVDD_n759 VGND 0.23651f
C2353 AVDD_n761 VGND 0.23651f
C2354 AVDD_n762 VGND 0.23651f
C2355 AVDD_t214 VGND 3.06771f
C2356 AVDD_n765 VGND 0.20759f
C2357 AVDD_t212 VGND 0.70954f
C2358 AVDD_n767 VGND 0.12081f
C2359 AVDD_t41 VGND 0.61563f
C2360 AVDD_n768 VGND 0.1497f
C2361 AVDD_n769 VGND 0.01327f
C2362 AVDD_n770 VGND 0.03277f
C2363 AVDD_n771 VGND 0.02952f
C2364 AVDD_n773 VGND 0.02554f
C2365 AVDD_n774 VGND 0.03636f
C2366 AVDD_n775 VGND 0.04602f
C2367 AVDD_n776 VGND 0.04115f
C2368 AVDD_t202 VGND 1.31074f
C2369 AVDD_t204 VGND 1.31072f
C2370 AVDD_t206 VGND 1.31071f
C2371 AVDD_t208 VGND 1.31071f
C2372 AVDD_t210 VGND 1.31071f
C2373 AVDD_t211 VGND 1.31071f
C2374 AVDD_t213 VGND 1.31071f
C2375 AVDD_t215 VGND 1.3178f
C2376 AVDD_n777 VGND 0.02697f
C2377 AVDD_n778 VGND 0.01931f
C2378 AVDD_n779 VGND 0.01931f
C2379 AVDD_n780 VGND 0.01932f
C2380 AVDD_n781 VGND 0.01931f
C2381 AVDD_n782 VGND 0.01931f
C2382 AVDD_n783 VGND 0.02228f
C2383 AVDD_n784 VGND 0.01466f
C2384 AVDD_n793 VGND 0.03326f
C2385 AVDD_n795 VGND 0.01656f
C2386 AVDD_n796 VGND 0.04132f
C2387 AVDD_n797 VGND 0.03398f
C2388 AVDD_n798 VGND 0.19563f
C2389 AVDD_n799 VGND 1.48168f
C2390 AVDD_n802 VGND 0.03198f
C2391 AVDD_n803 VGND 0.21195f
C2392 AVDD_n804 VGND 0.02656f
C2393 AVDD_n805 VGND 0.01486f
C2394 AVDD_t142 VGND 0.35195f
C2395 AVDD_n807 VGND 0.01963f
C2396 AVDD_n808 VGND 0.02163f
C2397 AVDD_t141 VGND 0.2837f
C2398 AVDD_n810 VGND 0.01235f
C2399 AVDD_n812 VGND 0.02103f
C2400 AVDD_n813 VGND 0.01507f
C2401 AVDD_t137 VGND 0.14959f
C2402 AVDD_t189 VGND 0.69654f
C2403 AVDD_n814 VGND 0.01206f
C2404 AVDD_t123 VGND 0.13465f
C2405 AVDD_t57 VGND 0.27909f
C2406 AVDD_t72 VGND 0.21867f
C2407 AVDD_n816 VGND 0.03626f
C2408 AVDD_n817 VGND 0.01323f
C2409 AVDD_n818 VGND 0.01248f
C2410 AVDD_n819 VGND 0.01273f
C2411 AVDD_n820 VGND 0.01193f
C2412 AVDD_n823 VGND 0.01087f
C2413 AVDD_n824 VGND 0.11936f
C2414 AVDD_t138 VGND 0.27475f
C2415 AVDD_n825 VGND 0.05547f
C2416 AVDD_t73 VGND 0.25835f
C2417 AVDD_n826 VGND 0.05772f
C2418 AVDD_t49 VGND 0.25391f
C2419 AVDD_n827 VGND 0.05772f
C2420 AVDD_t58 VGND 0.25613f
C2421 AVDD_n828 VGND 0.07062f
C2422 AVDD_n829 VGND 0.75965f
C2423 AVDD_n830 VGND 0.4539f
C2424 AVDD_n831 VGND 0.49772f
C2425 AVDD_n832 VGND 0.38804f
C2426 AVDD_n833 VGND 0.1655f
C2427 AVDD_n834 VGND 0.16645f
C2428 AVDD_n835 VGND 1.18504f
C2429 AVDD_n836 VGND 2.71216f
C2430 AVDD_n837 VGND 12.2107f
C2431 AVDD_n838 VGND 3.22664f
C2432 AVDD_n839 VGND 2.17151f
C2433 AVDD_n840 VGND 5.35929f
C2434 AVDD_n841 VGND 0.10343p
C2435 AVDD_n842 VGND 5.92925f
C2436 AVDD_n843 VGND 2.34044f
C2437 AVDD_n844 VGND 3.01776f
C2438 AVDD_n845 VGND 4.7309f
C2439 AVDD_n846 VGND 6.92859f
C2440 AVDD_n847 VGND 2.33816f
C2441 AVDD_n848 VGND 1.73932f
C2442 AVDD_n849 VGND 1.50385f
C2443 AVDD_n850 VGND 1.97772f
C2444 AVDD_n851 VGND 2.33258f
C2445 AVDD_n852 VGND 34.3533f
C2446 VPWR_n0 VGND 0.01044f
C2447 VPWR_n1 VGND 0.0331f
C2448 VPWR_n2 VGND 0.01983f
C2449 VPWR_n4 VGND 0.01261f
C2450 VPWR_n6 VGND 0.01295f
C2451 VPWR_t68 VGND 0.18813f
C2452 VPWR_n8 VGND 0.02183f
C2453 VPWR_t75 VGND 0.28619f
C2454 VPWR_n9 VGND 0.01518f
C2455 VPWR_n11 VGND 0.01413f
C2456 VPWR_n12 VGND 0.0331f
C2457 VPWR_n13 VGND 0.01983f
C2458 VPWR_n18 VGND 0.01146f
C2459 VPWR_n20 VGND 0.01295f
C2460 VPWR_n22 VGND 0.0331f
C2461 VPWR_n23 VGND 0.01983f
C2462 VPWR_n25 VGND 0.01261f
C2463 VPWR_t84 VGND 0.17457f
C2464 VPWR_n27 VGND 0.01829f
C2465 VPWR_n29 VGND 0.0185f
C2466 VPWR_n31 VGND 0.0331f
C2467 VPWR_n32 VGND 0.01983f
C2468 VPWR_n34 VGND 0.01293f
C2469 VPWR_n36 VGND 0.01295f
C2470 VPWR_n38 VGND 0.01261f
C2471 VPWR_n39 VGND 0.0331f
C2472 VPWR_n40 VGND 0.01983f
C2473 VPWR_t69 VGND 0.39722f
C2474 VPWR_n44 VGND 0.01608f
C2475 VPWR_t33 VGND 0.28383f
C2476 VPWR_n46 VGND 0.01461f
C2477 VPWR_n48 VGND 0.01984f
C2478 VPWR_n49 VGND 0.01681f
C2479 VPWR_n50 VGND 0.01382f
C2480 VPWR_n52 VGND 0.01682f
C2481 VPWR_n53 VGND 0.01534f
C2482 VPWR_n55 VGND 0.01534f
C2483 VPWR_n57 VGND 0.01383f
C2484 VPWR_t76 VGND 0.1791f
C2485 VPWR_n59 VGND 0.01309f
C2486 VPWR_t115 VGND 0.19118f
C2487 VPWR_n61 VGND 0.01608f
C2488 VPWR_t72 VGND 0.41525f
C2489 VPWR_n63 VGND 0.01503f
C2490 VPWR_t45 VGND 0.51778f
C2491 VPWR_n65 VGND 0.01503f
C2492 VPWR_t134 VGND 0.55277f
C2493 VPWR_n67 VGND 0.01503f
C2494 VPWR_t32 VGND 0.61065f
C2495 VPWR_n69 VGND 0.01503f
C2496 VPWR_t124 VGND 0.25953f
C2497 VPWR_n71 VGND 0.01503f
C2498 VPWR_t74 VGND 0.25214f
C2499 VPWR_n73 VGND 0.01503f
C2500 VPWR_t38 VGND 0.25282f
C2501 VPWR_n75 VGND 0.01636f
C2502 VPWR_t93 VGND 0.43707f
C2503 VPWR_n76 VGND 0.02283f
C2504 VPWR_n77 VGND 0.17585f
C2505 VPWR_t5 VGND 2.69025f
C2506 VPWR_n78 VGND 0.15491f
C2507 VPWR_n80 VGND 0.01057f
C2508 VPWR_n81 VGND 0.01044f
C2509 VPWR_n86 VGND 0.01068f
C2510 VPWR_n91 VGND 0.01035f
C2511 VPWR_n94 VGND 0.01285f
C2512 VPWR_n95 VGND 0.03309f
C2513 VPWR_n96 VGND 0.01774f
C2514 VPWR_n99 VGND 0.01111f
C2515 VPWR_n101 VGND 0.01068f
C2516 VPWR_n102 VGND 0.03079f
C2517 VPWR_n103 VGND 0.01363f
C2518 VPWR_n106 VGND 0.0308f
C2519 VPWR_n107 VGND 0.01147f
C2520 VPWR_n112 VGND 0.0308f
C2521 VPWR_n113 VGND 0.01147f
C2522 VPWR_n114 VGND 0.03079f
C2523 VPWR_n115 VGND 0.01363f
C2524 VPWR_n117 VGND 0.01111f
C2525 VPWR_n121 VGND 0.01146f
C2526 VPWR_n123 VGND 0.01117f
C2527 VPWR_n127 VGND 0.0331f
C2528 VPWR_n128 VGND 0.0156f
C2529 VPWR_t52 VGND 0.22137f
C2530 VPWR_t29 VGND 2.48343f
C2531 VPWR_n133 VGND 0.0331f
C2532 VPWR_n134 VGND 0.0156f
C2533 VPWR_n138 VGND 0.01141f
C2534 VPWR_t53 VGND 0.38536f
C2535 VPWR_n140 VGND 0.01984f
C2536 VPWR_n141 VGND 0.01424f
C2537 VPWR_t146 VGND 0.14922f
C2538 VPWR_n144 VGND 0.01033f
C2539 VPWR_t123 VGND 0.27047f
C2540 VPWR_n146 VGND 0.01069f
C2541 VPWR_t60 VGND 0.01094f
C2542 VPWR_t82 VGND 0.16714f
C2543 VPWR_n150 VGND 0.01141f
C2544 VPWR_t42 VGND 0.57842f
C2545 VPWR_n157 VGND 0.01117f
C2546 VPWR_t65 VGND 0.12293f
C2547 VPWR_n161 VGND 0.17579f
C2548 VPWR_t104 VGND 0.01094f
C2549 VPWR_t66 VGND 0.15531f
C2550 VPWR_t31 VGND 0.09865f
C2551 VPWR_t142 VGND 0.17958f
C2552 VPWR_t50 VGND 0.48711f
C2553 VPWR_t92 VGND 0.06391f
C2554 VPWR_t141 VGND 0.2179f
C2555 VPWR_t34 VGND 0.29272f
C2556 VPWR_t59 VGND 0.09369f
C2557 VPWR_t39 VGND 0.38648f
C2558 VPWR_t64 VGND 0.77365f
C2559 VPWR_t67 VGND 0.49781f
C2560 VPWR_t133 VGND 0.09502f
C2561 VPWR_t43 VGND 0.09974f
C2562 VPWR_t110 VGND 0.10486f
C2563 VPWR_t122 VGND 0.21723f
C2564 VPWR_t112 VGND 0.11887f
C2565 VPWR_t111 VGND 0.16334f
C2566 VPWR_n162 VGND 0.01519f
C2567 VPWR_n169 VGND 0.01054f
C2568 VPWR_n175 VGND 0.01148f
C2569 VPWR_n179 VGND 0.01049f
C2570 VPWR_n181 VGND 0.01861f
C2571 VPWR_n183 VGND 0.01712f
C2572 VPWR_n185 VGND 0.013f
C2573 VPWR_n189 VGND 0.01148f
C2574 VPWR_n191 VGND 0.01148f
C2575 VPWR_n195 VGND 0.01148f
C2576 VPWR_n203 VGND 0.01148f
C2577 VPWR_n205 VGND 0.01066f
C2578 VPWR_n209 VGND 0.01195f
C2579 VPWR_n213 VGND 0.01232f
C2580 VPWR_n219 VGND 0.01019f
C2581 VPWR_n221 VGND 0.01364f
C2582 VPWR_n227 VGND 0.01984f
C2583 VPWR_n228 VGND 0.0188f
C2584 VPWR_n230 VGND 0.05956f
C2585 VPWR_t0 VGND 2.03007f
C2586 VPWR_n232 VGND 0.09529f
C2587 VPWR_n235 VGND 3.36025f
C2588 pn200_t0 VGND 0.11238f
C2589 pn200_n0 VGND 0.03147f
C2590 pn200_n1 VGND 0.24475f
C2591 pn200_n2 VGND 4.64326f
C2592 pn200_n3 VGND 2.26503f
C2593 pn53_n0 VGND 0.78714f
C2594 pn53_n1 VGND 13.3012f
C2595 pn53_t0 VGND 0.16181f
C2596 pn53_n2 VGND 6.22516f
C2597 pn54_t0 VGND 0.10244f
C2598 pn54_n0 VGND 2.99415f
C2599 pn54_n1 VGND 20.5486f
C2600 pn54_n2 VGND 8.44143f
C2601 pn15_t0 VGND 0.10161f
C2602 pn15_n0 VGND 4.67208f
C2603 pn15_n1 VGND 20.1571f
C2604 pn15_n2 VGND 8.44332f
C2605 pn55_t0 VGND 0.05991f
C2606 pn55_n0 VGND 0.41606f
C2607 pn55_n1 VGND 3.00378f
C2608 pn55_n2 VGND 12.4172f
C2609 pn55_n3 VGND 4.96365f
C2610 pn92_t0 VGND 0.24226f
C2611 pn92_t1 VGND 0.09841f
C2612 pn92_n0 VGND 0.51885f
C2613 pn92_n1 VGND 0.16072f
C2614 pn91_t0 VGND 0.21195f
C2615 pn91_n0 VGND 0.63308f
C2616 pn93_t0 VGND 0.25684f
C2617 pn93_n0 VGND 0.3192f
C2618 pn168_t1 VGND 0.07427f
C2619 pn168_t0 VGND 0.12614f
C2620 pn168_n0 VGND 1.60326f
C2621 pn168_n1 VGND 2.06242f
C2622 pn83_t11 VGND 0.02366f
C2623 pn83_n0 VGND 6.8435f
C2624 pn83_t9 VGND 0.15528f
C2625 pn83_n1 VGND 10.7272f
C2626 pn83_t8 VGND 0.15528f
C2627 pn83_n2 VGND 0.67485f
C2628 pn83_t7 VGND 0.15528f
C2629 pn83_n3 VGND 0.72694f
C2630 pn83_t4 VGND 0.14209f
C2631 pn83_n4 VGND 0.61373f
C2632 pn83_t3 VGND 0.14209f
C2633 pn83_n5 VGND 0.56164f
C2634 pn83_t2 VGND 0.14209f
C2635 pn83_n6 VGND 0.7179f
C2636 pn83_t6 VGND 0.15528f
C2637 pn83_n7 VGND 0.62277f
C2638 pn83_t5 VGND 0.15528f
C2639 pn83_n8 VGND 0.62277f
C2640 pn83_t1 VGND 0.14209f
C2641 pn83_n9 VGND 0.7179f
C2642 pn83_t0 VGND 0.14209f
C2643 pn83_n10 VGND 1.06559f
C2644 pn228_t7 VGND 0.60064f
C2645 pn228_t8 VGND 0.54869f
C2646 pn228_t4 VGND 0.54871f
C2647 pn228_t5 VGND 4.66955f
C2648 pn228_t6 VGND 0.71948f
C2649 pn228_n0 VGND 0.49077f
C2650 pn228_n1 VGND 0.32889f
C2651 pn228_n2 VGND 0.22328f
C2652 pn228_t2 VGND 0.0261f
C2653 pn228_n3 VGND 0.16573f
C2654 pn228_t1 VGND 0.0261f
C2655 pn228_n4 VGND 0.17483f
C2656 pn228_t3 VGND 0.0261f
C2657 pn228_n5 VGND 0.17483f
C2658 pn228_t0 VGND 0.0261f
C2659 pn228_n6 VGND 0.20053f
C2660 pn228_n7 VGND 0.41979f
C2661 VOUT_t9 VGND 0.15308f
C2662 VOUT_t8 VGND 2.98536f
C2663 VOUT_t2 VGND 0.30863f
C2664 VOUT_n6 VGND 0.17538f
C2665 VOUT_n7 VGND 0.65112f
C2666 VOUT_n8 VGND 4.46342f
C2667 VOUT_n9 VGND 6.77423f
C2668 pn174_t0 VGND 3.20988f
C2669 pn89_t1 VGND 0.40634f
C2670 pn89_t0 VGND 4.18277f
C2671 pn89_n0 VGND 2.08769f
C2672 pn87_t2 VGND 0.21837f
C2673 pn87_t1 VGND 1.15377f
C2674 pn87_n0 VGND 0.75984f
C2675 pn87_t0 VGND 0.98726f
C2676 pn87_n1 VGND 10.0902f
C2677 pn87_n2 VGND 1.85019f
C2678 pn88_t0 VGND 2.74039f
C2679 pn88_t1 VGND 3.1174f
C2680 pn88_n0 VGND 1.03382f
C2681 pn88_t2 VGND 0.36352f
C2682 pn88_n1 VGND 0.97037f
C2683 pn172_t1 VGND 0.03864f
C2684 pn172_t0 VGND 0.37615f
C2685 pn172_n0 VGND 0.09991f
C2686 pn172_t2 VGND 1.75712f
C2687 pn172_n1 VGND 1.28899f
C2688 pn162_t0 VGND 10.79657f
C2689 pn162_t3 VGND 0.06571f
C2690 pn162_t2 VGND 3.40015f
C2691 pn162_n0 VGND 0.06148f
C2692 pn162_n1 VGND 0.04376f
C2693 pn162_n2 VGND 0.07187f
C2694 pn162_n6 VGND 0.01418f
C2695 pn229_t1 VGND 4.21723f
C2696 pn229_t2 VGND 0.12484f
C2697 pn229_n0 VGND 0.39682f
C2698 pn229_t0 VGND 1.03145f
C2699 pn229_n1 VGND 0.17815f
C2700 pn229_n2 VGND 0.08757f
C2701 pn90_t2 VGND 0.40541f
C2702 pn90_t1 VGND 3.19017f
C2703 pn90_t0 VGND 0.45525f
C2704 pn90_n0 VGND 5.25886f
C2705 pn90_n1 VGND 0.15924f
C2706 pn170_t2 VGND 0.39515f
C2707 pn170_t0 VGND 0.02476f
C2708 pn170_n0 VGND 0.16223f
C2709 pn170_t1 VGND 0.91963f
C2710 pn170_n1 VGND 0.26173f
C2711 pn171_t1 VGND 0.42509f
C2712 pn171_t2 VGND 0.03772f
C2713 pn171_n0 VGND 0.15778f
C2714 pn171_t0 VGND 1.76748f
C2715 pn171_n1 VGND 0.24578f
C2716 pn169_t1 VGND 0.11224f
C2717 pn169_t0 VGND 0.0407f
C2718 pn169_n0 VGND 0.56383f
C2719 pn161_n0 VGND 0.09038f
C2720 pn161_n1 VGND 0.03601f
C2721 pn161_n2 VGND 0.03626f
C2722 pn161_n3 VGND 0.03603f
C2723 pn161_n4 VGND 0.02629f
C2724 pn161_n5 VGND 0.01971f
C2725 pn161_n6 VGND 0.02619f
C2726 pn161_n7 VGND 0.03654f
C2727 pn161_n8 VGND 0.03653f
C2728 pn161_n9 VGND 0.03626f
C2729 pn161_n10 VGND 1.81873f
C2730 pn161_t1 VGND 0.03074f
C2731 pn161_t4 VGND 0.39761f
C2732 pn161_n11 VGND 0.50651f
C2733 pn161_t0 VGND 0.04722f
C2734 pn161_t10 VGND 0.36718f
C2735 pn161_n12 VGND 0.49322f
C2736 pn161_n13 VGND 1.35586f
C2737 pn161_t6 VGND 0.0415f
C2738 pn161_t5 VGND 0.38007f
C2739 pn161_n14 VGND 0.49322f
C2740 pn161_n15 VGND 1.55307f
C2741 pn161_t11 VGND 0.03573f
C2742 pn161_t7 VGND 0.41804f
C2743 pn161_n16 VGND 0.50845f
C2744 pn161_n17 VGND 1.76757f
C2745 pn161_t2 VGND 0.02271f
C2746 pn161_t8 VGND 0.38267f
C2747 pn161_n18 VGND 0.52876f
C2748 pn161_n19 VGND 1.40823f
C2749 pn161_t3 VGND 1.38492f
C2750 pn161_t9 VGND 0.3911f
C2751 pn161_n20 VGND 0.34698f
C2752 pn161_n21 VGND 0.99962f
C2753 pn161_n22 VGND 1.46551f
C2754 pn166_t1 VGND 0.05884f
C2755 pn166_t0 VGND 0.07159f
C2756 pn166_n0 VGND 0.51533f
C2757 pn167_t1 VGND 0.05178f
C2758 pn167_t0 VGND 0.12522f
C2759 pn167_n0 VGND 0.4851f
C2760 pn163_t1 VGND 0.06331f
C2761 pn163_t0 VGND 0.15835f
C2762 pn163_n0 VGND 0.59284f
C2763 pn164_t0 VGND 0.05753f
C2764 pn164_t1 VGND 0.14753f
C2765 pn164_n0 VGND 0.53867f
C2766 pn165_t1 VGND 0.04866f
C2767 pn165_t0 VGND 0.10008f
C2768 pn165_n0 VGND 0.4556f
C2769 pn227_t11 VGND 1.71805f
C2770 pn227_t3 VGND 1.71807f
C2771 pn227_t9 VGND 1.71806f
C2772 pn227_t7 VGND 1.71805f
C2773 pn227_t1 VGND 1.71807f
C2774 pn227_t13 VGND 1.71806f
C2775 pn227_t5 VGND 1.76706f
C2776 pn227_n0 VGND 0.18577f
C2777 pn227_n1 VGND 0.13314f
C2778 pn227_n2 VGND 0.13315f
C2779 pn227_n3 VGND 0.13315f
C2780 pn227_n4 VGND 0.13313f
C2781 pn227_n5 VGND 0.17311f
C2782 pn227_t15 VGND 4.3207f
C2783 pn227_n6 VGND 2.34283f
C2784 pn227_n7 VGND 0.27321f
C2785 pn227_n8 VGND 0.16691f
C2786 pn227_n9 VGND 0.16691f
C2787 pn227_n10 VGND 0.16691f
C2788 pn227_n11 VGND 0.16691f
C2789 pn227_n12 VGND 0.16511f
C2790 pn227_n13 VGND 0.89419f
C2791 pn227_n14 VGND 0.89409f
C2792 pn227_n15 VGND 0.16498f
C2793 pn227_n16 VGND 0.16691f
C2794 pn227_n17 VGND 0.16691f
C2795 pn227_n18 VGND 0.16691f
C2796 pn227_n19 VGND 0.16691f
C2797 pn227_n20 VGND 0.14941f
C2798 pn227_n21 VGND 0.07484f
C2799 pn227_n22 VGND 0.09408f
C2800 pn227_n23 VGND 0.1415f
C2801 pn221_t9 VGND 0.87108f
C2802 pn221_t3 VGND 4.26112f
C2803 pn221_t2 VGND 0.86822f
C2804 pn221_t4 VGND 0.86822f
C2805 pn221_n0 VGND 0.44617f
C2806 pn221_n1 VGND 0.48192f
C2807 pn221_t5 VGND 2.08589f
C2808 pn221_t11 VGND 2.0859f
C2809 pn221_t1 VGND 2.08593f
C2810 pn221_t7 VGND 2.0859f
C2811 pn221_t8 VGND 2.08589f
C2812 pn221_t6 VGND 2.08591f
C2813 pn221_t12 VGND 2.19014f
C2814 pn221_n2 VGND 0.32921f
C2815 pn221_n3 VGND 0.23598f
C2816 pn221_n4 VGND 0.23598f
C2817 pn221_n5 VGND 0.23595f
C2818 pn221_n6 VGND 0.23598f
C2819 pn221_n7 VGND 0.22114f
C2820 pn221_t0 VGND 2.09461f
C2821 pn221_n8 VGND 0.87436f
C2822 pn221_n9 VGND 3.0861f
C2823 pn221_t10 VGND 3.41431f
C2824 pn221_n10 VGND 0.93654f
C2825 pn160_n0 VGND 0.04842f
C2826 pn160_n1 VGND 0.11673f
C2827 pn160_n2 VGND 1.88358f
C2828 pn160_t0 VGND 1.07734f
C2829 pn160_t2 VGND 0.61183f
C2830 pn160_n3 VGND 0.69271f
C2831 pn160_n4 VGND 2.39188f
C2832 pn160_n5 VGND 1.10748f
C2833 pn160_n6 VGND 0.3016f
C2834 pn160_n7 VGND 0.02598f
C2835 pn160_n8 VGND 0.04903f
C2836 pn225_t1 VGND 0.1291f
C2837 pn225_n0 VGND 0.80127f
C2838 pn225_n1 VGND 6.26948f
C2839 pn153_t1 VGND 5.40507f
C2840 pn153_n0 VGND 1.46662f
C2841 pn153_t0 VGND 3.15425f
C2842 pn153_n1 VGND 2.41716f
C2843 pn153_n2 VGND 0.10105f
C2844 pn120_t3 VGND 0.13781f
C2845 pn120_t2 VGND 1.08102f
C2846 pn120_n0 VGND 0.47952f
C2847 pn120_t1 VGND 0.48303f
C2848 pn120_n1 VGND 1.16819f
C2849 pn120_t0 VGND 2.05587f
C2850 pn120_n2 VGND 6.17387f
C2851 pn226_t1 VGND 4.10373f
C2852 pn226_t0 VGND 2.04975f
C2853 pn226_t2 VGND 1.09518f
C2854 pn226_n0 VGND 2.00173f
C2855 pn226_n1 VGND 2.6177f
C2856 pn224_t3 VGND 1.50911f
C2857 pn224_t2 VGND 0.36791f
C2858 pn224_n0 VGND 1.29265f
C2859 pn224_t0 VGND 0.72727f
C2860 pn224_n1 VGND 0.71769f
C2861 pn224_t1 VGND 2.73022f
C2862 pn224_n2 VGND 1.60199f
C2863 pn224_t4 VGND 1.01976f
C2864 pn224_n3 VGND 0.98568f
C2865 pn224_n4 VGND 2.15674f
C2866 pn158_t0 VGND 0.8565f
C2867 pn158_n0 VGND 5.22615f
C2868 pn158_t1 VGND 1.26009f
C2869 pn158_n1 VGND 0.32342f
C2870 pn86_t1 VGND 1.88444f
C2871 pn86_t0 VGND 0.45923f
C2872 pn86_n0 VGND 0.39724f
C2873 pn86_n1 VGND 3.14406f
C2874 pn154_n0 VGND 0.56196f
C2875 pn154_t1 VGND 4.51574f
C2876 pn154_t0 VGND 0.20586f
C2877 pn154_n1 VGND 0.7649f
C2878 pn154_n2 VGND 0.61048f
C2879 pn154_t2 VGND 6.20317f
C2880 pn154_n3 VGND 0.10957f
C2881 pn222_t2 VGND 1.2112f
C2882 pn222_t1 VGND 0.59659f
C2883 pn222_n0 VGND 0.75991f
C2884 pn222_n1 VGND 0.31707f
C2885 VCM_t1 VGND 0.50754f
C2886 VCM_t2 VGND 0.18304f
C2887 VCM_n0 VGND 0.10056f
C2888 VCM_t0 VGND 1.2064f
C2889 VCM_n1 VGND 5.43696f
C2890 VCM_n2 VGND 0.06608f
C2891 VCM_n3 VGND 0.02732f
C2892 VCM_n4 VGND 0.09672f
C2893 VCM_n5 VGND 0.02772f
C2894 VCM_n6 VGND 0.02715f
C2895 VCM_n7 VGND 2.39024f
C2896 VCM_n8 VGND 8.97593f
C2897 VCM_n9 VGND 0.06608f
C2898 VCM_n10 VGND 0.02732f
C2899 VCM_n11 VGND 0.09672f
C2900 VCM_n12 VGND 0.02772f
C2901 VCM_n13 VGND 0.02715f
C2902 VCM_n14 VGND 2.71823f
C2903 VCM_n15 VGND 8.34745f
C2904 pn223_t2 VGND 0.59428f
C2905 pn223_t1 VGND 0.92492f
C2906 pn223_t0 VGND 1.09693f
C2907 pn223_n0 VGND 1.61415f
C2908 pn223_n1 VGND 4.81256f
C2909 pn159_t0 VGND 2.08487f
C2910 pn159_t2 VGND 1.56121f
C2911 pn159_n0 VGND 1.22799f
C2912 pn159_n1 VGND 0.69608f
C2913 pn156_t9 VGND 8.73286f
C2914 pn156_n0 VGND 0.08144f
C2915 pn156_n1 VGND 0.04485f
C2916 pn156_n2 VGND 0.01105f
C2917 pn156_n3 VGND 0.30771f
C2918 pn156_n4 VGND 0.02886f
C2919 pn156_n5 VGND 0.01074f
C2920 pn156_n6 VGND 0.34653f
C2921 pn156_t3 VGND 0.14091f
C2922 pn156_t1 VGND 0.11349f
C2923 pn156_n7 VGND 0.29078f
C2924 pn156_t5 VGND 0.12792f
C2925 pn156_n8 VGND 0.16284f
C2926 pn156_t0 VGND 0.11349f
C2927 pn156_n9 VGND 0.15686f
C2928 pn156_t2 VGND 0.12792f
C2929 pn156_n10 VGND 0.16284f
C2930 pn156_t6 VGND 8.71599f
C2931 pn156_n11 VGND 0.15686f
C2932 pn156_t4 VGND 0.12792f
C2933 pn156_n12 VGND 0.16284f
C2934 pn156_t7 VGND 0.11349f
C2935 pn156_n13 VGND 0.15686f
C2936 pn156_t8 VGND 0.12792f
C2937 pn156_n14 VGND 3.30524f
C2938 pn156_n15 VGND 2.85717f
C2939 pn156_n16 VGND 0.05405f
C2940 pn157_t1 VGND 0.11779f
C2941 pn157_t0 VGND 0.52381f
C2942 pn157_n0 VGND 0.11377f
C2943 pn85_t0 VGND 1.3088f
C2944 pn84_t18 VGND 3.31376f
C2945 pn84_t17 VGND 0.14654f
C2946 pn84_n0 VGND 1.44661f
C2947 pn84_t14 VGND 0.1121f
C2948 pn84_n1 VGND 0.70773f
C2949 pn84_t13 VGND 0.1121f
C2950 pn84_n2 VGND 0.7984f
C2951 pn84_t16 VGND 0.14654f
C2952 pn84_n3 VGND 0.82199f
C2953 pn84_t15 VGND 0.14654f
C2954 pn84_n4 VGND 0.73132f
C2955 pn84_t12 VGND 0.1121f
C2956 pn84_n5 VGND 0.61707f
C2957 pn84_t7 VGND 0.2717f
C2958 pn84_t8 VGND 0.21517f
C2959 pn84_n6 VGND 0.59812f
C2960 pn84_t1 VGND 0.24253f
C2961 pn84_n7 VGND 0.30873f
C2962 pn84_t5 VGND 0.21517f
C2963 pn84_n8 VGND 0.2974f
C2964 pn84_t11 VGND 0.24253f
C2965 pn84_n9 VGND 0.30873f
C2966 pn84_t9 VGND 0.21517f
C2967 pn84_n10 VGND 0.2974f
C2968 pn84_t4 VGND 0.24253f
C2969 pn84_n11 VGND 0.30873f
C2970 pn84_t3 VGND 0.21517f
C2971 pn84_n12 VGND 0.2974f
C2972 pn84_t6 VGND 0.24253f
C2973 pn84_n13 VGND 0.30873f
C2974 pn84_t10 VGND 0.21517f
C2975 pn84_n14 VGND 0.25962f
C2976 pn84_n15 VGND 0.25136f
C2977 pn84_n16 VGND 2.47842f
C2978 pn84_n17 VGND 2.68922f
C2979 pn220_n0 VGND 0.0213f
C2980 pn220_n2 VGND 0.36416f
C2981 pn220_t9 VGND 0.37899f
C2982 pn220_n3 VGND 0.08558f
C2983 pn220_n4 VGND 0.01129f
C2984 pn220_n5 VGND 0.0568f
C2985 pn220_n6 VGND 3.49057f
C2986 pn220_t0 VGND 0.12692f
C2987 pn220_n7 VGND 3.59449f
C2988 pn220_t7 VGND 0.12692f
C2989 pn220_n8 VGND 0.16792f
C2990 pn220_t2 VGND 0.12692f
C2991 pn220_n9 VGND 0.16792f
C2992 pn220_t4 VGND 0.12692f
C2993 pn220_n10 VGND 0.16792f
C2994 pn220_t1 VGND 0.12692f
C2995 pn220_n11 VGND 0.16792f
C2996 pn220_t5 VGND 8.66007f
C2997 pn220_n12 VGND 0.16792f
C2998 pn220_t3 VGND 0.12692f
C2999 pn220_n13 VGND 0.16792f
C3000 pn220_t6 VGND 0.12692f
C3001 pn220_n14 VGND 0.28473f
C3002 pn220_n15 VGND 0.05129f
C3003 pn82_t37 VGND 0.01657f
C3004 pn82_n0 VGND 0.31171f
C3005 pn82_t33 VGND 0.22863f
C3006 pn82_n1 VGND 0.46972f
C3007 pn82_t35 VGND 0.01657f
C3008 pn82_n2 VGND 0.40033f
C3009 pn82_n3 VGND 4.47239f
C3010 pn82_n4 VGND 14.9372f
C3011 pn82_t15 VGND 0.10877f
C3012 pn82_n5 VGND 9.60317f
C3013 pn82_t14 VGND 0.10877f
C3014 pn82_n6 VGND 0.18083f
C3015 pn82_t13 VGND 0.10877f
C3016 pn82_n7 VGND 0.18083f
C3017 pn82_t12 VGND 0.10877f
C3018 pn82_n8 VGND 0.18083f
C3019 pn82_t11 VGND 0.10877f
C3020 pn82_n9 VGND 0.18083f
C3021 pn82_t10 VGND 0.10877f
C3022 pn82_n10 VGND 0.18083f
C3023 pn82_t9 VGND 0.10877f
C3024 pn82_n11 VGND 0.18083f
C3025 pn82_t8 VGND 0.10877f
C3026 pn82_n12 VGND 0.18083f
C3027 pn82_t7 VGND 0.10877f
C3028 pn82_n13 VGND 0.14435f
C3029 pn82_t31 VGND 0.09953f
C3030 pn82_n14 VGND 0.13802f
C3031 pn82_t30 VGND 0.09953f
C3032 pn82_n15 VGND 0.17451f
C3033 pn82_t29 VGND 0.09953f
C3034 pn82_n16 VGND 0.17451f
C3035 pn82_t28 VGND 0.09953f
C3036 pn82_n17 VGND 0.17451f
C3037 pn82_t27 VGND 0.09953f
C3038 pn82_n18 VGND 0.17451f
C3039 pn82_t26 VGND 0.09953f
C3040 pn82_n19 VGND 0.17451f
C3041 pn82_t25 VGND 0.09953f
C3042 pn82_n20 VGND 0.17451f
C3043 pn82_t24 VGND 0.09953f
C3044 pn82_n21 VGND 0.13802f
C3045 pn82_t6 VGND 0.10877f
C3046 pn82_n22 VGND 0.14435f
C3047 pn82_t5 VGND 0.10877f
C3048 pn82_n23 VGND 0.18083f
C3049 pn82_t4 VGND 0.10877f
C3050 pn82_n24 VGND 0.18083f
C3051 pn82_t3 VGND 0.10877f
C3052 pn82_n25 VGND 0.18083f
C3053 pn82_t2 VGND 0.10877f
C3054 pn82_n26 VGND 0.18083f
C3055 pn82_t1 VGND 0.10877f
C3056 pn82_n27 VGND 0.18083f
C3057 pn82_t0 VGND 0.10877f
C3058 pn82_n28 VGND 0.14435f
C3059 pn82_t23 VGND 0.09953f
C3060 pn82_n29 VGND 0.13802f
C3061 pn82_t22 VGND 0.09953f
C3062 pn82_n30 VGND 0.17451f
C3063 pn82_t21 VGND 0.09953f
C3064 pn82_n31 VGND 0.17451f
C3065 pn82_t20 VGND 0.09953f
C3066 pn82_n32 VGND 0.17451f
C3067 pn82_t19 VGND 0.09953f
C3068 pn82_n33 VGND 0.17451f
C3069 pn82_t18 VGND 0.09953f
C3070 pn82_n34 VGND 0.17451f
C3071 pn82_t17 VGND 0.09953f
C3072 pn82_n35 VGND 0.17451f
C3073 pn82_t16 VGND 0.09953f
C3074 pn82_n36 VGND 0.27668f
C3075 pn150_t8 VGND 1.15919f
C3076 pn150_t10 VGND 0.11642f
C3077 pn150_n6 VGND 0.15054f
C3078 pn150_n7 VGND 0.55888f
C3079 pn150_t9 VGND 9.86452f
C3080 pn150_n8 VGND 3.83636f
C3081 pn150_n9 VGND 6.63178f
C3082 pn219_t4 VGND 6.05424f
C3083 pn219_t5 VGND 0.55059f
C3084 pn219_t6 VGND 0.55059f
C3085 pn219_t7 VGND 0.60269f
C3086 pn219_t8 VGND 8.41411f
C3087 pn219_n0 VGND 0.42112f
C3088 pn219_t3 VGND 0.02619f
C3089 pn219_n1 VGND 0.20121f
C3090 pn219_t1 VGND 0.02619f
C3091 pn219_n2 VGND 0.17543f
C3092 pn219_t2 VGND 0.23825f
C3093 pn219_n3 VGND 0.17543f
C3094 pn219_t0 VGND 0.02619f
C3095 pn219_n4 VGND 0.1663f
C3096 pn219_n5 VGND 0.22401f
C3097 pn219_n6 VGND 0.33001f
C3098 pn219_n7 VGND 0.49251f
C3099 VINN_t0 VGND 0.31642f
C3100 VINN_n0 VGND 3.00634f
C3101 pn151_t0 VGND 0.61942f
C3102 pn148_t1 VGND 0.16356f
C3103 pn148_t2 VGND 5.59987f
C3104 pn148_n0 VGND 0.08755f
C3105 pn148_t3 VGND 10.90831f
C3106 pn148_n1 VGND 0.17816f
C3107 pn148_t0 VGND 0.12484f
C3108 pn148_n2 VGND 0.39681f
C3109 pn149_n0 VGND 0.01932f
C3110 pn149_t3 VGND 0.89811f
C3111 pn149_t0 VGND 7.75221f
C3112 pn149_t1 VGND 0.06625f
C3113 pn149_n1 VGND 0.06199f
C3114 pn149_n2 VGND 0.04807f
C3115 pn149_n3 VGND 0.08392f
C3116 pn149_n4 VGND 0.0689f
C3117 IBIAS_IA_t11 VGND 0.04764f
C3118 IBIAS_IA_t10 VGND 0.02698f
C3119 IBIAS_IA_n0 VGND 0.25816f
C3120 IBIAS_IA_t9 VGND 0.02698f
C3121 IBIAS_IA_n1 VGND 0.1485f
C3122 IBIAS_IA_t5 VGND 0.03527f
C3123 IBIAS_IA_n2 VGND 0.15418f
C3124 IBIAS_IA_t4 VGND 0.03527f
C3125 IBIAS_IA_n3 VGND 0.13236f
C3126 IBIAS_IA_t8 VGND 0.02698f
C3127 IBIAS_IA_n4 VGND 0.12668f
C3128 IBIAS_IA_t7 VGND 0.02698f
C3129 IBIAS_IA_n5 VGND 0.1485f
C3130 IBIAS_IA_t3 VGND 0.03527f
C3131 IBIAS_IA_n6 VGND 0.15418f
C3132 IBIAS_IA_t2 VGND 0.03527f
C3133 IBIAS_IA_n7 VGND 0.14327f
C3134 IBIAS_IA_t1 VGND 0.03527f
C3135 IBIAS_IA_n8 VGND 0.13418f
C3136 IBIAS_IA_n9 VGND 0.051f
C3137 IBIAS_IA_n10 VGND 2.04241f
C3138 pn143_t0 VGND 0.21773f
C3139 pn143_n0 VGND 6.86001f
C3140 pn67_t0 VGND 0.28353f
C3141 pn67_n0 VGND 0.24146f
C3142 pn68_t0 VGND 0.39254f
C3143 pn68_n0 VGND 0.26639f
C3144 pn50_t0 VGND 0.24949f
C3145 pn50_n0 VGND 0.741f
C3146 pn50_n1 VGND 0.57401f
C3147 pn50_n2 VGND 1.13346f
C3148 pn50_n3 VGND 1.44504f
C3149 pn50_n4 VGND 0.43497f
C3150 pn50_n5 VGND 0.63865f
C3151 pn50_n6 VGND 2.64122f
C3152 pn50_n7 VGND 0.64092f
C3153 pn51_t0 VGND 0.25302f
C3154 pn51_n0 VGND 0.57764f
C3155 pn51_n1 VGND 0.71073f
C3156 pn51_n2 VGND 0.96854f
C3157 pn51_n3 VGND 1.33488f
C3158 pn51_n4 VGND 0.66052f
C3159 pn6_t0 VGND 0.30153f
C3160 pn6_n0 VGND 1.20184f
C3161 pn6_n1 VGND 0.21448f
C3162 pn6_n2 VGND 0.87457f
C3163 pn6_n3 VGND 1.75006f
C3164 pn6_n4 VGND 0.84639f
C3165 pn5_t0 VGND 0.2416f
C3166 pn5_n0 VGND 0.96957f
C3167 pn5_n1 VGND 0.45965f
C3168 pn5_n2 VGND 0.37843f
C3169 pn5_n3 VGND 1.55325f
C3170 pn5_n4 VGND 0.72487f
C3171 pn209_t0 VGND 0.19727f
C3172 pn209_n0 VGND 0.29914f
C3173 pn209_n1 VGND 1.7155f
C3174 pn209_n2 VGND 0.94784f
C3175 pn209_n3 VGND 2.6266f
C3176 pn209_n4 VGND 0.98188f
C3177 pn193_t0 VGND 0.29769f
C3178 pn193_n0 VGND 2.92287f
C3179 pn193_n1 VGND 0.99065f
C3180 pn60_t0 VGND 0.24547f
C3181 pn60_n0 VGND 1.13883f
C3182 pn41_t0 VGND 0.44396f
C3183 pn41_n0 VGND 1.08401f
C3184 pn41_n1 VGND 0.79234f
C3185 pn41_n2 VGND 1.03146f
C3186 pn41_n3 VGND 0.55108f
C3187 pn181_t0 VGND 0.20347f
C3188 pn181_n0 VGND 1.15965f
C3189 pn181_n1 VGND 2.73398f
C3190 pn181_n2 VGND 0.69732f
C3191 pn130_t1 VGND 0.40345f
C3192 pn130_t0 VGND 0.30137f
C3193 pn130_n0 VGND 0.58211f
C3194 pn130_n1 VGND 2.77033f
C3195 pn131_t0 VGND 0.7856f
C3196 pn131_t1 VGND 0.16484f
C3197 pn131_n0 VGND 1.22315f
C3198 pn131_n1 VGND 3.22149f
C3199 pn132_t0 VGND 0.28732f
C3200 pn132_t1 VGND 0.31418f
C3201 pn132_n0 VGND 0.47975f
C3202 pn132_n1 VGND 2.07087f
C3203 pn133_t1 VGND 0.65219f
C3204 pn133_t0 VGND 0.16877f
C3205 pn133_n0 VGND 0.52145f
C3206 pn133_n1 VGND 2.88601f
C3207 pn211_t0 VGND 0.13964f
C3208 pn211_n0 VGND 0.99956f
C3209 pn62_t0 VGND 0.28839f
C3210 pn62_n0 VGND 1.87f
C3211 pn63_t0 VGND 0.29603f
C3212 pn63_n0 VGND 1.67687f
C3213 pn64_t0 VGND 0.28462f
C3214 pn64_n0 VGND 1.2797f
C3215 pn65_t0 VGND 0.29302f
C3216 pn65_n0 VGND 1.65714f
C3217 pn38_t0 VGND 0.19924f
C3218 pn38_n0 VGND 2.2134f
C3219 pn38_n1 VGND 1.12197f
C3220 pn38_n2 VGND 0.49357f
C3221 pn42_t0 VGND 0.27421f
C3222 pn42_n0 VGND 0.68703f
C3223 pn42_n1 VGND 0.76233f
C3224 pn42_n2 VGND 0.97578f
C3225 pn42_n3 VGND 0.54951f
C3226 pn48_t0 VGND 0.56491f
C3227 pn48_n0 VGND 1.30392f
C3228 pn69_t0 VGND 0.53045f
C3229 pn69_n0 VGND 0.28689f
C3230 pn70_t0 VGND 0.54458f
C3231 pn70_n0 VGND 0.28184f
C3232 pn71_t0 VGND 0.66455f
C3233 pn71_n0 VGND 0.27898f
C3234 pn72_t0 VGND 0.72327f
C3235 pn72_n0 VGND 0.28091f
C3236 pn73_t0 VGND 0.37334f
C3237 pn73_n0 VGND 0.28367f
C3238 pn74_t0 VGND 0.36612f
C3239 pn74_n0 VGND 0.28405f
C3240 pn75_t0 VGND 0.36666f
C3241 pn75_n0 VGND 0.28375f
C3242 pn182_t0 VGND 0.32714f
C3243 pn182_n0 VGND 1.56622f
C3244 pn76_t0 VGND 0.55301f
C3245 pn76_n0 VGND 0.28897f
C3246 pn52_t0 VGND 1.78815f
C3247 pn56_t0 VGND 0.72562f
C3248 pn57_t0 VGND 0.61777f
C3249 pn58_t0 VGND 0.86325f
C3250 pn59_t0 VGND 0.92704f
C3251 pn187_t0 VGND 0.10577f
C3252 pn187_n0 VGND 0.46999f
C3253 pn35_t1 VGND 0.11213f
C3254 pn35_t0 VGND 0.30325f
C3255 pn35_n0 VGND 0.46508f
C3256 pn35_n1 VGND 0.23834f
C3257 pn35_n2 VGND 2.23762f
C3258 pn35_n3 VGND 1.66063f
C3259 pn35_n4 VGND 0.24272f
C3260 pn179_t0 VGND 0.39307f
C3261 pn179_n0 VGND 0.98483f
C3262 pn179_n1 VGND 0.36752f
C3263 pn203_t0 VGND 0.22682f
C3264 pn203_n0 VGND 0.29381f
C3265 pn121_t1 VGND 0.46834f
C3266 pn121_t0 VGND 0.34087f
C3267 pn121_n0 VGND 0.63706f
C3268 pn121_n1 VGND 4.02121f
C3269 pn204_t0 VGND 0.0896f
C3270 pn204_n0 VGND 0.38677f
C3271 pn205_t0 VGND 0.20168f
C3272 pn205_n0 VGND 0.30156f
C3273 pn186_t0 VGND 0.61145f
C3274 pn186_t1 VGND 0.17277f
C3275 pn186_n0 VGND 0.47689f
C3276 pn186_n1 VGND 3.20775f
C3277 pn186_n2 VGND 0.50288f
C3278 pn188_t0 VGND 0.15996f
C3279 pn188_n0 VGND 1.80492f
C3280 pn194_t0 VGND 0.26655f
C3281 pn194_n0 VGND 0.93251f
C3282 pn206_t0 VGND 0.07648f
C3283 pn206_n0 VGND 0.29461f
C3284 pn189_t0 VGND 0.09897f
C3285 pn189_n0 VGND 0.35786f
C3286 pn189_n1 VGND 0.26855f
C3287 pn207_t0 VGND 0.28812f
C3288 pn207_n0 VGND 0.4041f
C3289 pn197_t0 VGND 0.0773f
C3290 pn197_n0 VGND 0.29159f
C3291 pn199_t0 VGND 0.07895f
C3292 pn199_n0 VGND 0.29778f
C3293 pn198_t0 VGND 0.77044f
C3294 pn122_t0 VGND 0.07718f
C3295 pn122_t1 VGND 0.21654f
C3296 pn122_n0 VGND 0.29732f
C3297 pn185_t0 VGND 0.50018f
C3298 pn118_t0 VGND 0.50367f
C3299 pn118_t1 VGND 0.20125f
C3300 pn118_n0 VGND 2.01838f
C3301 pn33_t0 VGND 0.46611f
C3302 pn33_n0 VGND 0.3672f
C3303 pn208_t0 VGND 0.095f
C3304 pn208_n0 VGND 0.41006f
C3305 pn202_t0 VGND 0.19832f
C3306 pn202_n0 VGND 0.56434f
C3307 pn119_t1 VGND 0.34811f
C3308 pn119_t0 VGND 0.33304f
C3309 pn119_n0 VGND 1.88166f
C3310 pn21_t0 VGND 0.10489f
C3311 pn21_n0 VGND 0.24273f
C3312 pn22_t0 VGND 0.11555f
C3313 pn22_n0 VGND 0.2674f
C3314 pn18_t0 VGND 0.27159f
C3315 pn18_n0 VGND 1.18227f
C3316 pn184_t0 VGND 0.41077f
C3317 pn184_n0 VGND 1.27815f
C3318 pn23_t0 VGND 0.12697f
C3319 pn23_n0 VGND 0.29381f
C3320 pn24_t0 VGND 0.59977f
C3321 pn24_n0 VGND 0.281f
C3322 pn25_t0 VGND 0.1221f
C3323 pn25_n0 VGND 0.28256f
C3324 pn26_t0 VGND 0.11995f
C3325 pn26_n0 VGND 0.27758f
C3326 pn27_t0 VGND 0.49837f
C3327 pn27_n0 VGND 0.27922f
C3328 pn28_t0 VGND 0.12284f
C3329 pn28_n0 VGND 0.28427f
C3330 pn29_t0 VGND 0.12183f
C3331 pn29_n0 VGND 0.28194f
C3332 pn30_t0 VGND 0.12851f
C3333 pn30_n0 VGND 0.29738f
C3334 pn31_t0 VGND 0.11826f
C3335 pn31_n0 VGND 0.27367f
C3336 pn32_t0 VGND 0.11861f
C3337 pn32_n0 VGND 0.27447f
C3338 pn7_t0 VGND 0.12563f
C3339 pn7_n0 VGND 0.27279f
C3340 pn7_n1 VGND 5.35971f
C3341 pn7_n2 VGND 3.27898f
C3342 pn8_t0 VGND 0.07358f
C3343 pn8_n0 VGND 0.6937f
C3344 pn8_n1 VGND 11.8235f
C3345 pn8_n2 VGND 6.75402f
C3346 pn9_t0 VGND 0.09062f
C3347 pn9_n0 VGND 2.38792f
C3348 pn9_n1 VGND 16.6046f
C3349 pn9_n2 VGND 8.37388f
C3350 pn4_t0 VGND 0.69028f
C3351 pn10_t0 VGND 0.17332f
C3352 pn10_n0 VGND 3.66473f
C3353 pn10_n1 VGND 15.9925f
C3354 pn10_n2 VGND 8.20644f
C3355 pn11_t0 VGND 0.06069f
C3356 pn11_n0 VGND 0.37998f
C3357 pn11_n1 VGND 2.74326f
C3358 pn11_n2 VGND 11.4906f
C3359 pn11_n3 VGND 5.67549f
C3360 pn12_t0 VGND 1.14989f
C3361 pn13_t0 VGND 0.79049f
C3362 pn14_t0 VGND 1.60032f
C3363 pn16_t0 VGND 1.05572f
C3364 pn147_t1 VGND 0.08712f
C3365 pn147_t0 VGND 0.81722f
C3366 pn147_n0 VGND 0.3231f
C3367 pn146_t1 VGND 0.12851f
C3368 pn146_t0 VGND 0.18013f
C3369 pn146_n0 VGND 0.63667f
C3370 pn145_t2 VGND 0.23819f
C3371 pn145_t1 VGND 0.07339f
C3372 pn145_t0 VGND 0.33943f
C3373 pn145_n0 VGND 0.16602f
C3374 pn145_n1 VGND 0.5359f
C3375 pn80_t0 VGND 0.19999f
C3376 pn80_n0 VGND 1.62587f
C3377 pn80_n1 VGND 1.26393f
C3378 pn144_t1 VGND 0.06098f
C3379 pn144_t0 VGND 0.03353f
C3380 pn144_n0 VGND 2.10254f
C3381 pn142_t0 VGND 3.21223f
C3382 pn141_t2 VGND 2.74067f
C3383 pn141_t0 VGND 0.03853f
C3384 pn141_t1 VGND 0.05417f
C3385 pn141_n0 VGND 0.98259f
C3386 pn141_n1 VGND 1.04684f
C3387 pn213_t0 VGND 0.03283f
C3388 pn213_t1 VGND 3.2523f
C3389 pn213_t2 VGND 1.75732f
C3390 pn213_n0 VGND 1.30183f
C3391 pn213_n1 VGND 0.1009f
C3392 pn214_t1 VGND 0.91947f
C3393 pn214_t2 VGND 1.76748f
C3394 pn214_n0 VGND 0.24578f
C3395 pn214_t0 VGND 0.03499f
C3396 pn214_n1 VGND 0.15778f
C3397 pn215_t2 VGND 0.45875f
C3398 pn215_t1 VGND 0.91956f
C3399 pn215_n0 VGND 0.26118f
C3400 pn215_t0 VGND 0.0259f
C3401 pn215_n1 VGND 0.16189f
C3402 pn128_t1 VGND 0.40482f
C3403 pn128_t0 VGND 0.08179f
C3404 pn128_n0 VGND 0.15881f
C3405 pn128_t2 VGND 0.45517f
C3406 pn128_n1 VGND 5.2447f
C3407 pn140_t0 VGND 0.06215f
C3408 pn140_t1 VGND 0.07898f
C3409 pn140_n0 VGND 0.55633f
C3410 pn77_t0 VGND 0.04868f
C3411 pn77_n0 VGND 0.45579f
C3412 pn212_t4 VGND 0.02904f
C3413 pn212_n0 VGND 0.08963f
C3414 pn212_n1 VGND 0.03572f
C3415 pn212_n2 VGND 0.03596f
C3416 pn212_n3 VGND 0.01955f
C3417 pn212_n4 VGND 0.03574f
C3418 pn212_n5 VGND 0.02607f
C3419 pn212_n6 VGND 0.02597f
C3420 pn212_n7 VGND 0.03624f
C3421 pn212_n8 VGND 0.03623f
C3422 pn212_n9 VGND 0.03596f
C3423 pn212_n10 VGND 1.80374f
C3424 pn212_t8 VGND 0.46308f
C3425 pn212_n11 VGND 1.45343f
C3426 pn212_t11 VGND 0.39028f
C3427 pn212_t3 VGND 0.08059f
C3428 pn212_n12 VGND 0.34412f
C3429 pn212_n13 VGND 0.99138f
C3430 pn212_t9 VGND 0.38237f
C3431 pn212_t6 VGND 0.02378f
C3432 pn212_n14 VGND 0.5244f
C3433 pn212_n15 VGND 1.39662f
C3434 pn212_t10 VGND 0.41807f
C3435 pn212_t5 VGND 0.03289f
C3436 pn212_n16 VGND 0.50425f
C3437 pn212_n17 VGND 1.753f
C3438 pn212_t7 VGND 0.06106f
C3439 pn212_t1 VGND 0.03549f
C3440 pn212_n18 VGND 0.48916f
C3441 pn212_n19 VGND 1.54027f
C3442 pn212_t2 VGND 0.05743f
C3443 pn212_t0 VGND 0.0396f
C3444 pn212_n20 VGND 0.48916f
C3445 pn212_n21 VGND 1.34469f
C3446 pn212_n22 VGND 0.50234f
C3447 pn78_t0 VGND 0.05755f
C3448 pn78_n0 VGND 0.53886f
C3449 pn79_t0 VGND 0.06333f
C3450 pn79_n0 VGND 0.59303f
C3451 pn139_t0 VGND 0.05176f
C3452 pn139_t1 VGND 0.11433f
C3453 pn139_n0 VGND 0.48492f
C3454 pn138_t0 VGND 0.05884f
C3455 pn138_t1 VGND 0.07542f
C3456 pn138_n0 VGND 0.51533f
C3457 pn114_t16 VGND 1.60788f
C3458 pn114_t4 VGND 1.71801f
C3459 pn114_t2 VGND 1.718f
C3460 pn114_t10 VGND 1.71799f
C3461 pn114_t6 VGND 1.71801f
C3462 pn114_t12 VGND 1.71799f
C3463 pn114_t8 VGND 1.718f
C3464 pn114_t14 VGND 1.76699f
C3465 pn114_n0 VGND 0.18577f
C3466 pn114_n1 VGND 0.13315f
C3467 pn114_n2 VGND 0.13313f
C3468 pn114_n3 VGND 0.13314f
C3469 pn114_n4 VGND 0.13313f
C3470 pn114_n5 VGND 0.17309f
C3471 pn114_n6 VGND 0.14157f
C3472 pn114_n7 VGND 0.094f
C3473 pn114_t0 VGND 4.37304f
C3474 pn114_n8 VGND 2.34271f
C3475 pn114_n9 VGND 0.07476f
C3476 pn114_n10 VGND 0.14928f
C3477 pn114_n11 VGND 0.16691f
C3478 pn114_n12 VGND 0.16691f
C3479 pn114_n13 VGND 0.16691f
C3480 pn114_n14 VGND 0.16691f
C3481 pn114_n15 VGND 0.16511f
C3482 pn114_n16 VGND 0.89415f
C3483 pn114_n17 VGND 0.89406f
C3484 pn114_n18 VGND 0.16498f
C3485 pn114_n19 VGND 0.16691f
C3486 pn114_n20 VGND 0.16691f
C3487 pn114_n21 VGND 0.16691f
C3488 pn114_n22 VGND 0.16691f
C3489 pn114_n23 VGND 0.27335f
C3490 pn178_n0 VGND 0.11154f
C3491 pn178_n1 VGND 0.01863f
C3492 pn178_n2 VGND 0.01392f
C3493 pn178_n3 VGND 0.01392f
C3494 pn178_n4 VGND 0.01402f
C3495 pn178_n5 VGND 0.01402f
C3496 pn178_n6 VGND 0.01392f
C3497 pn178_n7 VGND 0.01392f
C3498 pn178_n8 VGND 0.01392f
C3499 pn178_n9 VGND 0.01392f
C3500 pn178_t5 VGND 2.08584f
C3501 pn178_t3 VGND 2.08588f
C3502 pn178_t12 VGND 2.08587f
C3503 pn178_t10 VGND 2.08584f
C3504 pn178_t9 VGND 2.08584f
C3505 pn178_t11 VGND 2.08586f
C3506 pn178_t4 VGND 2.09476f
C3507 pn178_t6 VGND 4.28984f
C3508 pn178_t8 VGND 0.86802f
C3509 pn178_n10 VGND 0.44659f
C3510 pn178_t7 VGND 0.81138f
C3511 pn178_n11 VGND 0.48146f
C3512 pn178_t0 VGND 0.8709f
C3513 pn178_t2 VGND 0.87087f
C3514 pn178_t1 VGND 3.41439f
C3515 pn178_n12 VGND 0.9369f
C3516 pn178_n13 VGND 3.08602f
C3517 pn178_n14 VGND 0.87417f
C3518 pn178_n15 VGND 0.22112f
C3519 pn178_n16 VGND 0.23599f
C3520 pn178_n17 VGND 0.23598f
C3521 pn178_n18 VGND 0.23596f
C3522 pn178_n19 VGND 0.23595f
C3523 pn178_n20 VGND 0.24308f
C3524 pn178_n21 VGND 0.07582f
C3525 pn2_t2 VGND 4.07515f
C3526 pn2_t1 VGND 0.42651f
C3527 pn2_n0 VGND 2.6178f
C3528 pn2_t0 VGND 1.09432f
C3529 pn2_n1 VGND 2.00176f
C3530 pn104_t3 VGND 3.619f
C3531 pn104_n0 VGND 2.15688f
C3532 pn104_t1 VGND 2.02264f
C3533 pn104_n1 VGND 0.98565f
C3534 pn104_t2 VGND 2.08823f
C3535 pn104_n2 VGND 1.60197f
C3536 pn104_t0 VGND 1.83248f
C3537 pn104_n3 VGND 0.71767f
C3538 pn104_t4 VGND 6.7011f
C3539 pn104_n4 VGND 1.29269f
C3540 pn111_t1 VGND 0.25757f
C3541 pn111_n0 VGND 0.32351f
C3542 pn111_t2 VGND 0.87582f
C3543 pn111_n1 VGND 5.22778f
C3544 pn176_t1 VGND 1.95698f
C3545 pn176_t2 VGND 1.27875f
C3546 pn176_t0 VGND 1.56443f
C3547 pn176_n0 VGND 0.39708f
C3548 pn176_n1 VGND 3.14281f
C3549 pn176_n2 VGND 0.91492f
C3550 pn127_t0 VGND 10.92393f
C3551 pn127_t2 VGND 0.16354f
C3552 pn127_t1 VGND 5.7758f
C3553 pn127_n0 VGND 0.08759f
C3554 pn127_n1 VGND 0.17815f
C3555 pn127_t3 VGND 0.12484f
C3556 pn127_n2 VGND 0.39681f
C3557 pn110_t9 VGND 9.79214f
C3558 pn110_t3 VGND 0.21466f
C3559 pn110_n6 VGND 0.0763f
C3560 pn110_n7 VGND 0.28327f
C3561 pn110_t8 VGND 0.0666f
C3562 pn110_n8 VGND 1.95854f
C3563 pn110_t10 VGND 1.22704f
C3564 pn110_n9 VGND 3.31057f
C3565 pn129_t3 VGND 0.91181f
C3566 pn129_t1 VGND 7.45274f
C3567 pn129_t0 VGND 0.06726f
C3568 pn129_n0 VGND 0.06295f
C3569 pn129_n1 VGND 0.04881f
C3570 pn129_n2 VGND 0.09786f
C3571 pn126_t2 VGND 0.19212f
C3572 pn126_n0 VGND 0.23331f
C3573 pn126_t0 VGND 0.51412f
C3574 pn126_n1 VGND 0.23541f
C3575 pn96_t0 VGND 1.18553f
C3576 pn96_n0 VGND 9.20689f
C3577 pn177_t7 VGND 0.60688f
C3578 pn177_t8 VGND 0.5544f
C3579 pn177_t2 VGND 0.55439f
C3580 pn177_t0 VGND 7.99861f
C3581 pn177_t1 VGND 0.72706f
C3582 pn177_n0 VGND 0.42397f
C3583 pn177_t4 VGND 0.02637f
C3584 pn177_n1 VGND 0.20261f
C3585 pn177_t3 VGND 0.02637f
C3586 pn177_n2 VGND 0.17665f
C3587 pn177_t5 VGND 0.02637f
C3588 pn177_n3 VGND 0.17665f
C3589 pn177_t6 VGND 0.02637f
C3590 pn177_n4 VGND 0.16745f
C3591 pn177_n5 VGND 0.22558f
C3592 pn177_n6 VGND 0.3323f
C3593 pn177_n7 VGND 0.49579f
C3594 pn109_t0 VGND 1.18453f
C3595 pn109_t2 VGND 0.61184f
C3596 pn109_n0 VGND 0.69272f
C3597 pn109_n1 VGND 2.3919f
C3598 pn109_n2 VGND 0.11673f
C3599 pn109_n3 VGND 0.04843f
C3600 pn109_n4 VGND 0.04903f
C3601 pn109_n5 VGND 0.02598f
C3602 pn109_n6 VGND 0.3016f
C3603 pn109_n7 VGND 1.10749f
C3604 pn109_n8 VGND 0.10976f
C3605 pn109_n9 VGND 1.88351f
C3606 pn101_t0 VGND 3.09938f
C3607 pn101_t2 VGND 0.19662f
C3608 pn101_n0 VGND 0.10104f
C3609 pn101_n1 VGND 2.41718f
C3610 pn101_n2 VGND 1.46662f
C3611 pn106_t2 VGND 3.69259f
C3612 pn106_t1 VGND 0.12912f
C3613 pn106_n0 VGND 0.80142f
C3614 pn106_n1 VGND 6.27052f
C3615 pn3_n0 VGND 0.69653f
C3616 pn3_t1 VGND 1.56224f
C3617 pn3_n1 VGND 1.22886f
C3618 pn1_t2 VGND 3.09434f
C3619 pn1_t1 VGND 0.59444f
C3620 pn1_n0 VGND 4.81252f
C3621 pn1_t0 VGND 6.62642f
C3622 pn1_n1 VGND 1.61408f
C3623 pn113_t2 VGND 0.18959f
C3624 pn113_n0 VGND 0.23473f
C3625 pn113_t0 VGND 0.51594f
C3626 pn113_n1 VGND 0.2328f
C3627 VINP_t0 VGND 0.62548f
C3628 VINP_n0 VGND 2.91513f
C3629 pn99_t2 VGND 5.61967f
C3630 pn99_t3 VGND 0.17005f
C3631 pn99_n0 VGND 0.76358f
C3632 pn99_t1 VGND 0.67163f
C3633 pn99_n1 VGND 0.1094f
C3634 pn99_n2 VGND 0.60945f
C3635 pn99_n3 VGND 0.56099f
C3636 pn108_t0 VGND 0.63227f
C3637 pn108_t1 VGND 0.56729f
C3638 pn108_n0 VGND 0.75945f
C3639 pn100_t8 VGND 1.1525f
C3640 pn100_t10 VGND 9.84871f
C3641 pn100_n6 VGND 0.14944f
C3642 pn100_n7 VGND 0.55482f
C3643 pn100_t9 VGND 0.13044f
C3644 pn100_n8 VGND 3.80854f
C3645 pn100_n9 VGND 6.58363f
C3646 pn175_t4 VGND 0.60132f
C3647 pn175_t5 VGND 0.54933f
C3648 pn175_t6 VGND 8.17285f
C3649 pn175_t7 VGND 0.60133f
C3650 pn175_t8 VGND 0.72033f
C3651 pn175_n0 VGND 0.42019f
C3652 pn175_t0 VGND 0.02613f
C3653 pn175_n1 VGND 0.20076f
C3654 pn175_t1 VGND 0.02613f
C3655 pn175_n2 VGND 0.17504f
C3656 pn175_t2 VGND 0.02613f
C3657 pn175_n3 VGND 0.17504f
C3658 pn175_t3 VGND 0.02613f
C3659 pn175_n4 VGND 0.16592f
C3660 pn175_n5 VGND 0.22353f
C3661 pn175_n6 VGND 0.32928f
C3662 pn175_n7 VGND 0.49141f
C3663 pn105_t0 VGND 0.61525f
C3664 pn97_t2 VGND 0.16356f
C3665 pn97_t1 VGND 5.52467f
C3666 pn97_n0 VGND 0.08755f
C3667 pn97_t3 VGND 10.89937f
C3668 pn97_n1 VGND 0.17815f
C3669 pn97_t0 VGND 0.12484f
C3670 pn97_n2 VGND 0.39681f
C3671 pn98_n0 VGND 0.01911f
C3672 pn98_t1 VGND 0.88858f
C3673 pn98_t4 VGND 0.05944f
C3674 pn98_t3 VGND 7.68907f
C3675 pn98_n1 VGND 0.06133f
C3676 pn98_n2 VGND 0.04756f
C3677 pn98_n3 VGND 0.08303f
C3678 pn98_n4 VGND 0.06816f
C3679 pn103_t1 VGND 0.52379f
C3680 pn103_t0 VGND 0.11779f
C3681 pn103_n0 VGND 0.11373f
C3682 pn95_t0 VGND 0.66162f
XCM_1 pn120 pn102 cap_cmomi w=10.200u l=8.650u mmin=1 mmax=4 feed=double subblock=0 m=1
XCM_2 pn120 pn102 cap_cmomi w=10.200u l=8.650u mmin=1 mmax=4 feed=double subblock=0 m=1
XCM_3 pn107 pn100 cap_cmomi w=14.880u l=16.080u mmin=1 mmax=4 feed=double subblock=0 m=1
XCM_4 pn107 pn100 cap_cmomi w=14.880u l=16.080u mmin=1 mmax=4 feed=double subblock=0 m=1
XCM_5 pn107 pn100 cap_cmomi w=14.880u l=16.080u mmin=1 mmax=4 feed=double subblock=0 m=1
XCM_6 pn107 pn100 cap_cmomi w=14.880u l=16.080u mmin=1 mmax=4 feed=double subblock=0 m=1
XCM_7 pn120 pn102 cap_cmomi w=10.200u l=8.650u mmin=1 mmax=4 feed=double subblock=0 m=1
XCM_8 pn120 pn102 cap_cmomi w=10.200u l=8.650u mmin=1 mmax=4 feed=double subblock=0 m=1
XCM_9 pn100 pn107 cap_cmomi w=14.880u l=16.080u mmin=1 mmax=4 feed=double subblock=0 m=1
XCM_10 pn100 pn107 cap_cmomi w=14.880u l=16.080u mmin=1 mmax=4 feed=double subblock=0 m=1
XCM_11 pn100 pn107 cap_cmomi w=14.880u l=16.080u mmin=1 mmax=4 feed=double subblock=0 m=1
XCM_12 pn100 pn107 cap_cmomi w=14.880u l=16.080u mmin=1 mmax=4 feed=double subblock=0 m=1
XCM_13 pn100 pn107 cap_cmomi w=14.880u l=16.080u mmin=1 mmax=4 feed=double subblock=0 m=1
XCM_14 pn120 pn1 cap_cmomi w=26.160u l=25.560u mmin=1 mmax=4 feed=double subblock=0 m=1
XCM_15 pn112 pn110 cap_cmomi w=14.880u l=16.080u mmin=1 mmax=4 feed=double subblock=0 m=1
XCM_16 pn112 pn110 cap_cmomi w=14.880u l=16.080u mmin=1 mmax=4 feed=double subblock=0 m=1
XCM_17 pn112 pn110 cap_cmomi w=14.880u l=16.080u mmin=1 mmax=4 feed=double subblock=0 m=1
XCM_18 pn112 pn110 cap_cmomi w=14.880u l=16.080u mmin=1 mmax=4 feed=double subblock=0 m=1
XCM_19 pn112 pn110 cap_cmomi w=14.880u l=16.080u mmin=1 mmax=4 feed=double subblock=0 m=1
XCM_20 pn110 pn112 cap_cmomi w=14.880u l=16.080u mmin=1 mmax=4 feed=double subblock=0 m=1
XCM_21 pn110 pn112 cap_cmomi w=14.880u l=16.080u mmin=1 mmax=4 feed=double subblock=0 m=1
XCM_22 pn110 pn112 cap_cmomi w=14.880u l=16.080u mmin=1 mmax=4 feed=double subblock=0 m=1
XCM_23 pn110 pn112 cap_cmomi w=14.880u l=16.080u mmin=1 mmax=4 feed=double subblock=0 m=1
XCM_24 pn152 pn150 cap_cmomi w=14.880u l=16.080u mmin=1 mmax=4 feed=double subblock=0 m=1
XCM_25 pn152 pn150 cap_cmomi w=14.880u l=16.080u mmin=1 mmax=4 feed=double subblock=0 m=1
XCM_26 pn152 pn150 cap_cmomi w=14.880u l=16.080u mmin=1 mmax=4 feed=double subblock=0 m=1
XCM_27 pn152 pn150 cap_cmomi w=14.880u l=16.080u mmin=1 mmax=4 feed=double subblock=0 m=1
XCM_28 pn150 pn152 cap_cmomi w=14.880u l=16.080u mmin=1 mmax=4 feed=double subblock=0 m=1
XCM_29 pn150 pn152 cap_cmomi w=14.880u l=16.080u mmin=1 mmax=4 feed=double subblock=0 m=1
XCM_30 pn150 pn152 cap_cmomi w=14.880u l=16.080u mmin=1 mmax=4 feed=double subblock=0 m=1
XCM_31 pn150 pn152 cap_cmomi w=14.880u l=16.080u mmin=1 mmax=4 feed=double subblock=0 m=1
XCM_32 pn150 pn152 cap_cmomi w=14.880u l=16.080u mmin=1 mmax=4 feed=double subblock=0 m=1
XCM_33 pn155 pn87 cap_cmomi w=10.200u l=8.650u mmin=1 mmax=4 feed=double subblock=0 m=1
XCM_34 pn155 pn87 cap_cmomi w=10.200u l=8.650u mmin=1 mmax=4 feed=double subblock=0 m=1
XCM_35 pn155 pn87 cap_cmomi w=10.200u l=8.650u mmin=1 mmax=4 feed=double subblock=0 m=1
XCM_36 pn155 pn87 cap_cmomi w=10.200u l=8.650u mmin=1 mmax=4 feed=double subblock=0 m=1
XCM_37 pn223 pn87 cap_cmomi w=26.160u l=25.560u mmin=1 mmax=4 feed=double subblock=0 m=1
XCM_38 pn173 VOUT cap_cmomi w=14.880u l=16.080u mmin=1 mmax=4 feed=double subblock=0 m=1
XCM_39 pn173 VOUT cap_cmomi w=14.880u l=16.080u mmin=1 mmax=4 feed=double subblock=0 m=1
XCM_40 pn173 VOUT cap_cmomi w=14.880u l=16.080u mmin=1 mmax=4 feed=double subblock=0 m=1
XCM_41 pn173 VOUT cap_cmomi w=14.880u l=16.080u mmin=1 mmax=4 feed=double subblock=0 m=1
XCM_42 VOUT pn173 cap_cmomi w=14.880u l=16.080u mmin=1 mmax=4 feed=double subblock=0 m=1
XCM_43 VOUT pn173 cap_cmomi w=14.880u l=16.080u mmin=1 mmax=4 feed=double subblock=0 m=1
XCM_44 VOUT pn173 cap_cmomi w=14.880u l=16.080u mmin=1 mmax=4 feed=double subblock=0 m=1
XCM_45 VOUT pn173 cap_cmomi w=14.880u l=16.080u mmin=1 mmax=4 feed=double subblock=0 m=1
XCM_46 VOUT pn173 cap_cmomi w=14.880u l=16.080u mmin=1 mmax=4 feed=double subblock=0 m=1
Rfl_a_44396_15660_ a_44396_15660_ AVSS 1T
Rfl_a_44486_19396_ a_44486_19396_ AVSS 1T
Rfl_a_44486_19676_ a_44486_19676_ AVSS 1T
Rfl_a_44486_19956_ a_44486_19956_ AVSS 1T
Rfl_a_44748_40115_ a_44748_40115_ AVSS 1T
Rfl_a_45396_45655_ a_45396_45655_ AVSS 1T
Rfl_a_47077_45655_ a_47077_45655_ AVSS 1T
Rfl_a_50103_45655_ a_50103_45655_ AVSS 1T
Rfl_a_51011_7855_ a_51011_7855_ AVSS 1T
Rfl_a_51438_33170_ a_51438_33170_ AVSS 1T
Rfl_a_51830_18659_ a_51830_18659_ AVSS 1T
Rfl_a_52037_46392_ a_52037_46392_ AVSS 1T
Rfl_a_52037_46672_ a_52037_46672_ AVSS 1T
Rfl_a_52037_46952_ a_52037_46952_ AVSS 1T
Rfl_a_55785_6174_ a_55785_6174_ AVSS 1T
Rfl_a_56212_34851_ a_56212_34851_ AVSS 1T
Rfl_a_57562_18659_ a_57562_18659_ AVSS 1T
Rfl_a_60595_18659_ a_60595_18659_ AVSS 1T
Rfl_a_62475_13119_ a_62475_13119_ AVSS 1T
Rfl_a_62827_42656_ a_62827_42656_ AVSS 1T
Rfl_a_72766_16118_ a_72766_16118_ AVSS 1T
Rfl_a_72766_21992_ a_72766_21992_ AVSS 1T
Rfl_a_72766_6326_ a_72766_6326_ AVSS 1T
Rfl_a_82482_46078_ a_82482_46078_ AVSS 1T
Rfl_a_89198_14152_ a_89198_14152_ AVSS 1T
Rfl_a_89198_25050_ a_89198_25050_ AVSS 1T
Rfl_a_89198_9382_ a_89198_9382_ AVSS 1T
Rfl_a_95786_21556_ a_95786_21556_ AVSS 1T
Rfl_a_95787_5888_ a_95787_5888_ AVSS 1T
Rfl_a_96098_12142_ a_96098_12142_ AVSS 1T
Rfl_pn115 pn115 AVSS 1T
Rfl_pn116 pn116 AVSS 1T
Rfl_pn117 pn117 AVSS 1T
Rfl_pn123 pn123 AVSS 1T
Rfl_pn124 pn124 AVSS 1T
Rfl_pn125 pn125 AVSS 1T
Rfl_pn134 pn134 AVSS 1T
Rfl_pn135 pn135 AVSS 1T
Rfl_pn136 pn136 AVSS 1T
Rfl_pn137 pn137 AVSS 1T
.ends pgia_top
