** sch_path: /foss/designs/sg13cmos5l_spma_ip__instramp/xschem/pgia_top/pgia_top.sch
.subckt pgia_top VINP VINN VCM gain_sel[0] gain_sel[1] gain_sel[2] gain_sel[3] VOUT AVDD VPWR IBIAS_IA AVSS VGND
*.PININFO AVDD:B AVSS:B VPWR:B VGND:B VINP:I VINN:I VCM:I gain_sel[0]:I gain_sel[1]:I gain_sel[2]:I gain_sel[3]:I IBIAS_IA:I
*+ VOUT:O
x_dec VGND VPWR gain_sel[0] gain_sel[1] gain_sel[2] gain_sel[3] s1[0] s1[1] s1[2] s1[3] s1[4] net3 net4 net5 net6 net7 s2[0] s2[1]
+ s2[2] s2[3] s2[4] net8 net9 net10 net11 net12 gain_decoder_4b
x_ia AVSS AVDD IBIAS_IA VINN V_IA VINP VCM instramp_cmos5l
x_stage1 AVDD AVSS IBIAS_IA V_IA VCM v_stage1 s1[0] s1[1] s1[2] s1[3] s1[4] gain_stage
x_stage2 AVDD AVSS IBIAS_IA v_stage1 VCM v_stage2 s2[0] s2[1] s2[2] s2[3] s2[4] gain_stage
x_buf AVDD AVSS IBIAS_IA v_stage2 VOUT output_buffer
MM1 net1 net1 VCM AVDD sg13_lv_pmos w=0.2u l=2u ng=1
MM2 net1 net1 VINN AVDD sg13_lv_pmos w=0.2u l=2u ng=1
MM3 net2 net2 VINP AVDD sg13_lv_pmos w=0.2u l=2u ng=1
MM4 net2 net2 VCM AVDD sg13_lv_pmos w=0.2u l=2u ng=1
**** begin user architecture code

* Standard cell models & synthesized gain decoder macro

**** end user architecture code
.ends

* expanding   symbol:  instramp_cmos5l/instramp_cmos5l.sym # of pins=7
** sym_path: /foss/designs/sg13cmos5l_spma_ip__instramp/xschem/instramp_cmos5l/instramp_cmos5l.sym
** sch_path: /foss/designs/sg13cmos5l_spma_ip__instramp/xschem/instramp_cmos5l/instramp_cmos5l.sch
.subckt instramp_cmos5l VSS VDD IBIAS VINN VOUT VINP CM
*.PININFO VDD:B IBIAS:B VSS:B CM:B VOUT:B VINN:B VINP:B
x1 VSS IBIAS VDD net3 VINP net4 ota_cmos5l
x2 VSS IBIAS VDD net1 VINN net2 ota_cmos5l
x3 VSS IBIAS VDD net5 net6 VOUT ota_cmos5l
RR1 net4 net6 6.233k $SUB=VSS $[rhigh] w=0.5e-6 l=2e-6 b=0
RR2 net2 net5 6.233k $SUB=VSS $[rhigh] w=0.5e-6 l=2e-6 b=0
RR3 net6 CM 53.06k $SUB=VSS $[rhigh] w=0.5e-6 l=8*2.23e-6 b=0
RR4 net5 VOUT 53.06k $SUB=VSS $[rhigh] w=0.5e-6 l=8*2.23e-6 b=0
RR7 net2 net1 6.233k $SUB=VSS $[rhigh] w=0.5e-6 l=2e-6 b=0
RR8 net4 net3 6.233k $SUB=VSS $[rhigh] w=0.5e-6 l=2e-6 b=0
.ends

* expanding   symbol:  gain_stage/gain_stage.sym # of pins=11
** sym_path: /foss/designs/sg13cmos5l_spma_ip__instramp/xschem/gain_stage/gain_stage.sym
** sch_path: /foss/designs/sg13cmos5l_spma_ip__instramp/xschem/gain_stage/gain_stage.sch
.subckt gain_stage AVDD AVSS IBIAS VIN VCM VOUT s[0] s[1] s[2] s[3] s[4]
*.PININFO AVDD:B AVSS:B IBIAS:I VIN:I VCM:I VOUT:O s[0]:I s[1]:I s[2]:I s[3]:I s[4]:I
x_nor3 nor3_out s[0] s[1] s[2] AVDD AVSS sg13cmos5l_nor3_1
x_nor2 nor2_out s[3] s[4] AVDD AVSS sg13cmos5l_nor2_1
x_and2 S0 nor3_out nor2_out AVDD AVSS sg13cmos5l_and2_1
x1 s[3] s[4] S0 s[1] s[0] s[2] AVDD VCM VIN VOUT IBIAS AVSS gain_network
.ends

* expanding   symbol:  output_buffer/output_buffer.sym # of pins=5
** sym_path: /foss/designs/sg13cmos5l_spma_ip__instramp/xschem/output_buffer/output_buffer.sym
** sch_path: /foss/designs/sg13cmos5l_spma_ip__instramp/xschem/output_buffer/output_buffer.sch
.subckt output_buffer VDD VSS IBIAS VINN VOUT
*.PININFO VDD:B VSS:B IBIAS:B VINN:B VOUT:B
x1 VSS IBIAS VDD VINN VOUT VOUT ota_cmos5l
.ends

* expanding   symbol:  ota_cmos5l/ota_cmos5l.sym # of pins=6
** sym_path: /foss/designs/sg13cmos5l_spma_ip__instramp/xschem/ota_cmos5l/ota_cmos5l.sym
** sch_path: /foss/designs/sg13cmos5l_spma_ip__instramp/xschem/ota_cmos5l/ota_cmos5l.sch
.subckt ota_cmos5l VSS IBIAS VDD VINN VINP VOUT
.param temp=27
.param lbias=0.15u wbias=0.15u
.param m6=1 m7=4 m8=8
.param linpair=3u winpair=20u
.param lload=5u wload=10u
.param lcs=3u wcs=20u
.param Cc=2p
*.PININFO IBIAS:B VDD:B VSS:B VOUT:B VINP:B VINN:B
MM6 IBIAS IBIAS VDD VDD sg13_lv_pmos w={wbias} l={lbias} ng=1 m={m6}
MM7 net1 IBIAS VDD VDD sg13_lv_pmos w={wbias} l={lbias} ng=1 m={m7}
MM8 VOUT IBIAS VDD VDD sg13_lv_pmos w={wbias} l={lbias} ng=1 m={m8}
MM1 net2 VINN net1 VDD sg13_lv_pmos w={winpair} l={linpair} ng=1
MM2 net3 VINP net1 VDD sg13_lv_pmos w={winpair} l={linpair} ng=1
MM3 net2 net2 VSS VSS sg13_lv_nmos w={wload} l={lload} ng=1
MM4 net3 net2 VSS VSS sg13_lv_nmos w={wload} l={lload} ng=1
MM5 VOUT net3 VSS VSS sg13_lv_nmos w={wcs} l={lcs} ng=1
RR1 net3 net4 6.085k $SUB=VSS $[rhigh] w=0.5e-6 l=1.95e-6 b=0
CC2_1 VOUT net4 cap_cmomi w=15e-6 l=15e-6 m=1
CC2_2 VOUT net4 cap_cmomi w=15e-6 l=15e-6 m=1
CC2_3 VOUT net4 cap_cmomi w=15e-6 l=15e-6 m=1
CC2_4 VOUT net4 cap_cmomi w=15e-6 l=15e-6 m=1
CC2_5 VOUT net4 cap_cmomi w=15e-6 l=15e-6 m=1
**** begin user architecture code

**** end user architecture code
CC1_1 net4 VOUT cap_cmomi w=15e-6 l=15e-6 m=1
CC1_2 net4 VOUT cap_cmomi w=15e-6 l=15e-6 m=1
CC1_3 net4 VOUT cap_cmomi w=15e-6 l=15e-6 m=1
CC1_4 net4 VOUT cap_cmomi w=15e-6 l=15e-6 m=1
.ends

* expanding   symbol:  gain_network/gain_network.sym # of pins=12
** sym_path: /foss/designs/sg13cmos5l_spma_ip__instramp/xschem/gain_network/gain_network.sym
** sch_path: /foss/designs/sg13cmos5l_spma_ip__instramp/xschem/gain_network/gain_network.sch
.subckt gain_network S4 S5 S0 S2 S1 S3 AVDD V_CM V_IN2 V_OUT2 I_BIAS AVSS
*.PININFO I_BIAS:I V_IN2:I V_CM:I AVSS:I AVDD:I V_OUT2:O S5:I S4:I S3:I S2:I S1:I S0:I
x13 net8 S5 AVDD AVSS sg13cmos5l_inv_1
x12 net9 S4 AVDD AVSS sg13cmos5l_inv_1
x11 net10 S3 AVDD AVSS sg13cmos5l_inv_1
x10 net11 S2 AVDD AVSS sg13cmos5l_inv_1
x9 net12 S1 AVDD AVSS sg13cmos5l_inv_1
x8 net13 S0 AVDD AVSS sg13cmos5l_inv_1
x7 net7 AVSS AVDD S5 net8 net6 tgate l=0.13e-6 wn=0.18e-6 wp=0.54e-6
x6 net7 AVSS AVDD S4 net9 net5 tgate l=0.13e-6 wn=0.18e-6 wp=0.54e-6
x5 net7 AVSS AVDD S3 net10 net4 tgate l=0.13e-6 wn=0.18e-6 wp=0.54e-6
x4 net7 AVSS AVDD S2 net11 net3 tgate l=0.13e-6 wn=0.2e-6 wp=0.6e-6
x3 net7 AVSS AVDD S1 net12 net2 tgate l=0.13e-6 wn=0.3e-6 wp=0.9e-6
x2 net7 AVSS AVDD S0 net13 net1 tgate l=0.13e-6 wn=0.4e-6 wp=1.2e-6
RR6 net5 net4 160k $SUB=AVSS $[rhigh] w=0.5e-6 l=54e-6 b=0
RR5 net4 net3 80k $SUB=AVSS $[rhigh] w=0.5e-6 l=26.95e-6 b=0
x1 AVDD V_CM net7 V_OUT2 I_BIAS AVSS gain_ota
RR1 net7 V_IN2 20.01k $SUB=AVSS $[rhigh] w=0.5e-6 l=6.66e-6 b=0
RR2 V_OUT2 net1 9.781k $SUB=AVSS $[rhigh] w=0.5e-6 l=3.2e-6 b=0
RR3 net1 net2 20.01k $SUB=AVSS $[rhigh] w=0.5e-6 l=6.66e-6 b=0
RR4 net2 net3 40k $SUB=AVSS $[rhigh] w=0.5e-6 l=13.42e-6 b=0
RR7 net14 net5 160k $SUB=AVSS $[rhigh] w=0.5e-6 l=54e-6 b=0
RR8 net6 net14 160k $SUB=AVSS $[rhigh] w=0.5e-6 l=54e-6 b=0
DD1 AVSS S5 dantenna l=0.78u w=0.78u
.ends

* expanding   symbol:  tgate.sym # of pins=6
** sym_path: /foss/designs/sg13cmos5l_spma_ip__instramp/xschem/tgate/tgate.sym
** sch_path: /foss/designs/sg13cmos5l_spma_ip__instramp/xschem/tgate/tgate.sch
.subckt tgate IN AVSS AVDD EN ENB OUT  l=0.13e-6 wn=1e-6 wp=3e-6
*.PININFO AVDD:B AVSS:B IN:B OUT:B EN:I ENB:I
MM1 IN EN OUT AVSS sg13_lv_nmos w=wn l=l ng=1
MM2 OUT ENB IN AVDD sg13_lv_pmos w=wp l=l ng=1
.ends

* expanding   symbol:  gain_ota/gain_ota.sym # of pins=6
** sym_path: /foss/designs/sg13cmos5l_spma_ip__instramp/xschem/gain_ota/gain_ota.sym
** sch_path: /foss/designs/sg13cmos5l_spma_ip__instramp/xschem/gain_ota/gain_ota.sch
.subckt gain_ota VDD V_inp V_inn V_out I_bias VSS
*.PININFO V_inn:I VDD:I VSS:I V_out:O I_bias:I V_inp:I
MM1 F1 V_inn net6 VDD sg13_lv_pmos w=26.56u l=2u ng=4
MM2 F2 V_inp net6 VDD sg13_lv_pmos w=26.56u l=2u ng=4
MM3 net5 net5 VDD VDD sg13_lv_pmos w=7.33u l=2u ng=1
MM4 N_A net5 VDD VDD sg13_lv_pmos w=7.33u l=2u ng=1
MM7 F1 V_bn2 VSS VSS sg13_lv_nmos w=9.21u l=2u ng=1
MM8 F2 V_bn2 VSS VSS sg13_lv_nmos w=9.21u l=2u ng=1
MM_tail net6 V_btail VDD VDD sg13_lv_pmos w=7.46u l=2u ng=1 m=8
MM_ctrlp N_B V_ctrlp N_A VDD sg13_lv_pmos w=2.20u l=0.50u ng=1
MM_outp V_out N_A VDD VDD sg13_lv_pmos w=22.20u l=0.5u ng=4
MM_ctrln N_A V_ctrln N_B VSS sg13_lv_nmos w=0.84u l=0.5u ng=1
MM_outn V_out N_B VSS VSS sg13_lv_nmos w=8.4u l=0.5u ng=1
MM5 net5 V_bn1 F1 VSS sg13_lv_nmos w=6.41u l=2u ng=1
MM6 N_A V_bn1 F2 VSS sg13_lv_nmos w=6.41u l=2u ng=1
MM_mp1 net1 net1 VDD VDD sg13_lv_pmos w=2.30u l=2u ng=1
MM_mn1 net1 I_bias VSS VSS sg13_lv_nmos w=0.87u l=2u ng=1
MM_refn I_bias I_bias VSS VSS sg13_lv_nmos w=0.87u l=2u ng=1
MM_mp2 V_bn1 net1 VDD VDD sg13_lv_pmos w=11.50u l=2u ng=2
MM_mp3 V_bn2 net1 VDD VDD sg13_lv_pmos w=23u l=2u ng=4
MM_bn1 V_bn1 V_bn1 net2 VSS sg13_lv_nmos w=1.60u l=2u ng=1
MM_bn2 V_bn2 V_bn2 VSS VSS sg13_lv_nmos w=9.21u l=2u ng=1
MM_mn2 V_btail I_bias VSS VSS sg13_lv_nmos w=6u l=2u ng=1
MM_rep_tail V_btail V_btail VDD VDD sg13_lv_pmos w=7.46u l=2u ng=1 m=8
MM_mn4 N_B I_bias VSS VSS sg13_lv_nmos w=3.2u l=2u ng=1
RR1 net2 VSS 44.67k $SUB=VSS $[rhigh] w=0.5e-6 l=15e-6 b=0
MM_mp4 V_ctrln net1 VDD VDD sg13_lv_pmos w=4.60u l=2u ng=1
MM_rep_ctrln V_ctrln V_ctrln net3 VSS sg13_lv_nmos w=0.84u l=0.5u ng=1
MM_rep_outn net3 net3 VSS VSS sg13_lv_nmos w=2.10u l=0.5u ng=1
MM_mn3 V_ctrlp I_bias VSS VSS sg13_lv_nmos w=1.74u l=2u ng=1
MM_rep_outp net4 net4 VDD VDD sg13_lv_pmos w=5.55u l=0.5u ng=1
MM_rep_ctrlp V_ctrlp V_ctrlp net4 VDD sg13_lv_pmos w=2.20u l=0.50u ng=1
MM_mp5 N_A net1 VDD VDD sg13_lv_pmos w=9.21u l=2u ng=1
RR2 N_A net7 12.15k $SUB=VSS $[rhigh] w=0.5e-6 l=4e-6 b=0
CC3_1 V_out F2 cap_cmomi w=25e-6 l=25e-6 m=1
CC4_1 net7 V_out cap_cmomi w=8.5e-6 l=8.5e-6 m=1
CC4_2 net7 V_out cap_cmomi w=8.5e-6 l=8.5e-6 m=1
CC4_3 net7 V_out cap_cmomi w=8.5e-6 l=8.5e-6 m=1
CC4_4 net7 V_out cap_cmomi w=8.5e-6 l=8.5e-6 m=1
.ends

.subckt gain_decoder_4b VGND VPWR gain_sel[0] gain_sel[1] gain_sel[2] gain_sel[3]
+ s1[0] s1[1] s1[2] s1[3] s1[4] s1_b[0] s1_b[1] s1_b[2] s1_b[3] s1_b[4] s2[0] s2[1]
+ s2[2] s2[3] s2[4] s2_b[0] s2_b[1] s2_b[2] s2_b[3] s2_b[4]
Xoutput20 s2_b[0] _33_/A VPWR VGND sg13cmos5l_buf_1
Xoutput7 s1[2] _21_/Y VPWR VGND sg13cmos5l_buf_1
Xoutput10 s1_b[0] _14_/Y VPWR VGND sg13cmos5l_buf_1
Xoutput21 s2_b[1] _35_/A VPWR VGND sg13cmos5l_buf_1
Xoutput8 s1[3] _27_/Y VPWR VGND sg13cmos5l_buf_1
XFILLER_0_15 VPWR VGND sg13cmos5l_decap_8
XFILLER_0_37 VPWR VGND sg13cmos5l_fill_1
XFILLER_1_0 VPWR VGND sg13cmos5l_decap_8
Xoutput11 s1_b[1] _18_/A VPWR VGND sg13cmos5l_buf_1
Xoutput22 s2_b[2] _37_/A VPWR VGND sg13cmos5l_buf_1
Xoutput9 s1[4] _31_/Y VPWR VGND sg13cmos5l_buf_1
XFILLER_0_49 VPWR VGND sg13cmos5l_decap_4
X_29_ _29_/Y _29_/A _40_/B VPWR VGND sg13cmos5l_nand2_1
Xoutput12 s1_b[2] _21_/A VPWR VGND sg13cmos5l_buf_1
Xoutput23 s2_b[3] _39_/Y VPWR VGND sg13cmos5l_buf_1
XFILLER_0_29 VPWR VGND sg13cmos5l_decap_4
X_28_ _40_/B _28_/A _39_/A VPWR VGND sg13cmos5l_nor2b_1
Xoutput13 s1_b[3] _27_/A VPWR VGND sg13cmos5l_buf_1
Xoutput24 s2_b[4] _41_/A VPWR VGND sg13cmos5l_buf_1
X_26_ _27_/A _36_/A _34_/B VPWR VGND sg13cmos5l_nand2_1
X_27_ _27_/Y _27_/A VPWR VGND sg13cmos5l_inv_1
Xoutput14 s1_b[4] _30_/Y VPWR VGND sg13cmos5l_buf_1
X_25_ _25_/Y _39_/A _28_/A VPWR VGND sg13cmos5l_nand2b_1
Xoutput15 s2[0] _33_/Y VPWR VGND sg13cmos5l_buf_1
X_24_ _34_/B _39_/A _28_/A VPWR VGND sg13cmos5l_nor2b_1
X_41_ _41_/Y _41_/A VPWR VGND sg13cmos5l_inv_1
Xoutput16 s2[1] _35_/Y VPWR VGND sg13cmos5l_buf_1
Xoutput17 s2[2] _37_/Y VPWR VGND sg13cmos5l_buf_1
XFILLER_1_21 VPWR VGND sg13cmos5l_fill_2
XFILLER_1_7 VPWR VGND sg13cmos5l_decap_8
X_23_ _23_/Y _36_/A VPWR VGND sg13cmos5l_inv_1
X_40_ _41_/A _40_/A _40_/B VPWR VGND sg13cmos5l_nand2_1
Xoutput18 s2[3] _38_/X VPWR VGND sg13cmos5l_buf_1
X_22_ _36_/A _22_/A _22_/B VPWR VGND sg13cmos5l_nor2_1
Xoutput19 s2[4] _41_/Y VPWR VGND sg13cmos5l_buf_1
X_21_ _21_/Y _21_/A VPWR VGND sg13cmos5l_inv_1
X_20_ _21_/A _22_/A _22_/B _20_/C VPWR VGND sg13cmos5l_nand3_1
Xinput1 _22_/B gain_sel[0] VPWR VGND sg13cmos5l_buf_1
XFILLER_1_14 VPWR VGND sg13cmos5l_decap_8
XFILLER_1_58 VPWR VGND sg13cmos5l_fill_1
Xinput2 _22_/A gain_sel[1] VPWR VGND sg13cmos5l_buf_1
Xinput3 _28_/A gain_sel[2] VPWR VGND sg13cmos5l_buf_1
Xinput4 _39_/A gain_sel[3] VPWR VGND sg13cmos5l_buf_1
XFILLER_2_61 VPWR VGND sg13cmos5l_fill_1
X_39_ _39_/Y _39_/A _39_/B VPWR VGND sg13cmos5l_nand2_1
XFILLER_2_42 VPWR VGND sg13cmos5l_decap_8
XFILLER_2_53 VPWR VGND sg13cmos5l_fill_1
X_38_ _38_/X _39_/A _39_/B VPWR VGND sg13cmos5l_and2_1
XFILLER_1_109 VPWR VGND sg13cmos5l_fill_2
X_37_ _37_/Y _37_/A VPWR VGND sg13cmos5l_inv_1
XFILLER_2_22 VPWR VGND sg13cmos5l_decap_8
X_19_ _29_/A _22_/A _22_/B VPWR VGND sg13cmos5l_nand2_1
X_36_ _37_/A _36_/A _40_/B VPWR VGND sg13cmos5l_nand2_1
XFILLER_2_78 VPWR VGND sg13cmos5l_fill_1
X_18_ _18_/Y _18_/A VPWR VGND sg13cmos5l_inv_1
X_35_ _35_/Y _35_/A VPWR VGND sg13cmos5l_inv_1
XFILLER_0_102 VPWR VGND sg13cmos5l_fill_1
X_17_ _18_/A _40_/A _20_/C VPWR VGND sg13cmos5l_nand2_1
X_34_ _35_/A _29_/A _34_/B VPWR VGND sg13cmos5l_nand2b_1
XFILLER_2_15 VPWR VGND sg13cmos5l_decap_8
XFILLER_2_36 VPWR VGND sg13cmos5l_fill_2
X_16_ _20_/C _39_/A _28_/A VPWR VGND sg13cmos5l_nor2_1
X_33_ _33_/Y _33_/A VPWR VGND sg13cmos5l_inv_1
XFILLER_2_49 VPWR VGND sg13cmos5l_decap_4
XFILLER_2_8 VPWR VGND sg13cmos5l_decap_8
X_15_ _40_/A _22_/B _22_/A VPWR VGND sg13cmos5l_nor2b_1
X_31_ _31_/Y _36_/A _25_/Y _29_/Y VPWR VGND sg13cmos5l_o21ai_1
X_32_ _33_/A _40_/A _34_/B VPWR VGND sg13cmos5l_nand2_1
X_14_ _14_/Y _39_/A _39_/B VPWR VGND sg13cmos5l_nand2b_1
X_30_ _30_/Y _23_/Y _34_/B _40_/B _29_/A VPWR VGND sg13cmos5l_a22oi_1
XFILLER_0_8 VPWR VGND sg13cmos5l_decap_8
XFILLER_2_29 VPWR VGND sg13cmos5l_decap_8
X_12_ _39_/B _22_/A _12_/B _28_/A VPWR VGND sg13cmos5l_nor3_1
X_13_ _13_/Y _39_/A _39_/B VPWR VGND sg13cmos5l_nor2b_1
X_11_ _12_/B _22_/B VPWR VGND sg13cmos5l_inv_1
XFILLER_0_42 VPWR VGND sg13cmos5l_decap_8
XFILLER_0_22 VPWR VGND sg13cmos5l_decap_8
XFILLER_0_77 VPWR VGND sg13cmos5l_fill_1
Xoutput5 s1[0] _13_/Y VPWR VGND sg13cmos5l_buf_1
Xoutput6 s1[1] _18_/Y VPWR VGND sg13cmos5l_buf_1
.ends

.subckt sg13cmos5l_and2_1 X A B VDD VSS
MN0 net4 A net2 VSS sg13_lv_nmos w=640.00n l=130.00n ng=1 ad=2.176e-13 as=2.176e-13 pd=1.96e-06 ps=1.96e-06 m=1
MN2 X net4 VSS VSS sg13_lv_nmos w=740.00n l=130.00n ng=1 ad=2.516e-13 as=2.516e-13 pd=2.16e-06 ps=2.16e-06 m=1
MN1 net2 B VSS VSS sg13_lv_nmos w=640.00n l=130.00n ng=1 ad=2.176e-13 as=2.176e-13 pd=1.96e-06 ps=1.96e-06 m=1
MP0 net4 B VDD VDD sg13_lv_pmos w=840.00n l=130.00n ng=1 ad=2.856e-13 as=2.856e-13 pd=2.36e-06 ps=2.36e-06 m=1
MP2 X net4 VDD VDD sg13_lv_pmos w=1.12u l=130.00n ng=1 ad=3.808e-13 as=3.808e-13 pd=2.92e-06 ps=2.92e-06 m=1
MP1 net4 A VDD VDD sg13_lv_pmos w=840.00n l=130.00n ng=1 ad=2.856e-13 as=2.856e-13 pd=2.36e-06 ps=2.36e-06 m=1
.ends

.subckt sg13cmos5l_buf_1 X A VDD VSS
MN0 net1 A VSS VSS sg13_lv_nmos w=550.00n l=130.00n ng=1 ad=1.87e-13 as=1.87e-13 pd=1.78e-06 ps=1.78e-06 m=1
MN1 X net1 VSS VSS sg13_lv_nmos w=740.00n l=130.00n ng=1 ad=2.516e-13 as=2.516e-13 pd=2.16e-06 ps=2.16e-06 m=1
MP1 X net1 VDD VDD sg13_lv_pmos w=1.12u l=130.00n ng=1 ad=3.808e-13 as=3.808e-13 pd=2.92e-06 ps=2.92e-06 m=1
MP0 net1 A VDD VDD sg13_lv_pmos w=840.00n l=130.00n ng=1 ad=2.856e-13 as=2.856e-13 pd=2.36e-06 ps=2.36e-06 m=1
.ends

.subckt sg13cmos5l_decap_4 VDD VSS
MN0 VSS VDD VSS VSS sg13_lv_nmos w=420.00n l=1.000u ng=1 ad=1.428e-13 as=1.428e-13 pd=1.52e-06 ps=1.52e-06 m=1
MP0 VDD VSS VDD VDD sg13_lv_pmos w=1.000u l=1.000u ng=1 ad=3.4e-13 as=3.4e-13 pd=2.68e-06 ps=2.68e-06 m=1
.ends

.subckt sg13cmos5l_decap_8 VDD VSS
MN0 VSS VDD VSS VSS sg13_lv_nmos w=840.00n l=1.000u ng=2 ad=1.596e-13 as=2.856e-13 pd=1.6e-06 ps=3.04e-06 m=1
MP0 VDD VSS VDD VDD sg13_lv_pmos w=2.000u l=1.000u ng=2 ad=3.8e-13 as=6.8e-13 pd=2.76e-06 ps=5.36e-06 m=1
.ends

.subckt sg13cmos5l_inv_1 Y A VDD VSS
MN0 Y A VSS VSS sg13_lv_nmos w=740.00n l=130.00n ng=1 ad=2.516e-13 as=2.516e-13 pd=2.16e-06 ps=2.16e-06 m=1
MP0 Y A VDD VDD sg13_lv_pmos w=1.12u l=130.00n ng=1 ad=3.808e-13 as=3.808e-13 pd=2.92e-06 ps=2.92e-06 m=1
.ends

.subckt sg13cmos5l_nand2_1 Y A B VDD VSS
MP1 Y B VDD VDD sg13_lv_pmos w=1.12u l=130.00n ng=1 ad=3.808e-13 as=3.808e-13 pd=2.92e-06 ps=2.92e-06 m=1
MP0 Y A VDD VDD sg13_lv_pmos w=1.12u l=130.00n ng=1 ad=3.808e-13 as=3.808e-13 pd=2.92e-06 ps=2.92e-06 m=1
MN1 net1 B VSS VSS sg13_lv_nmos w=740.00n l=130.00n ng=1 ad=2.516e-13 as=2.516e-13 pd=2.16e-06 ps=2.16e-06 m=1
MN0 Y A net1 VSS sg13_lv_nmos w=740.00n l=130.00n ng=1 ad=2.516e-13 as=2.516e-13 pd=2.16e-06 ps=2.16e-06 m=1
.ends

.subckt sg13cmos5l_nand2b_1 Y A_N B VDD VSS
MP2 Y net2 VDD VDD sg13_lv_pmos w=1.12u l=130.00n ng=1 ad=3.808e-13 as=3.808e-13 pd=2.92e-06 ps=2.92e-06 m=1
MP1 net2 A_N VDD VDD sg13_lv_pmos w=840.00n l=130.00n ng=1 ad=2.856e-13 as=2.856e-13 pd=2.36e-06 ps=2.36e-06 m=1
MP0 Y B VDD VDD sg13_lv_pmos w=1.12u l=130.00n ng=1 ad=3.808e-13 as=3.808e-13 pd=2.92e-06 ps=2.92e-06 m=1
MN1 Y net2 net1 VSS sg13_lv_nmos w=740.00n l=130.00n ng=1 ad=2.516e-13 as=2.516e-13 pd=2.16e-06 ps=2.16e-06 m=1
MN0 net2 A_N VSS VSS sg13_lv_nmos w=550.00n l=130.00n ng=1 ad=1.87e-13 as=1.87e-13 pd=1.78e-06 ps=1.78e-06 m=1
MN2 net1 B VSS VSS sg13_lv_nmos w=740.00n l=130.00n ng=1 ad=2.516e-13 as=2.516e-13 pd=2.16e-06 ps=2.16e-06 m=1
.ends

.subckt sg13cmos5l_nand3_1 Y A B C VDD VSS
MP0 Y A VDD VDD sg13_lv_pmos w=1.12u l=130.00n ng=1 ad=3.808e-13 as=3.808e-13 pd=2.92e-06 ps=2.92e-06 m=1
MP1 Y B VDD VDD sg13_lv_pmos w=1.12u l=130.00n ng=1 ad=3.808e-13 as=3.808e-13 pd=2.92e-06 ps=2.92e-06 m=1
MP2 Y C VDD VDD sg13_lv_pmos w=1.12u l=130.00n ng=1 ad=3.808e-13 as=3.808e-13 pd=2.92e-06 ps=2.92e-06 m=1
MN1 net2 B net3 VSS sg13_lv_nmos w=740.00n l=130.00n ng=1 ad=2.516e-13 as=2.516e-13 pd=2.16e-06 ps=2.16e-06 m=1
MN2 net3 C VSS VSS sg13_lv_nmos w=740.00n l=130.00n ng=1 ad=2.516e-13 as=2.516e-13 pd=2.16e-06 ps=2.16e-06 m=1
MN0 Y A net2 VSS sg13_lv_nmos w=740.00n l=130.00n ng=1 ad=2.516e-13 as=2.516e-13 pd=2.16e-06 ps=2.16e-06 m=1
.ends

.subckt sg13cmos5l_nor2_1 Y A B VDD VSS
MN0 Y A VSS VSS sg13_lv_nmos w=740.00n l=130.00n ng=1 ad=2.516e-13 as=2.516e-13 pd=2.16e-06 ps=2.16e-06 m=1
MN1 Y B VSS VSS sg13_lv_nmos w=740.00n l=130.00n ng=1 ad=2.516e-13 as=2.516e-13 pd=2.16e-06 ps=2.16e-06 m=1
MP0 net1 A VDD VDD sg13_lv_pmos w=1.12u l=130.00n ng=1 ad=3.808e-13 as=3.808e-13 pd=2.92e-06 ps=2.92e-06 m=1
MP1 Y B net1 VDD sg13_lv_pmos w=1.12u l=130.00n ng=1 ad=3.808e-13 as=3.808e-13 pd=2.92e-06 ps=2.92e-06 m=1
.ends

.subckt sg13cmos5l_nor2b_1 Y A B_N VDD VSS
MN0 B B_N VSS VSS sg13_lv_nmos w=550.00n l=130.00n ng=1 ad=1.87e-13 as=1.87e-13 pd=1.78e-06 ps=1.78e-06 m=1
MN1 Y A VSS VSS sg13_lv_nmos w=740.00n l=130.00n ng=1 ad=2.516e-13 as=2.516e-13 pd=2.16e-06 ps=2.16e-06 m=1
MN2 Y B VSS VSS sg13_lv_nmos w=740.00n l=130.00n ng=1 ad=2.516e-13 as=2.516e-13 pd=2.16e-06 ps=2.16e-06 m=1
MP0 B B_N VDD VDD sg13_lv_pmos w=840.00n l=130.00n ng=1 ad=2.856e-13 as=2.856e-13 pd=2.36e-06 ps=2.36e-06 m=1
MP1 net1 B VDD VDD sg13_lv_pmos w=1.12u l=130.00n ng=1 ad=3.808e-13 as=3.808e-13 pd=2.92e-06 ps=2.92e-06 m=1
MP2 Y A net1 VDD sg13_lv_pmos w=1.12u l=130.00n ng=1 ad=3.808e-13 as=3.808e-13 pd=2.92e-06 ps=2.92e-06 m=1
.ends

.subckt sg13cmos5l_nor3_1 Y A B C VDD VSS
MP2 Y C net2 VDD sg13_lv_pmos w=1.12u l=130.00n ng=1 ad=3.808e-13 as=3.808e-13 pd=2.92e-06 ps=2.92e-06 m=1
MP1 net2 B net3 VDD sg13_lv_pmos w=1.12u l=130.00n ng=1 ad=3.808e-13 as=3.808e-13 pd=2.92e-06 ps=2.92e-06 m=1
MP0 net3 A VDD VDD sg13_lv_pmos w=1.12u l=130.00n ng=1 ad=3.808e-13 as=3.808e-13 pd=2.92e-06 ps=2.92e-06 m=1
MN0 Y A VSS VSS sg13_lv_nmos w=770.00n l=130.00n ng=1 ad=2.618e-13 as=2.618e-13 pd=2.22e-06 ps=2.22e-06 m=1
MN1 Y B VSS VSS sg13_lv_nmos w=770.00n l=130.00n ng=1 ad=2.618e-13 as=2.618e-13 pd=2.22e-06 ps=2.22e-06 m=1
MN2 Y C VSS VSS sg13_lv_nmos w=770.00n l=130.00n ng=1 ad=2.618e-13 as=2.618e-13 pd=2.22e-06 ps=2.22e-06 m=1
.ends

.subckt sg13cmos5l_o21ai_1 Y A1 A2 B1 VDD VSS
MP0 net14 A1 VDD VDD sg13_lv_pmos w=1.12u l=150.00n ng=1 ad=3.808e-13 as=3.808e-13 pd=2.92e-06 ps=2.92e-06 m=1
MP1 Y A2 net14 VDD sg13_lv_pmos w=1.12u l=150.00n ng=1 ad=3.808e-13 as=3.808e-13 pd=2.92e-06 ps=2.92e-06 m=1
MP2 Y B1 VDD VDD sg13_lv_pmos w=1.12u l=150.00n ng=1 ad=3.808e-13 as=3.808e-13 pd=2.92e-06 ps=2.92e-06 m=1
MN0 net1 A2 VSS VSS sg13_lv_nmos w=740.00n l=150.00n ng=1 ad=2.516e-13 as=2.516e-13 pd=2.16e-06 ps=2.16e-06 m=1
MN2 net1 A1 VSS VSS sg13_lv_nmos w=740.00n l=150.00n ng=1 ad=2.516e-13 as=2.516e-13 pd=2.16e-06 ps=2.16e-06 m=1
MN1 Y B1 net1 VSS sg13_lv_nmos w=740.00n l=150.00n ng=1 ad=2.516e-13 as=2.516e-13 pd=2.16e-06 ps=2.16e-06 m=1
.ends

.subckt sg13cmos5l_a22oi_1 Y A1 A2 B1 B2 VDD VSS
MN1 net1 B1 VSS VSS sg13_lv_nmos w=740.00n l=130.00n ng=1 ad=2.516e-13 as=2.516e-13 pd=2.16e-06 ps=2.16e-06 m=1
MN0 Y B2 net1 VSS sg13_lv_nmos w=740.00n l=130.00n ng=1 ad=2.516e-13 as=2.516e-13 pd=2.16e-06 ps=2.16e-06 m=1
MN3 net2 A2 VSS VSS sg13_lv_nmos w=740.00n l=130.00n ng=1 ad=2.516e-13 as=2.516e-13 pd=2.16e-06 ps=2.16e-06 m=1
MN2 Y A1 net2 VSS sg13_lv_nmos w=740.00n l=130.00n ng=1 ad=2.516e-13 as=2.516e-13 pd=2.16e-06 ps=2.16e-06 m=1
MP1 Y B1 net3 VDD sg13_lv_pmos w=1.12u l=130.00n ng=1 ad=3.808e-13 as=3.808e-13 pd=2.92e-06 ps=2.92e-06 m=1
MP3 Y B2 net3 VDD sg13_lv_pmos w=1.12u l=130.00n ng=1 ad=3.808e-13 as=3.808e-13 pd=2.92e-06 ps=2.92e-06 m=1
MP2 net3 A2 VDD VDD sg13_lv_pmos w=1.12u l=130.00n ng=1 ad=3.808e-13 as=3.808e-13 pd=2.92e-06 ps=2.92e-06 m=1
MP0 net3 A1 VDD VDD sg13_lv_pmos w=1.12u l=130.00n ng=1 ad=3.808e-13 as=3.808e-13 pd=2.92e-06 ps=2.92e-06 m=1
.ends

.subckt sg13cmos5l_fill_1 VDD VSS
.ends

.subckt sg13cmos5l_fill_2 VDD VSS
.ends
