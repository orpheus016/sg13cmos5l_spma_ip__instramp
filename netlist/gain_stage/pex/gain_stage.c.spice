** post-layout netlist of gain_stage: kpex -> ngspice by scripts/pex_netlist.py (source: /foss/designs/sg13cmos5l_spma_ip__instramp/runs/pex/gain_stage/kpex/gain_stage__gain_stage/gain_stage_k25d_pex_netlist.spice)
.subckt gain_stage AVDD AVSS IBIAS VIN VCM VOUT s[0] s[1] s[2] s[3] s[4]
XM_1 n282 n277 n281 AVSS sg13_lv_nmos L=0.13U W=0.64U AS=0.2176P AD=0.1216P PS=1.96U PD=1.02U rfmode=0
XM_2 n282 n278 AVSS AVSS sg13_lv_nmos L=0.13U W=0.64U AS=0.1331P AD=0.1216P PS=1.12U PD=1.02U rfmode=0
XM_3 n220 n281 AVSS AVSS sg13_lv_nmos L=0.13U W=0.74U AS=0.1331P AD=0.2516P PS=1.12U PD=2.16U rfmode=0
XM_4 n277 s[0] AVSS AVSS sg13_lv_nmos L=0.13U W=0.77U AS=0.2618P AD=0.1694P PS=2.22U PD=1.21U rfmode=0
XM_5 AVSS s[1] n277 AVSS sg13_lv_nmos L=0.13U W=0.77U AS=0.1694P AD=0.1463P PS=1.21U PD=1.15U rfmode=0
XM_6 n277 s[2] AVSS AVSS sg13_lv_nmos L=0.13U W=0.77U AS=0.1463P AD=0.2618P PS=1.15U PD=2.22U rfmode=0
XM_7 n44 n196 n69 AVSS sg13_lv_nmos L=0.5U W=0.84U AS=0.2856P AD=0.2856P PS=2.36U PD=2.36U rfmode=0
XM_8 n196 n196 n93 AVSS sg13_lv_nmos L=0.5U W=0.84U AS=0.2856P AD=0.2856P PS=2.36U PD=2.36U rfmode=0
XM_9 n153 IBIAS AVSS AVSS sg13_lv_nmos L=2U W=0.87U AS=0.2958P AD=0.2958P PS=2.42U PD=2.42U rfmode=0
XM_10 AVSS IBIAS IBIAS AVSS sg13_lv_nmos L=2U W=0.87U AS=0.2958P AD=0.2958P PS=2.42U PD=2.42U rfmode=0
XM_11 VOUT n69 AVSS AVSS sg13_lv_nmos L=0.5U W=8.4U AS=2.856P AD=2.856P PS=17.48U PD=17.48U rfmode=0
XM_12 n86 n24 n26 AVSS sg13_lv_nmos L=2U W=6.41U AS=2.1794P AD=2.1794P PS=13.5U PD=13.5U rfmode=0
XM_13 n33 n25 AVSS AVSS sg13_lv_nmos L=2U W=9.21U AS=3.1314P AD=3.1314P PS=19.1U PD=19.1U rfmode=0
XM_14 n93 n93 AVSS AVSS sg13_lv_nmos L=0.5U W=2.1U AS=0.714P AD=0.714P PS=4.88U PD=4.88U rfmode=0
XM_15 n227 s[2] AVSS AVSS sg13_lv_nmos L=0.13U W=0.74U AS=0.2516P AD=0.2516P PS=2.16U PD=2.16U rfmode=0
XM_16 AVSS n25 n26 AVSS sg13_lv_nmos L=2U W=9.21U AS=3.1314P AD=3.1314P PS=19.1U PD=19.1U rfmode=0
XM_17 n223 s[0] AVSS AVSS sg13_lv_nmos L=0.13U W=0.74U AS=0.2516P AD=0.2516P PS=2.16U PD=2.16U rfmode=0
XM_18 n25 n25 AVSS AVSS sg13_lv_nmos L=2U W=9.21U AS=3.1314P AD=3.1314P PS=19.1U PD=19.1U rfmode=0
XM_19 n215 IBIAS AVSS AVSS sg13_lv_nmos L=2U W=6U AS=2.04P AD=2.04P PS=12.68U PD=12.68U rfmode=0
XM_20 n24 n24 n10 AVSS sg13_lv_nmos L=2U W=1.6U AS=0.544P AD=0.544P PS=3.88U PD=3.88U rfmode=0
XM_21 n228 s[3] AVSS AVSS sg13_lv_nmos L=0.13U W=0.74U AS=0.2516P AD=0.2516P PS=2.16U PD=2.16U rfmode=0
XM_22 n252 s[3] n213 AVSS sg13_lv_nmos L=0.13U W=0.18U AS=0.1026P AD=0.1026P PS=1.34U PD=1.34U rfmode=0
XM_23 n33 n24 n44 AVSS sg13_lv_nmos L=2U W=6.41U AS=2.1794P AD=2.1794P PS=13.5U PD=13.5U rfmode=0
XM_24 n278 s[3] AVSS AVSS sg13_lv_nmos L=0.13U W=0.74U AS=0.2516P AD=0.1406P PS=2.16U PD=1.12U rfmode=0
XM_25 AVSS s[4] n278 AVSS sg13_lv_nmos L=0.13U W=0.74U AS=0.1406P AD=0.2516P PS=1.12U PD=2.16U rfmode=0
XM_26 n69 IBIAS AVSS AVSS sg13_lv_nmos L=2U W=3.2U AS=1.088P AD=1.088P PS=7.08U PD=7.08U rfmode=0
XM_27 n100 IBIAS AVSS AVSS sg13_lv_nmos L=2U W=1.74U AS=0.5916P AD=0.5916P PS=4.16U PD=4.16U rfmode=0
XM_28 n250 s[1] n213 AVSS sg13_lv_nmos L=0.13U W=0.2U AS=0.104P AD=0.104P PS=1.34U PD=1.34U rfmode=0
XM_29 n222 n220 AVSS AVSS sg13_lv_nmos L=0.13U W=0.74U AS=0.2516P AD=0.2516P PS=2.16U PD=2.16U rfmode=0
XM_30 n225 s[1] AVSS AVSS sg13_lv_nmos L=0.13U W=0.74U AS=0.2516P AD=0.2516P PS=2.16U PD=2.16U rfmode=0
XM_31 n230 s[4] AVSS AVSS sg13_lv_nmos L=0.13U W=0.74U AS=0.2516P AD=0.2516P PS=2.16U PD=2.16U rfmode=0
XM_32 n249 s[0] n213 AVSS sg13_lv_nmos L=0.13U W=0.3U AS=0.102P AD=0.102P PS=1.28U PD=1.28U rfmode=0
XM_33 n251 s[2] n213 AVSS sg13_lv_nmos L=0.13U W=0.18U AS=0.1026P AD=0.1026P PS=1.34U PD=1.34U rfmode=0
XM_34 n253 s[4] n213 AVSS sg13_lv_nmos L=0.13U W=0.18U AS=0.1026P AD=0.1026P PS=1.34U PD=1.34U rfmode=0
XM_35 n248 n220 n213 AVSS sg13_lv_nmos L=0.13U W=0.4U AS=0.136P AD=0.136P PS=1.48U PD=1.48U rfmode=0
XM_36 n145 n100 n100 AVDD sg13_lv_pmos L=0.5U W=2.2U AS=0.748P AD=0.748P PS=5.08U PD=5.08U rfmode=0
XM_37 AVDD n145 n145 AVDD sg13_lv_pmos L=0.5U W=5.55U AS=1.887P AD=1.887P PS=11.78U PD=11.78U rfmode=0
XM_38 n25 n153 AVDD AVDD sg13_lv_pmos L=2U W=5.75U AS=1.955P AD=1.0925P PS=12.18U PD=6.13U rfmode=0
XM_39 AVDD n153 n25 AVDD sg13_lv_pmos L=2U W=5.75U AS=1.0925P AD=1.0925P PS=6.13U PD=6.13U rfmode=0
XM_40 n25 n153 AVDD AVDD sg13_lv_pmos L=2U W=5.75U AS=1.0925P AD=1.0925P PS=6.13U PD=6.13U rfmode=0
XM_41 AVDD n153 n25 AVDD sg13_lv_pmos L=2U W=5.75U AS=1.0925P AD=1.955P PS=6.13U PD=12.18U rfmode=0
XM_42 n33 VCM n142 AVDD sg13_lv_pmos L=2U W=6.64U AS=2.2576P AD=1.2616P PS=13.96U PD=7.02U rfmode=0
XM_43 n142 VCM n33 AVDD sg13_lv_pmos L=2U W=6.64U AS=1.2616P AD=1.2616P PS=7.02U PD=7.02U rfmode=0
XM_44 n33 VCM n142 AVDD sg13_lv_pmos L=2U W=6.64U AS=1.2616P AD=1.2616P PS=7.02U PD=7.02U rfmode=0
XM_45 n142 VCM n33 AVDD sg13_lv_pmos L=2U W=6.64U AS=1.2616P AD=2.2576P PS=7.02U PD=13.96U rfmode=0
XM_46 AVDD n86 n44 AVDD sg13_lv_pmos L=2U W=7.33U AS=2.4922P AD=2.4922P PS=15.34U PD=15.34U rfmode=0
XM_47 AVDD n153 n153 AVDD sg13_lv_pmos L=2U W=2.3U AS=0.782P AD=0.782P PS=5.28U PD=5.28U rfmode=0
XM_48 AVDD n86 n86 AVDD sg13_lv_pmos L=2U W=7.33U AS=2.4922P AD=2.4922P PS=15.34U PD=15.34U rfmode=0
XM_49 AVDD n153 n44 AVDD sg13_lv_pmos L=2U W=9.21U AS=3.1314P AD=3.1314P PS=19.1U PD=19.1U rfmode=0
XM_50 VOUT n44 AVDD AVDD sg13_lv_pmos L=0.5U W=5.55U AS=1.887P AD=1.0545P PS=11.78U PD=5.93U rfmode=0
XM_51 AVDD n44 VOUT AVDD sg13_lv_pmos L=0.5U W=5.55U AS=1.0545P AD=1.0545P PS=5.93U PD=5.93U rfmode=0
XM_52 VOUT n44 AVDD AVDD sg13_lv_pmos L=0.5U W=5.55U AS=1.0545P AD=1.0545P PS=5.93U PD=5.93U rfmode=0
XM_53 AVDD n44 VOUT AVDD sg13_lv_pmos L=0.5U W=5.55U AS=1.0545P AD=1.887P PS=5.93U PD=11.78U rfmode=0
XM_54 n24 n153 AVDD AVDD sg13_lv_pmos L=2U W=5.75U AS=1.955P AD=1.0925P PS=12.18U PD=6.13U rfmode=0
XM_55 AVDD n153 n24 AVDD sg13_lv_pmos L=2U W=5.75U AS=1.0925P AD=1.955P PS=6.13U PD=12.18U rfmode=0
XM_56 n26 n213 n142 AVDD sg13_lv_pmos L=2U W=6.64U AS=2.2576P AD=1.2616P PS=13.96U PD=7.02U rfmode=0
XM_57 n142 n213 n26 AVDD sg13_lv_pmos L=2U W=6.64U AS=1.2616P AD=1.2616P PS=7.02U PD=7.02U rfmode=0
XM_58 n26 n213 n142 AVDD sg13_lv_pmos L=2U W=6.64U AS=1.2616P AD=1.2616P PS=7.02U PD=7.02U rfmode=0
XM_59 n142 n213 n26 AVDD sg13_lv_pmos L=2U W=6.64U AS=1.2616P AD=2.2576P PS=7.02U PD=13.96U rfmode=0
XM_60 n44 n100 n69 AVDD sg13_lv_pmos L=0.5U W=2.2U AS=0.748P AD=0.748P PS=5.08U PD=5.08U rfmode=0
XM_61 AVDD n215 n215 AVDD sg13_lv_pmos L=2U W=7.46U AS=2.5364P AD=2.5364P PS=15.6U PD=15.6U rfmode=0
XM_62 AVDD n215 n215 AVDD sg13_lv_pmos L=2U W=7.46U AS=2.5364P AD=2.5364P PS=15.6U PD=15.6U rfmode=0
XM_63 AVDD n215 n215 AVDD sg13_lv_pmos L=2U W=7.46U AS=2.5364P AD=2.5364P PS=15.6U PD=15.6U rfmode=0
XM_64 AVDD n153 n196 AVDD sg13_lv_pmos L=2U W=4.6U AS=1.564P AD=1.564P PS=9.88U PD=9.88U rfmode=0
XM_65 AVDD n215 n215 AVDD sg13_lv_pmos L=2U W=7.46U AS=2.5364P AD=2.5364P PS=15.6U PD=15.6U rfmode=0
XM_66 AVDD n215 n215 AVDD sg13_lv_pmos L=2U W=7.46U AS=2.5364P AD=2.5364P PS=15.6U PD=15.6U rfmode=0
XM_67 AVDD n215 n215 AVDD sg13_lv_pmos L=2U W=7.46U AS=2.5364P AD=2.5364P PS=15.6U PD=15.6U rfmode=0
XM_68 AVDD n215 n215 AVDD sg13_lv_pmos L=2U W=7.46U AS=2.5364P AD=2.5364P PS=15.6U PD=15.6U rfmode=0
XM_69 AVDD n215 n215 AVDD sg13_lv_pmos L=2U W=7.46U AS=2.5364P AD=2.5364P PS=15.6U PD=15.6U rfmode=0
XM_70 AVDD n215 n142 AVDD sg13_lv_pmos L=2U W=7.46U AS=2.5364P AD=2.5364P PS=15.6U PD=15.6U rfmode=0
XM_71 AVDD n215 n142 AVDD sg13_lv_pmos L=2U W=7.46U AS=2.5364P AD=2.5364P PS=15.6U PD=15.6U rfmode=0
XM_72 AVDD n215 n142 AVDD sg13_lv_pmos L=2U W=7.46U AS=2.5364P AD=2.5364P PS=15.6U PD=15.6U rfmode=0
XM_73 AVDD n215 n142 AVDD sg13_lv_pmos L=2U W=7.46U AS=2.5364P AD=2.5364P PS=15.6U PD=15.6U rfmode=0
XM_74 AVDD n215 n142 AVDD sg13_lv_pmos L=2U W=7.46U AS=2.5364P AD=2.5364P PS=15.6U PD=15.6U rfmode=0
XM_75 AVDD n215 n142 AVDD sg13_lv_pmos L=2U W=7.46U AS=2.5364P AD=2.5364P PS=15.6U PD=15.6U rfmode=0
XM_76 AVDD n215 n142 AVDD sg13_lv_pmos L=2U W=7.46U AS=2.5364P AD=2.5364P PS=15.6U PD=15.6U rfmode=0
XM_77 AVDD n215 n142 AVDD sg13_lv_pmos L=2U W=7.46U AS=2.5364P AD=2.5364P PS=15.6U PD=15.6U rfmode=0
XM_78 n284 s[0] AVDD AVDD sg13_lv_pmos L=0.13U W=1.12U AS=0.3808P AD=0.2464P PS=2.92U PD=1.56U rfmode=0
XM_79 n283 s[1] n284 AVDD sg13_lv_pmos L=0.13U W=1.12U AS=0.2464P AD=0.2128P PS=1.56U PD=1.5U rfmode=0
XM_80 n277 s[2] n283 AVDD sg13_lv_pmos L=0.13U W=1.12U AS=0.2128P AD=0.3808P PS=1.5U PD=2.92U rfmode=0
XM_81 n285 s[3] AVDD AVDD sg13_lv_pmos L=0.13U W=1.12U AS=0.4032P AD=0.1176P PS=2.96U PD=1.33U rfmode=0
XM_82 n278 s[4] n285 AVDD sg13_lv_pmos L=0.13U W=1.12U AS=0.1176P AD=0.3808P PS=1.33U PD=2.92U rfmode=0
XM_83 n248 n222 n213 AVDD sg13_lv_pmos L=0.13U W=1.2U AS=0.408P AD=0.408P PS=3.08U PD=3.08U rfmode=0
XM_84 n222 n220 AVDD AVDD sg13_lv_pmos L=0.13U W=1.12U AS=0.3808P AD=0.3808P PS=2.92U PD=2.92U rfmode=0
XM_85 n249 n223 n213 AVDD sg13_lv_pmos L=0.13U W=0.9U AS=0.306P AD=0.306P PS=2.48U PD=2.48U rfmode=0
XM_86 n223 s[0] AVDD AVDD sg13_lv_pmos L=0.13U W=1.12U AS=0.3808P AD=0.3808P PS=2.92U PD=2.92U rfmode=0
XM_87 n250 n225 n213 AVDD sg13_lv_pmos L=0.13U W=0.6U AS=0.204P AD=0.204P PS=1.88U PD=1.88U rfmode=0
XM_88 n225 s[1] AVDD AVDD sg13_lv_pmos L=0.13U W=1.12U AS=0.3808P AD=0.3808P PS=2.92U PD=2.92U rfmode=0
XM_89 n251 n227 n213 AVDD sg13_lv_pmos L=0.13U W=0.54U AS=0.1836P AD=0.1836P PS=1.76U PD=1.76U rfmode=0
XM_90 n227 s[2] AVDD AVDD sg13_lv_pmos L=0.13U W=1.12U AS=0.3808P AD=0.3808P PS=2.92U PD=2.92U rfmode=0
XM_91 n252 n228 n213 AVDD sg13_lv_pmos L=0.13U W=0.54U AS=0.1836P AD=0.1836P PS=1.76U PD=1.76U rfmode=0
XM_92 n228 s[3] AVDD AVDD sg13_lv_pmos L=0.13U W=1.12U AS=0.3808P AD=0.3808P PS=2.92U PD=2.92U rfmode=0
XM_93 n253 n230 n213 AVDD sg13_lv_pmos L=0.13U W=0.54U AS=0.1836P AD=0.1836P PS=1.76U PD=1.76U rfmode=0
XM_94 n230 s[4] AVDD AVDD sg13_lv_pmos L=0.13U W=1.12U AS=0.3808P AD=0.3808P PS=2.92U PD=2.92U rfmode=0
XM_95 n281 n277 AVDD AVDD sg13_lv_pmos L=0.13U W=0.84U AS=0.2856P AD=0.1596P PS=2.36U PD=1.22U rfmode=0
XM_96 n281 n278 AVDD AVDD sg13_lv_pmos L=0.13U W=0.84U AS=0.1918P AD=0.1596P PS=1.5U PD=1.22U rfmode=0
XM_97 n220 n281 AVDD AVDD sg13_lv_pmos L=0.13U W=1.12U AS=0.1918P AD=0.3808P PS=1.5U PD=2.92U rfmode=0
XD_98 AVSS s[4] dantenna w=0.78u l=0.78u
XR_99 n4 n44 AVSS rhigh w=0.5u l=4.0u ps=0 b=0 m=1
XR_100 n10 AVSS AVSS rhigh w=0.5u l=15.0u ps=0 b=0 m=1
XR_101 VOUT n248 AVSS rhigh w=0.5u l=3.2u ps=0 b=0 m=1
XR_102 n251 n252 AVSS rhigh w=0.5u l=54.0u ps=0 b=0 m=1
XR_103 VIN n213 AVSS rhigh w=0.5u l=6.66u ps=0 b=0 m=1
XR_104 n250 n251 AVSS rhigh w=0.5u l=26.95u ps=0 b=0 m=1
XR_105 n249 n250 AVSS rhigh w=0.5u l=13.42u ps=0 b=0 m=1
XR_106 n248 n249 AVSS rhigh w=0.5u l=6.66u ps=0 b=0 m=1
XR_107 n273 n252 AVSS rhigh w=0.5u l=54.0u ps=0 b=0 m=1
XR_108 n273 n253 AVSS rhigh w=0.5u l=54.0u ps=0 b=0 m=1
XC_109 n33 VOUT cap_cmomi w=25e-6 l=25e-6 mmin=1 mmax=4 feed=double subblock=0 m=1
XC_110 n4 VOUT cap_cmomi w=25e-6 l=25e-6 mmin=1 mmax=4 feed=double subblock=0 m=1
XC_111 n4 VOUT cap_cmomi w=25e-6 l=25e-6 mmin=1 mmax=4 feed=double subblock=0 m=1
XC_112 n4 VOUT cap_cmomi w=25e-6 l=25e-6 mmin=1 mmax=4 feed=double subblock=0 m=1
XC_113 n4 VOUT cap_cmomi w=25e-6 l=25e-6 mmin=1 mmax=4 feed=double subblock=0 m=1
Cext_1 n10 n24 716.628a
Cext_2 n10 n25 31.7384a
Cext_3 n10 n26 3.38527a
Cext_4 n10 AVSS 961.281a
Cext_5 n10 IBIAS 0.100778a
Cext_6 n10 VSS 1.8725f
Cext_7 n100 n142 127.263a
Cext_8 n100 n145 156.124a
Cext_9 n100 n153 291.801a
Cext_10 n100 n196 432.592a
Cext_11 n100 n213 3.26468a
Cext_12 n100 n215 28.239a
Cext_13 n100 n24 18.9182a
Cext_14 n100 n25 188.755a
Cext_15 n100 n26 223.85a
Cext_16 n100 n33 20.8982a
Cext_17 n100 n44 570.314a
Cext_18 n100 n69 287.041a
Cext_19 n100 n86 20.1552a
Cext_20 n100 n93 7.01634a
Cext_21 n100 AVDD 2.35207f
Cext_22 n100 AVSS 273.99a
Cext_23 n100 IBIAS 120.683a
Cext_24 n100 VCM 164.463a
Cext_25 n100 VOUT 139.68a
Cext_26 n100 VSS 5.02711f
Cext_27 n142 n153 0.246446a
Cext_28 n142 n196 171.558a
Cext_29 n142 n213 2.01927f
Cext_30 n142 n215 3.39654f
Cext_31 n142 n26 652.757a
Cext_32 n142 n33 389.607a
Cext_33 n142 n44 121.569a
Cext_34 n142 n69 3.29571a
Cext_35 n142 n86 26.2082a
Cext_36 n142 AVDD 5.68631f
Cext_37 n142 s[3] 3.4374a
Cext_38 n142 VCM 1.60328f
Cext_39 n142 VOUT 291.004a
Cext_40 n142 VSS 4.00742f
Cext_41 n145 n153 34.6845a
Cext_42 n145 n215 16.0229a
Cext_43 n145 n24 13.4889a
Cext_44 n145 n25 5.39096a
Cext_45 n145 n44 7.15795a
Cext_46 n145 AVDD 860.018a
Cext_47 n145 IBIAS 0.232728a
Cext_48 n145 VCM 18.5073a
Cext_49 n145 VSS 1.59798f
Cext_50 n153 n196 599.226a
Cext_51 n153 n213 228.061a
Cext_52 n153 n215 1.99351f
Cext_53 n153 n24 1.45187f
Cext_54 n153 n25 1.90445f
Cext_55 n153 n26 6.12484a
Cext_56 n153 n44 647.093a
Cext_57 n153 AVDD 5.05127f
Cext_58 n153 AVSS 347.422a
Cext_59 n153 IBIAS 388.584a
Cext_60 n153 VCM 644.509a
Cext_61 n153 VIN 2.24668a
Cext_62 n153 VSS 19.5457f
Cext_63 n196 n213 325.257a
Cext_64 n196 n215 30.7402a
Cext_65 n196 n24 66.3079a
Cext_66 n196 n25 36.1299a
Cext_67 n196 n26 871.945a
Cext_68 n196 n33 929.372a
Cext_69 n196 n44 180.048a
Cext_70 n196 n69 522.541a
Cext_71 n196 n86 86.661a
Cext_72 n196 n93 105.49a
Cext_73 n196 AVDD 3.24579f
Cext_74 n196 AVSS 910.079a
Cext_75 n196 VCM 412.088a
Cext_76 n196 VOUT 75.4863a
Cext_77 n196 VSS 3.19723f
Cext_78 n213 n215 548.194a
Cext_79 n213 n220 384.598a
Cext_80 n213 n222 86.3181a
Cext_81 n213 n223 52.6685a
Cext_82 n213 n225 47.0633a
Cext_83 n213 n227 70.9045a
Cext_84 n213 n228 77.1806a
Cext_85 n213 n230 16.0868a
Cext_86 n213 n24 20.7164a
Cext_87 n213 n248 901.315a
Cext_88 n213 n249 311.514a
Cext_89 n213 n250 290.662a
Cext_90 n213 n251 293.599a
Cext_91 n213 n252 255.194a
Cext_92 n213 n253 148.274a
Cext_93 n213 n26 2.41397f
Cext_94 n213 n44 70.7607a
Cext_95 n213 AVDD 1.84074f
Cext_96 n213 AVSS 951.734a
Cext_97 n213 s[0] 274.446a
Cext_98 n213 s[1] 452.777a
Cext_99 n213 s[2] 836.248a
Cext_100 n213 s[3] 240.278a
Cext_101 n213 s[4] 448.387a
Cext_102 n213 VCM 8.99176a
Cext_103 n213 VIN 16.6244a
Cext_104 n213 VOUT 17.2982a
Cext_105 n213 VSS 17.4f
Cext_106 n215 n222 1.93763a
Cext_107 n215 n223 1.55087a
Cext_108 n215 n225 0.878709a
Cext_109 n215 n227 0.675214a
Cext_110 n215 n228 0.614975a
Cext_111 n215 n24 331.072a
Cext_112 n215 n25 24.2479a
Cext_113 n215 n26 3.11757a
Cext_114 n215 n33 5.7459a
Cext_115 n215 n44 45.2346a
Cext_116 n215 n69 0.375416a
Cext_117 n215 AVDD 16.4423f
Cext_118 n215 AVSS 990.186a
Cext_119 n215 IBIAS 702.849a
Cext_120 n215 s[0] 53.1992a
Cext_121 n215 s[1] 16.5748a
Cext_122 n215 s[2] 3.33186a
Cext_123 n215 s[3] 164.016a
Cext_124 n215 VCM 111.984a
Cext_125 n215 VIN 0.292923a
Cext_126 n215 VOUT 2.90086a
Cext_127 n215 VSS 42.2543f
Cext_128 n220 n222 86.8078a
Cext_129 n220 n248 54.0794a
Cext_130 n220 n277 20.1274a
Cext_131 n220 n278 25.8239a
Cext_132 n220 n281 87.5604a
Cext_133 n220 AVDD 205.133a
Cext_134 n220 AVSS 688.219a
Cext_135 n220 s[0] 553.065a
Cext_136 n220 s[1] 127.223a
Cext_137 n220 s[2] 127.061a
Cext_138 n220 s[3] 181.226a
Cext_139 n220 s[4] 938.804a
Cext_140 n220 VSS 2.22639f
Cext_141 n222 n248 23.2372a
Cext_142 n222 n249 2.59005a
Cext_143 n222 AVDD 216.479a
Cext_144 n222 AVSS 85.3167a
Cext_145 n222 s[0] 88.9916a
Cext_146 n222 s[1] 6.31963a
Cext_147 n222 s[2] 1.51556a
Cext_148 n222 s[3] 1.09981a
Cext_149 n222 s[4] 0.881791a
Cext_150 n222 VSS 871.924a
Cext_151 n223 n248 1.97174a
Cext_152 n223 n249 12.5716a
Cext_153 n223 AVDD 286.385a
Cext_154 n223 AVSS 87.4602a
Cext_155 n223 s[0] 82.9931a
Cext_156 n223 s[1] 13.2536a
Cext_157 n223 s[2] 1.46697a
Cext_158 n223 s[3] 1.07025a
Cext_159 n223 s[4] 0.86383a
Cext_160 n223 VSS 879.633a
Cext_161 n225 n248 2.03175a
Cext_162 n225 n250 10.9248a
Cext_163 n225 AVDD 203.483a
Cext_164 n225 AVSS 86.5386a
Cext_165 n225 s[1] 90.778a
Cext_166 n225 s[2] 52.8109a
Cext_167 n225 s[3] 18.2676a
Cext_168 n225 s[4] 0.909123a
Cext_169 n225 VSS 922.032a
Cext_170 n227 n248 1.97994a
Cext_171 n227 n251 11.1041a
Cext_172 n227 AVDD 234.188a
Cext_173 n227 AVSS 88.8779a
Cext_174 n227 s[2] 86.9843a
Cext_175 n227 s[3] 129.752a
Cext_176 n227 s[4] 3.1237a
Cext_177 n227 VSS 844.91a
Cext_178 n228 n248 1.66542a
Cext_179 n228 n252 30.0348a
Cext_180 n228 AVDD 239.075a
Cext_181 n228 AVSS 92.4463a
Cext_182 n228 s[3] 81.5561a
Cext_183 n228 s[4] 44.6356a
Cext_184 n228 VSS 823.906a
Cext_185 n230 n248 1.97994a
Cext_186 n230 n252 8.57318a
Cext_187 n230 n253 18.7116a
Cext_188 n230 AVDD 238.397a
Cext_189 n230 AVSS 88.8779a
Cext_190 n230 s[4] 81.6791a
Cext_191 n230 VSS 887.611a
Cext_192 n24 n25 206.568a
Cext_193 n24 n26 613.552a
Cext_194 n24 n33 412.218a
Cext_195 n24 n4 90.9399a
Cext_196 n24 n44 842.841a
Cext_197 n24 n69 4.36491a
Cext_198 n24 n86 487.033a
Cext_199 n24 AVDD 988.314a
Cext_200 n24 AVSS 1.74012f
Cext_201 n24 IBIAS 188.635a
Cext_202 n24 VCM 143.779a
Cext_203 n24 VOUT 33.4006a
Cext_204 n24 VSS 11.1789f
Cext_205 n248 n249 44.0818a
Cext_206 n248 n250 34.1024a
Cext_207 n248 n251 495.371a
Cext_208 n248 n252 798.12a
Cext_209 n248 n253 2.15095f
Cext_210 n248 n273 1.75293a
Cext_211 n248 n277 1.33751a
Cext_212 n248 n278 8.50653a
Cext_213 n248 n281 0.404319a
Cext_214 n248 AVDD 114.282a
Cext_215 n248 AVSS 89.0363a
Cext_216 n248 s[0] 8.96096a
Cext_217 n248 s[1] 769.463a
Cext_218 n248 s[2] 220.163a
Cext_219 n248 s[3] 105.63a
Cext_220 n248 s[4] 1.65916f
Cext_221 n248 VOUT 3.45582a
Cext_222 n248 VSS 6.70301f
Cext_223 n249 AVDD 8.61895a
Cext_224 n249 AVSS 6.58361a
Cext_225 n249 s[0] 17.8768a
Cext_226 n249 s[1] 19.8978a
Cext_227 n249 s[2] 4.42405a
Cext_228 n249 s[3] 3.22422a
Cext_229 n249 s[4] 2.42328a
Cext_230 n249 VSS 750.764a
Cext_231 n25 n26 1.12174f
Cext_232 n25 n33 1.11539f
Cext_233 n25 n44 4.15771a
Cext_234 n25 n69 116.618a
Cext_235 n25 n86 1.35607a
Cext_236 n25 n93 15.7279a
Cext_237 n25 AVDD 385.934a
Cext_238 n25 AVSS 3.14794f
Cext_239 n25 IBIAS 374.902a
Cext_240 n25 VCM 51.9279a
Cext_241 n25 VOUT 20.7743a
Cext_242 n25 VSS 11.1144f
Cext_243 n250 AVDD 2.02226a
Cext_244 n250 AVSS 2.31301a
Cext_245 n250 s[1] 32.6275a
Cext_246 n250 s[2] 19.6221a
Cext_247 n250 s[3] 3.48637a
Cext_248 n250 s[4] 2.07367a
Cext_249 n250 VSS 717.103a
Cext_250 n251 n252 0.333949a
Cext_251 n251 n273 14.5472a
Cext_252 n251 AVDD 1.28109a
Cext_253 n251 AVSS 0.837701a
Cext_254 n251 s[2] 34.7718a
Cext_255 n251 s[3] 14.2961a
Cext_256 n251 s[4] 267.521a
Cext_257 n251 VSS 2.86459f
Cext_258 n252 n253 410.321a
Cext_259 n252 AVDD 4.99803a
Cext_260 n252 s[3] 8.02116a
Cext_261 n252 s[4] 134.188a
Cext_262 n252 VSS 3.45672f
Cext_263 n253 AVDD 7.40299a
Cext_264 n253 s[4] 104.485a
Cext_265 n253 VSS 2.00532f
Cext_266 n26 n33 279.997a
Cext_267 n26 n4 3.22092a
Cext_268 n26 n44 205.061a
Cext_269 n26 n69 181.04a
Cext_270 n26 n86 76.1316a
Cext_271 n26 n93 0.531942a
Cext_272 n26 AVDD 276.26a
Cext_273 n26 AVSS 1.63266f
Cext_274 n26 IBIAS 0.249088a
Cext_275 n26 VCM 481.14a
Cext_276 n26 VOUT 4.38815a
Cext_277 n26 VSS 3.5021f
Cext_278 n273 s[4] 38.009a
Cext_279 n273 VSS 386.985a
Cext_280 n277 n278 309.834a
Cext_281 n277 n281 102.011a
Cext_282 n277 AVDD 199.683a
Cext_283 n277 AVSS 363.255a
Cext_284 n277 s[0] 45.1152a
Cext_285 n277 s[1] 162.598a
Cext_286 n277 s[2] 121.904a
Cext_287 n277 s[3] 27.8181a
Cext_288 n277 s[4] 47.4346a
Cext_289 n277 VSS 838.113a
Cext_290 n278 n281 211.095a
Cext_291 n278 AVDD 94.2403a
Cext_292 n278 AVSS 151.735a
Cext_293 n278 s[1] 0.768506a
Cext_294 n278 s[2] 1.74208a
Cext_295 n278 s[3] 76.2579a
Cext_296 n278 s[4] 186.969a
Cext_297 n278 VSS 450.595a
Cext_298 n281 AVDD 151.522a
Cext_299 n281 AVSS 22.4779a
Cext_300 n281 s[4] 0.708298a
Cext_301 n281 VSS 329.017a
Cext_302 n33 n4 2.11721a
Cext_303 n33 n44 457.03a
Cext_304 n33 n69 394.564a
Cext_305 n33 n86 257.825a
Cext_306 n33 AVDD 259.835a
Cext_307 n33 AVSS 1.304f
Cext_308 n33 VCM 2.07166f
Cext_309 n33 VOUT 1.39271f
Cext_310 n33 VSS 3.59417f
Cext_311 n4 n44 161.589a
Cext_312 n4 n86 1.50158a
Cext_313 n4 AVSS 1.04249f
Cext_314 n4 VOUT 805.36a
Cext_315 n4 VSS 3.0166f
Cext_316 n44 n69 1.14014f
Cext_317 n44 n86 795.339a
Cext_318 n44 AVDD 2.59647f
Cext_319 n44 AVSS 681.318a
Cext_320 n44 VCM 309.991a
Cext_321 n44 VOUT 1.52886f
Cext_322 n44 VSS 8.9021f
Cext_323 n69 n86 396.181a
Cext_324 n69 n93 78.379a
Cext_325 n69 AVDD 491.762a
Cext_326 n69 AVSS 1.22414f
Cext_327 n69 IBIAS 177.671a
Cext_328 n69 VCM 36.3815a
Cext_329 n69 VOUT 937.516a
Cext_330 n69 VSS 3.6815f
Cext_331 n86 AVDD 1.86545f
Cext_332 n86 AVSS 370.674a
Cext_333 n86 VCM 11.1852a
Cext_334 n86 VOUT 226.71a
Cext_335 n86 VSS 6.63988f
Cext_336 n93 AVSS 486.445a
Cext_337 n93 IBIAS 15.8842a
Cext_338 n93 VSS 666.921a
Cext_339 AVDD AVSS 1.53353f
Cext_340 AVDD IBIAS 3.55288a
Cext_341 AVDD s[0] 434.794a
Cext_342 AVDD s[1] 208.452a
Cext_343 AVDD s[2] 184.608a
Cext_344 AVDD s[3] 672.964a
Cext_345 AVDD s[4] 218.141a
Cext_346 AVDD VCM 651.897a
Cext_347 AVDD VOUT 1.22741f
Cext_348 AVDD VSS 42.9219f
Cext_349 AVSS IBIAS 2.77241f
Cext_350 AVSS s[0] 781.599a
Cext_351 AVSS s[1] 707.211a
Cext_352 AVSS s[2] 508.695a
Cext_353 AVSS s[3] 1.58304f
Cext_354 AVSS s[4] 668.703a
Cext_355 AVSS VCM 1.04573a
Cext_356 AVSS VOUT 1.01542f
Cext_357 AVSS VSS 40.4838f
Cext_358 IBIAS VSS 7.99354f
Cext_359 s[0] s[1] 612.561a
Cext_360 s[0] s[2] 59.305a
Cext_361 s[0] s[3] 59.1937a
Cext_362 s[0] s[4] 81.7711a
Cext_363 s[1] s[2] 3.46815f
Cext_364 s[1] s[3] 55.9532a
Cext_365 s[1] s[4] 70.9836a
Cext_366 s[2] s[3] 4.64372f
Cext_367 s[2] s[4] 83.5235a
Cext_368 s[3] s[4] 3.82605f
Cext_369 VCM VIN 26.4143a
Cext_370 VCM VOUT 164.907a
Cext_371 VCM VSS 8.97835f
Cext_372 VIN VSS 852.468a
Cext_373 VOUT VSS 14.4199f
Cext_374 VSS s[0] 2.9844f
Cext_375 VSS s[1] 2.41896f
Cext_376 VSS s[2] 3.12444f
Cext_377 VSS s[3] 3.86703f
Cext_378 VSS s[4] 6.05347f
.ends gain_stage
