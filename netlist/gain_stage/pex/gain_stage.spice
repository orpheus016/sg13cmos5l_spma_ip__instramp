** post-layout RC netlist of gain_stage: Magic extresist -> ngspice by scripts/pex_netlist.py --magic (source: /foss/designs/sg13cmos5l_spma_ip__instramp/runs/pex/gain_stage/magic/raw.spice)
.subckt gain_stage AVDD AVSS IBIAS VIN VCM VOUT s[0] s[1] s[2] s[3] s[4]
X0 AVDD_t40 pn35_t4 pn35_t5 AVDD_t39 sg13_lv_pmos ad=2.5364p pd=15.6u as=2.5364p ps=15.6u w=7.46u l=2u
X1 AVDD_t27 pn16_t0 pn16_t1 AVDD_t26 sg13_lv_pmos ad=0.782p pd=5.28u as=0.782p ps=5.28u w=2.3u l=2u
X2 AVDD_t56 pn35_t16 pn29_t5 AVDD_t51 sg13_lv_pmos ad=2.5364p pd=15.6u as=2.5364p ps=15.6u w=7.46u l=2u
X3 pn37 s[1]_t2 pn36 AVDD_t0 sg13_lv_pmos ad=0.2128p pd=1.5u as=0.2464p ps=1.56u w=1.12u l=0.13u
X4 pn28_t0 pn4_t0 AVSS_t25 rhigh l=54u w=0.5u ps=0 b=0 m=1
X5 AVDD_t37 pn35_t12 pn35_t13 AVDD_t26 sg13_lv_pmos ad=2.5364p pd=15.6u as=2.5364p ps=15.6u w=7.46u l=2u
X6 pn33_t1 pn33_t0 pn13_t0 AVSS_t43 sg13_lv_nmos ad=0.2856p pd=2.36u as=0.2856p ps=2.36u w=0.84u l=0.5u
X7 pn7 s[0]_t2 AVSS_t32 AVSS_t0 sg13_lv_nmos ad=0.1694p pd=1.21u as=0.2618p ps=2.22u w=0.77u l=0.13u
X8 pn4 s[4]_t1 pn17_t1 AVSS_t17 sg13_lv_nmos ad=0.1026p pd=1.34u as=0.1026p ps=1.34u w=0.18u l=0.13u
X9 pn3_t2 pn19 pn17_t10 AVDD_t4 sg13_lv_pmos ad=0.1836p pd=1.76u as=0.1836p ps=1.76u w=0.54u l=0.13u
X10 AVDD_t65 pn32_t5 VOUT_t2 AVDD_t64 sg13_lv_pmos ad=1.887p pd=11.78u as=1.0545p ps=5.93u w=5.55u l=0.5u
X11 pn29_t12 VCM_t0 pn31 AVDD_t30 sg13_lv_pmos ad=1.2616p pd=7.02u as=1.2616p ps=7.02u w=6.64u l=2u
X12 AVSS_t12 s[4]_t2 dantenna l=0.78u w=0.78u
X13 pn20_t1 s[4]_t0 AVSS_t15 AVSS_t14 sg13_lv_nmos ad=0.2516p pd=2.16u as=0.2516p ps=2.16u w=0.74u l=0.13u
X14 pn5_t1 pn24 pn17_t6 AVDD_t15 sg13_lv_pmos ad=0.408p pd=3.08u as=0.408p ps=3.08u w=1.2u l=0.13u
X15 pn29_t9 pn17_t12 pn34 AVDD_t30 sg13_lv_pmos ad=1.2616p pd=7.02u as=1.2616p ps=7.02u w=6.64u l=2u
X16 AVDD_t53 pn35_t19 pn29_t3 AVDD_t51 sg13_lv_pmos ad=2.5364p pd=15.6u as=2.5364p ps=15.6u w=7.46u l=2u
X17 pn5_t2 VOUT_t3 AVSS_t63 rhigh l=3.2u w=0.5u ps=0 b=0 m=1
X18 AVSS_t50 pn11_t4 pn34_t2 AVSS_t49 sg13_lv_nmos ad=3.1314p pd=19.1u as=3.1314p ps=19.1u w=9.21u l=2u
X19 AVDD_t50 pn35_t21 pn29_t1 AVDD_t49 sg13_lv_pmos ad=2.5364p pd=15.6u as=2.5364p ps=15.6u w=7.46u l=2u
X20 VOUT_t1 pn32_t5 AVDD_t61 AVDD_t60 sg13_lv_pmos ad=1.0545p pd=5.93u as=1.887p ps=11.78u w=5.55u l=0.5u
X21 pn16_t2 IBIAS_t5 AVSS_t54 AVSS_t53 sg13_lv_nmos ad=0.2958p pd=2.42u as=0.2958p ps=2.42u w=0.87u l=2u
X22 pn20_t0 s[4]_t0 AVDD_t7 AVDD_t6 sg13_lv_pmos ad=0.3808p pd=2.92u as=0.3808p ps=2.92u w=1.12u l=0.13u
X23 pn11_t1 pn16_t3 AVDD_t23 AVDD_t19 sg13_lv_pmos ad=1.0925p pd=6.13u as=1.0925p ps=6.13u w=5.75u l=2u
X24 AVDD_t52 pn35_t20 pn29_t0 AVDD_t51 sg13_lv_pmos ad=2.5364p pd=15.6u as=2.5364p ps=15.6u w=7.46u l=2u
X25 AVDD_t32 pn35_t23 pn29_t6 AVDD_t31 sg13_lv_pmos ad=2.5364p pd=15.6u as=2.5364p ps=15.6u w=7.46u l=2u
X26 pn17 VIN_t0 AVSS_t11 rhigh l=6.66u w=0.5u ps=0 b=0 m=1
X27 AVSS_t16 s[4]_t3 pn6 AVSS_t8 sg13_lv_nmos ad=0.2516p pd=2.16u as=0.1406p ps=1.12u w=0.74u l=0.13u
X28 pn30_t0 pn14 pn14_t0 AVDD_t26 sg13_lv_pmos ad=0.748p pd=5.08u as=0.748p ps=5.08u w=2.2u l=0.5u
X29 pn11_t2 pn11 AVSS_t48 AVSS_t47 sg13_lv_nmos ad=3.1314p pd=19.1u as=3.1314p ps=19.1u w=9.21u l=2u
X30 pn34 pn17_t12 pn29_t10 AVDD_t30 sg13_lv_pmos ad=1.2616p pd=7.02u as=2.2576p ps=13.96u w=6.64u l=2u
X31 pn27_t2 pn18 pn17_t9 AVDD_t8 sg13_lv_pmos ad=0.1836p pd=1.76u as=0.1836p ps=1.76u w=0.54u l=0.13u
X32 pn28 pn3_t1 AVSS_t30 rhigh l=54u w=0.5u ps=0 b=0 m=1
X33 AVDD_t54 pn35_t18 pn29_t4 AVDD_t51 sg13_lv_pmos ad=2.5364p pd=15.6u as=2.5364p ps=15.6u w=7.46u l=2u
X34 pn31_t2 pn11_t3 AVSS_t46 AVSS_t45 sg13_lv_nmos ad=3.1314p pd=19.1u as=3.1314p ps=19.1u w=9.21u l=2u
X35 pn19_t1 s[3]_t0 AVSS_t7 AVSS_t6 sg13_lv_nmos ad=0.2516p pd=2.16u as=0.2516p ps=2.16u w=0.74u l=0.13u
X36 pn32_t2 pn33_t2 pn2_t0 AVSS_t44 sg13_lv_nmos ad=0.2856p pd=2.36u as=0.2856p ps=2.36u w=0.84u l=0.5u
X37 AVDD_t44 pn35_t0 pn35_t1 AVDD_t43 sg13_lv_pmos ad=2.5364p pd=15.6u as=2.5364p ps=15.6u w=7.46u l=2u
X38 AVSS_t29 pn6_t1 pn9 AVSS_t64 sg13_lv_nmos ad=0.1331p pd=1.12u as=0.1216p ps=1.02u w=0.64u l=0.13u
X39 VOUT_t0 pn2_t2 AVSS_t52 AVSS_t51 sg13_lv_nmos ad=2.856p pd=17.48u as=2.856p ps=17.48u w=8.4u l=0.5u
X40 pn22_t0 s[1]_t0 AVSS_t4 AVSS_t3 sg13_lv_nmos ad=0.2516p pd=2.16u as=0.2516p ps=2.16u w=0.74u l=0.13u
X41 pn24_t0 pn23_t2 AVSS_t38 AVSS_t37 sg13_lv_nmos ad=0.2516p pd=2.16u as=0.2516p ps=2.16u w=0.74u l=0.13u
X42 pn31_t0 VCM_t0 pn29_t12 AVDD_t30 sg13_lv_pmos ad=1.2616p pd=7.02u as=1.2616p ps=7.02u w=6.64u l=2u
X43 pn6_t0 s[4]_t3 pn38 AVDD_t0 sg13_lv_pmos ad=0.3808p pd=2.92u as=0.1176p ps=1.33u w=1.12u l=0.13u
X44 pn7_t0 s[2]_t2 AVSS_t1 AVSS_t0 sg13_lv_nmos ad=0.2618p pd=2.22u as=0.1463p ps=1.15u w=0.77u l=0.13u
X45 pn26_t2 pn22 pn17_t7 AVDD_t1 sg13_lv_pmos ad=0.204p pd=1.88u as=0.204p ps=1.88u w=0.6u l=0.13u
X46 AVDD_t38 pn35_t10 pn35_t11 AVDD_t17 sg13_lv_pmos ad=2.5364p pd=15.6u as=2.5364p ps=15.6u w=7.46u l=2u
X47 AVSS_t27 pn1_t0 AVSS_t26 rhigh l=15u w=0.5u ps=0 b=0 m=1
X48 pn29_t8 pn17_t12 pn34_t1 AVDD_t30 sg13_lv_pmos ad=2.2576p pd=13.96u as=1.2616p ps=7.02u w=6.64u l=2u
X49 pn19_t0 s[3]_t0 AVDD_t5 AVDD_t4 sg13_lv_pmos ad=0.3808p pd=2.92u as=0.3808p ps=2.92u w=1.12u l=0.13u
X50 pn34_t1 pn17_t12 pn29_t9 AVDD_t30 sg13_lv_pmos ad=1.2616p pd=7.02u as=1.2616p ps=7.02u w=6.64u l=2u
X51 pn13_t1 pn13 AVSS_t42 AVSS_t41 sg13_lv_nmos ad=0.714p pd=4.88u as=0.714p ps=4.88u w=2.1u l=0.5u
X52 pn25_t2 pn21 pn17_t8 AVDD_t13 sg13_lv_pmos ad=0.306p pd=2.48u as=0.306p ps=2.48u w=0.9u l=0.13u
X53 pn22_t1 s[1]_t0 AVDD_t2 AVDD_t1 sg13_lv_pmos ad=0.3808p pd=2.92u as=0.3808p ps=2.92u w=1.12u l=0.13u
X54 pn24_t1 pn23_t2 AVDD_t16 AVDD_t15 sg13_lv_pmos ad=0.3808p pd=2.92u as=0.3808p ps=2.92u w=1.12u l=0.13u
X55 AVDD_t11 pn6_t1 pn8_t0 AVDD_t10 sg13_lv_pmos ad=0.1918p pd=1.5u as=0.1596p ps=1.22u w=0.84u l=0.13u
X56 pn36 s[0]_t2 AVDD_t12 AVDD_t0 sg13_lv_pmos ad=0.2464p pd=1.56u as=0.3808p ps=2.92u w=1.12u l=0.13u
X57 pn21_t0 s[0]_t0 AVSS_t35 AVSS_t34 sg13_lv_nmos ad=0.2516p pd=2.16u as=0.2516p ps=2.16u w=0.74u l=0.13u
X58 pn6 s[3]_t2 AVSS_t9 AVSS_t8 sg13_lv_nmos ad=0.1406p pd=1.12u as=0.2516p ps=2.16u w=0.74u l=0.13u
X59 pn27_t1 s[2]_t1 pn17_t3 AVSS_t22 sg13_lv_nmos ad=0.1026p pd=1.34u as=0.1026p ps=1.34u w=0.18u l=0.13u
X60 AVDD_t18 pn16_t5 pn33 AVDD_t17 sg13_lv_pmos ad=1.564p pd=9.88u as=1.564p ps=9.88u w=4.6u l=2u
X61 AVDD_t42 pn35_t2 pn35_t3 AVDD_t41 sg13_lv_pmos ad=2.5364p pd=15.6u as=2.5364p ps=15.6u w=7.46u l=2u
X62 AVDD_t36 pn35_t6 pn35_t7 AVDD_t35 sg13_lv_pmos ad=2.5364p pd=15.6u as=2.5364p ps=15.6u w=7.46u l=2u
X63 AVDD_t62 pn32_t5 VOUT_t1 AVDD_t31 sg13_lv_pmos ad=1.0545p pd=5.93u as=1.0545p ps=5.93u w=5.55u l=0.5u
X64 pn5 pn23 pn17_t5 AVSS_t36 sg13_lv_nmos ad=0.136p pd=1.48u as=0.136p ps=1.48u w=0.4u l=0.13u
X65 pn38 s[3]_t2 AVDD_t3 AVDD_t0 sg13_lv_pmos ad=0.1176p pd=1.33u as=0.4032p ps=2.96u w=1.12u l=0.13u
X66 pn14_t1 IBIAS_t4 AVSS_t58 AVSS_t57 sg13_lv_nmos ad=0.5916p pd=4.16u as=0.5916p ps=4.16u w=1.74u l=2u
X67 pn21_t1 s[0]_t0 AVDD_t14 AVDD_t13 sg13_lv_pmos ad=0.3808p pd=2.92u as=0.3808p ps=2.92u w=1.12u l=0.13u
X68 AVSS_t60 IBIAS_t0 IBIAS_t1 AVSS_t59 sg13_lv_nmos ad=0.2958p pd=2.42u as=0.2958p ps=2.42u w=0.87u l=2u
X69 AVDD_t68 pn15 pn32_t4 AVDD_t66 sg13_lv_pmos ad=2.4922p pd=15.34u as=2.4922p ps=15.34u w=7.33u l=2u
X70 AVDD_t25 pn16 pn32 AVDD_t24 sg13_lv_pmos ad=3.1314p pd=19.1u as=3.1314p ps=19.1u w=9.21u l=2u
X71 VOUT_t2 pn32_t5 AVDD_t62 AVDD_t63 sg13_lv_pmos ad=1.0545p pd=5.93u as=1.0545p ps=5.93u w=5.55u l=0.5u
X72 pn5_t0 pn25 AVSS_t18 rhigh l=6.66u w=0.5u ps=0 b=0 m=1
X73 pn9 pn7_t2 pn8 AVSS_t64 sg13_lv_nmos ad=0.1216p pd=1.02u as=0.2176p ps=1.96u w=0.64u l=0.13u
X74 pn27 pn3_t0 AVSS_t19 rhigh l=54u w=0.5u ps=0 b=0 m=1
X75 pn4_t1 pn20 pn17_t11 AVDD_t6 sg13_lv_pmos ad=0.1836p pd=1.76u as=0.1836p ps=1.76u w=0.54u l=0.13u
X76 pn26_t1 s[1]_t1 pn17_t4 AVSS_t2 sg13_lv_nmos ad=0.104p pd=1.34u as=0.104p ps=1.34u w=0.2u l=0.13u
X77 pn15_t0 pn10_t3 pn34_t0 AVSS_t40 sg13_lv_nmos ad=2.1794p pd=13.5u as=2.1794p ps=13.5u w=6.41u l=2u
X78 pn10_t0 pn16_t4 AVDD_t21 AVDD_t19 sg13_lv_pmos ad=1.0925p pd=6.13u as=1.955p ps=12.18u w=5.75u l=2u
X79 AVSS_t1 s[1]_t2 pn7 AVSS_t0 sg13_lv_nmos ad=0.1463p pd=1.15u as=0.1694p ps=1.21u w=0.77u l=0.13u
X80 pn11_t0 pn16_t3 AVDD_t29 AVDD_t19 sg13_lv_pmos ad=1.0925p pd=6.13u as=1.955p ps=12.18u w=5.75u l=2u
X81 pn25_t1 pn26 AVSS_t20 rhigh l=13.42u w=0.5u ps=0 b=0 m=1
X82 pn8_t0 pn7_t2 AVDD_t70 AVDD_t10 sg13_lv_pmos ad=0.1596p pd=1.22u as=0.2856p ps=2.36u w=0.84u l=0.13u
X83 AVDD_t34 pn35_t14 pn35 AVDD_t33 sg13_lv_pmos ad=2.5364p pd=15.6u as=2.5364p ps=15.6u w=7.46u l=2u
X84 pn23_t1 pn8_t1 AVDD_t11 AVDD_t10 sg13_lv_pmos ad=0.3808p pd=2.92u as=0.1918p ps=1.5u w=1.12u l=0.13u
X85 pn23_t0 pn8_t1 AVSS_t29 AVSS_t28 sg13_lv_nmos ad=0.2516p pd=2.16u as=0.1331p ps=1.12u w=0.74u l=0.13u
X86 pn2 IBIAS_t2 AVSS_t62 AVSS_t61 sg13_lv_nmos ad=1.088p pd=7.08u as=1.088p ps=7.08u w=3.2u l=2u
X87 pn25_t0 s[0]_t1 pn17_t0 AVSS_t33 sg13_lv_nmos ad=0.102p pd=1.28u as=0.102p ps=1.28u w=0.3u l=0.13u
X88 AVDD_t22 pn16_t3 pn11_t1 AVDD_t19 sg13_lv_pmos ad=1.955p pd=12.18u as=1.0925p ps=6.13u w=5.75u l=2u
X89 AVDD_t55 pn35_t17 pn29_t7 AVDD_t51 sg13_lv_pmos ad=2.5364p pd=15.6u as=2.5364p ps=15.6u w=7.46u l=2u
X90 pn7_t1 s[2]_t2 pn37 AVDD_t0 sg13_lv_pmos ad=0.3808p pd=2.92u as=0.2128p ps=1.5u w=1.12u l=0.13u
X91 pn35_t15 IBIAS_t3 AVSS_t56 AVSS_t55 sg13_lv_nmos ad=2.04p pd=12.68u as=2.04p ps=12.68u w=6u l=2u
X92 AVDD_t59 pn30_t1 pn30_t2 AVDD_t58 sg13_lv_pmos ad=1.887p pd=11.78u as=1.887p ps=11.78u w=5.55u l=0.5u
X93 pn18_t0 s[2]_t0 AVSS_t24 AVSS_t23 sg13_lv_nmos ad=0.2516p pd=2.16u as=0.2516p ps=2.16u w=0.74u l=0.13u
X94 pn32_t3 pn14_t2 pn2_t1 AVDD_t57 sg13_lv_pmos ad=0.748p pd=5.08u as=0.748p ps=5.08u w=2.2u l=0.5u
X95 pn32_t1 pn12 AVSS_t31 rhigh l=4u w=0.5u ps=0 b=0 m=1
X96 pn26_t0 pn27_t0 AVSS_t5 rhigh l=26.95u w=0.5u ps=0 b=0 m=1
X97 pn31 VCM_t0 pn29 AVDD_t30 sg13_lv_pmos ad=1.2616p pd=7.02u as=2.2576p ps=13.96u w=6.64u l=2u
X98 AVDD_t46 pn35_t8 pn35_t9 AVDD_t45 sg13_lv_pmos ad=2.5364p pd=15.6u as=2.5364p ps=15.6u w=7.46u l=2u
X99 pn18_t1 s[2]_t0 AVDD_t9 AVDD_t8 sg13_lv_pmos ad=0.3808p pd=2.92u as=0.3808p ps=2.92u w=1.12u l=0.13u
X100 pn3 s[3]_t1 pn17_t2 AVSS_t10 sg13_lv_nmos ad=0.1026p pd=1.34u as=0.1026p ps=1.34u w=0.18u l=0.13u
X101 pn10_t1 pn10 pn1 AVSS_t39 sg13_lv_nmos ad=0.544p pd=3.88u as=0.544p ps=3.88u w=1.6u l=2u
X102 pn31_t1 pn10_t2 pn32_t0 AVSS_t40 sg13_lv_nmos ad=2.1794p pd=13.5u as=2.1794p ps=13.5u w=6.41u l=2u
X103 pn29_t11 VCM_t0 pn31_t0 AVDD_t30 sg13_lv_pmos ad=2.2576p pd=13.96u as=1.2616p ps=7.02u w=6.64u l=2u
X104 AVDD_t20 pn16_t4 pn10_t0 AVDD_t19 sg13_lv_pmos ad=1.955p pd=12.18u as=1.0925p ps=6.13u w=5.75u l=2u
X105 AVDD_t23 pn16_t3 pn11_t0 AVDD_t19 sg13_lv_pmos ad=1.0925p pd=6.13u as=1.0925p ps=6.13u w=5.75u l=2u
X106 AVDD_t48 pn35_t22 pn29_t2 AVDD_t47 sg13_lv_pmos ad=2.5364p pd=15.6u as=2.5364p ps=15.6u w=7.46u l=2u
X107 AVDD_t67 pn15_t1 pn15_t2 AVDD_t66 sg13_lv_pmos ad=2.4922p pd=15.34u as=2.4922p ps=15.34u w=7.33u l=2u
R0 pn1 pn1_t0 51.8954
R1 pn13_n0 pn13_t0 17.8873
R2 pn13 pn13_n0 15.3273
R3 pn13_n0 pn13_t1 2.94632
R4 IBIAS_n0 IBIAS_t3 25.7258
R5 IBIAS IBIAS_n4 20.8237
R6 IBIAS_t5 IBIAS_t4 16.8947
R7 IBIAS_t0 IBIAS_t5 16.8903
R8 IBIAS_t0 IBIAS_n2 15.0005
R9 IBIAS_t3 IBIAS_t2 14.0016
R10 IBIAS_n4 IBIAS_n3 9.07096
R11 IBIAS_n1 IBIAS_n0 9.0005
R12 IBIAS_n2 IBIAS_t1 8.81129
R13 IBIAS_n3 IBIAS_t0 7.49231
R14 IBIAS_n3 IBIAS_n1 0.108892
R15 IBIAS_n4 IBIAS_n0 0.0389734
R16 IBIAS_n2 IBIAS_n1 0.0152561
R17 pn15_n0 pn15_t0 23.0361
R18 pn15 pn15_n1 5.15561
R19 pn15_n1 pn15_t1 4.56061
R20 pn15_n0 pn15_t2 1.82304
R21 pn15_n1 pn15_n0 0.5912
R22 pn31_n1 pn31_n0 21.5278
R23 pn31_n0 pn31_t1 3.90449
R24 pn31_n1 pn31_t0 3.54264
R25 pn31 pn31_n1 2.48315
R26 pn31_n0 pn31_t2 1.16531
R27 VCM VCM_n5 14.4382
R28 VCM_n2 VCM_t0 12.7904
R29 VCM_n3 VCM_n0 9.0912
R30 VCM_n2 VCM_n1 9.05697
R31 VCM_n1 VCM_n0 9.0137
R32 VCM_n5 VCM_n4 9.0005
R33 VCM_n3 VCM_n2 4.52153
R34 VCM_n4 VCM_n1 0.0775
R35 VCM_n4 VCM_n3 0.0388129
R36 VCM_n5 VCM_n0 0.00123333
R37 pn30_n1 pn30_n0 18.0729
R38 pn30_n0 pn30_t1 16.3396
R39 pn30_n0 pn30_t2 0.70323
R40 pn30 pn30_n1 0.00240162
R41 pn30_n1 pn30_t0 0.00159825
R42 pn11_n2 pn11_n0 22.354
R43 pn11_n2 pn11_n1 14.2797
R44 pn11_n0 pn11_t3 6.97267
R45 pn11_n0 pn11_t4 6.15134
R46 pn11 pn11_n3 5.64783
R47 pn11_n1 pn11_t1 3.66242
R48 pn11_n1 pn11_t0 3.54172
R49 pn11_n3 pn11_n2 2.93385
R50 pn11_n3 pn11_t2 0.193778
R51 pn2_n1 pn2_t1 37.3573
R52 pn2 pn2_n1 35.7213
R53 pn2_n0 pn2_t2 24.0005
R54 pn2_n0 pn2_t0 13.562
R55 pn2_n1 pn2_n0 4.80997
R56 pn14_n0 pn14_t2 95.3284
R57 pn14_n1 pn14_n0 20.1156
R58 pn14_n0 pn14_t1 16.1539
R59 pn14 pn14_n1 15.0005
R60 pn14_n1 pn14_t0 3.64157
R61 pn32 pn32_n4 44.5178
R62 pn32_n1 pn32_t2 27.6562
R63 pn32_n0 pn32_t1 24.3167
R64 pn32_n0 pn32_t0 23.4573
R65 pn32_n2 pn32_t4 21.8369
R66 pn32_n3 pn32_n2 20.8686
R67 pn32_n4 pn32_n3 19.9402
R68 pn32_n4 pn32_t5 11.401
R69 pn32_n3 pn32_t3 4.69053
R70 pn32_n2 pn32_n1 0.523367
R71 pn32_n1 pn32_n0 0.391367
R72 VOUT_n2 VOUT_n1 126.001
R73 VOUT_n2 VOUT_t3 39.3356
R74 VOUT_n1 VOUT_n0 21.3188
R75 VOUT_n0 VOUT_t2 2.71311
R76 VOUT_n1 VOUT_t0 2.66642
R77 VOUT_n0 VOUT_t1 2.3407
R78 VOUT VOUT_n2 0.571033
R79 pn34_n0 pn34_t0 25.8137
R80 pn34_n1 pn34_n0 23.557
R81 pn34_n1 pn34_t1 2.66105
R82 pn34 pn34_n1 1.61005
R83 pn34_n0 pn34_t2 1.17702
R84 VIN VIN_t0 19.1015
R85 pn10_n1 pn10_t0 47.2302
R86 pn10_n1 pn10_n0 37.4277
R87 pn10_n0 pn10_t2 6.78973
R88 pn10_n0 pn10_t3 6.47445
R89 pn10_n2 pn10_t1 4.23839
R90 pn10 pn10_n2 4.22391
R91 pn10_n2 pn10_n1 1.85858
R92 pn33 pn33_n1 65.8331
R93 pn33_n1 pn33_t2 63.1062
R94 pn33_n1 pn33_n0 23.8719
R95 pn33_n0 pn33_t0 15.2505
R96 pn33_n0 pn33_t1 8.50305
R97 pn16_n4 pn16_t2 25.9904
R98 pn16_n5 pn16_t5 15.4267
R99 pn16_n4 pn16_n3 12.9235
R100 pn16_n6 pn16_n5 9.44417
R101 pn16_n1 pn16_n0 9.07539
R102 pn16_n8 pn16_n1 9.05326
R103 pn16_n7 pn16_n6 9.0005
R104 pn16_t5 pn16_n2 7.16221
R105 pn16_n2 pn16_t3 5.80793
R106 pn16 pn16_n8 5.0034
R107 pn16 pn16_n0 4.99428
R108 pn16_n3 pn16_t1 3.79089
R109 pn16_n3 pn16_t0 2.48849
R110 pn16_n2 pn16_t4 2.46963
R111 pn16_n5 pn16_n4 0.648767
R112 pn16_n7 pn16_n0 0.108864
R113 pn16_n8 pn16_n7 0.0942444
R114 pn16_n6 pn16_n1 0.00343333
R115 pn29_n9 pn29_n8 15.89
R116 pn29_n10 pn29_n9 11.3042
R117 pn29_n10 pn29_t11 5.49431
R118 pn29 pn29_n10 5.49195
R119 pn29_n0 pn29_t10 5.40847
R120 pn29_n0 pn29_t8 5.40838
R121 pn29_n2 pn29_t5 4.12156
R122 pn29_n8 pn29_t6 2.26694
R123 pn29_n6 pn29_t1 2.13536
R124 pn29_n4 pn29_t3 2.13524
R125 pn29_n7 pn29_t2 2.13506
R126 pn29_n3 pn29_t4 2.1347
R127 pn29_n5 pn29_t0 2.13469
R128 pn29_n2 pn29_t7 2.13394
R129 pn29_n7 pn29_n6 1.98738
R130 pn29_n6 pn29_n5 1.98738
R131 pn29_n5 pn29_n4 1.98738
R132 pn29_n4 pn29_n3 1.98738
R133 pn29_n3 pn29_n2 1.98738
R134 pn29_n10 pn29_t12 1.72344
R135 pn29_n9 pn29_n1 1.64649
R136 pn29_n8 pn29_n7 1.38512
R137 pn29_n1 pn29_t9 1.17119
R138 pn29_n1 pn29_n0 0.40018
R139 pn35_n6 pn35_t15 48.9991
R140 pn35_n22 pn35_t14 4.95984
R141 pn35_t14 pn35_n21 4.95984
R142 pn35_n0 pn35_t9 4.12295
R143 pn35_n23 pn35_n5 3.81591
R144 pn35_n14 pn35_n13 3.36038
R145 pn35_n7 pn35_t16 3.20148
R146 pn35_n14 pn35_t8 2.42277
R147 pn35_n13 pn35_t23 2.42272
R148 pn35_n20 pn35_t6 2.41279
R149 pn35_n19 pn35_t12 2.41279
R150 pn35_n18 pn35_t10 2.41279
R151 pn35_n17 pn35_t4 2.41279
R152 pn35_n16 pn35_t2 2.41279
R153 pn35_n15 pn35_t0 2.41279
R154 pn35_n12 pn35_t22 2.41279
R155 pn35_n11 pn35_t21 2.41279
R156 pn35_n10 pn35_t20 2.41279
R157 pn35_n9 pn35_t19 2.41279
R158 pn35_n8 pn35_t18 2.41279
R159 pn35_n7 pn35_t17 2.41279
R160 pn35_n23 pn35_n22 2.37189
R161 pn35_n5 pn35_t7 2.13624
R162 pn35_n4 pn35_t13 2.13584
R163 pn35_n3 pn35_t11 2.13483
R164 pn35_n2 pn35_t5 2.13473
R165 pn35_n1 pn35_t3 2.13472
R166 pn35_n0 pn35_t1 2.13405
R167 pn35_n5 pn35_n4 1.98738
R168 pn35_n4 pn35_n3 1.98738
R169 pn35_n3 pn35_n2 1.98738
R170 pn35_n2 pn35_n1 1.98738
R171 pn35_n1 pn35_n0 1.98738
R172 pn35_n20 pn35_n19 0.790191
R173 pn35_n19 pn35_n18 0.790191
R174 pn35_n18 pn35_n17 0.790191
R175 pn35_n17 pn35_n16 0.790191
R176 pn35_n16 pn35_n15 0.790191
R177 pn35_n12 pn35_n11 0.790191
R178 pn35_n11 pn35_n10 0.790191
R179 pn35_n10 pn35_n9 0.790191
R180 pn35_n9 pn35_n8 0.790191
R181 pn35_n8 pn35_n7 0.790191
R182 pn35_n13 pn35_n12 0.778958
R183 pn35_n15 pn35_n14 0.777179
R184 pn35_n21 pn35_n20 0.65392
R185 pn35 pn35_n23 0.307615
R186 pn35_n22 pn35_n6 0.188087
R187 pn35_n21 pn35_n6 0.0942483
R188 pn20 pn20_n0 17.1716
R189 pn20_n0 pn20_t1 8.69261
R190 pn20_n0 pn20_t0 6.03031
R191 pn19 pn19_n0 17.1716
R192 pn19_n0 pn19_t1 8.69261
R193 pn19_n0 pn19_t0 6.03031
R194 pn18 pn18_n0 17.1716
R195 pn18_n0 pn18_t0 8.69261
R196 pn18_n0 pn18_t1 6.03031
R197 pn22 pn22_n0 17.1579
R198 pn22_n0 pn22_t0 8.73326
R199 pn22_n0 pn22_t1 5.98966
R200 pn21 pn21_n0 16.9681
R201 pn21_n0 pn21_t0 8.72848
R202 pn21_n0 pn21_t1 5.99445
R203 pn17_n13 pn17_n11 47.3
R204 pn17_n19 pn17_n18 46.2417
R205 pn17_n17 pn17_n16 46.1848
R206 pn17_n15 pn17_n14 46.1641
R207 pn17_n13 pn17_n12 46.1641
R208 pn17_n21 pn17_n20 18.8794
R209 pn17_n20 pn17_t5 17.9905
R210 pn17_n18 pn17_t0 17.853
R211 pn17_n16 pn17_t4 17.7564
R212 pn17_n14 pn17_t3 17.6189
R213 pn17_n12 pn17_t2 17.6189
R214 pn17_n11 pn17_t1 17.6189
R215 pn17_n16 pn17_t7 17.5436
R216 pn17_n22 pn17_n10 17.5169
R217 pn17_n14 pn17_t9 17.3993
R218 pn17_n12 pn17_t10 17.3993
R219 pn17_n11 pn17_t11 17.3993
R220 pn17 pn17_n22 15.0012
R221 pn17_n21 pn17_n19 10.9033
R222 pn17_n4 pn17_n3 9.05448
R223 pn17_n7 pn17_n6 9.0476
R224 pn17_n1 pn17_n0 9.0335
R225 pn17_n8 pn17_n0 9.03277
R226 pn17_n10 pn17_n9 9.0005
R227 pn17_n9 pn17_n2 9.0005
R228 pn17_n8 pn17_n7 9.0005
R229 pn17_n3 pn17_n1 9.0005
R230 pn17_n5 pn17_n2 9.0005
R231 pn17_n18 pn17_t8 8.91864
R232 pn17_n4 pn17_t12 7.4777
R233 pn17_n6 pn17_t12 7.4777
R234 pn17_n20 pn17_t6 6.3601
R235 pn17_n17 pn17_n15 4.25237
R236 pn17_n22 pn17_n21 3.02307
R237 pn17_n19 pn17_n17 2.10223
R238 pn17_n15 pn17_n13 1.19803
R239 pn17_n6 pn17_n5 0.0971047
R240 pn17_n5 pn17_n4 0.0916048
R241 pn17_n9 pn17_n1 0.0775
R242 pn17_n3 pn17_n2 0.0775
R243 pn17_n9 pn17_n8 0.0767667
R244 pn17_n7 pn17_n2 0.0767667
R245 pn17_n10 pn17_n0 0.00196667
R246 pn24 pn24_n0 17.0396
R247 pn24_n0 pn24_t0 8.70696
R248 pn24_n0 pn24_t1 6.01597
R249 pn26_n0 pn26_t2 18.4133
R250 pn26_n0 pn26_t1 17.0005
R251 pn26_n1 pn26_t0 15.1472
R252 pn26 pn26_n1 15.0647
R253 pn26_n1 pn26_n0 0.435
R254 pn25_n0 pn25_t0 17.0005
R255 pn25 pn25_n1 15.2123
R256 pn25_n1 pn25_t1 15.006
R257 pn25_n0 pn25_t2 9.87426
R258 pn25_n1 pn25_n0 0.435
R259 pn5_n0 pn5_t2 48.5
R260 pn5 pn5_n1 17.0005
R261 pn5_n0 pn5_t0 15.0005
R262 pn5_n1 pn5_t1 7.4876
R263 pn5_n1 pn5_n0 0.4295
R264 pn27 pn27_n1 19.0109
R265 pn27_n0 pn27_t2 17.8908
R266 pn27_n0 pn27_t1 17.1518
R267 pn27_n1 pn27_t0 15.2242
R268 pn27_n1 pn27_n0 0.452417
R269 pn3 pn3_n1 18.2277
R270 pn3_n1 pn3_t2 17.0005
R271 pn3_n0 pn3_t1 15.2572
R272 pn3_n0 pn3_t0 15.0005
R273 pn3_n1 pn3_n0 5.803
R274 pn4_n0 pn4_t0 37.7132
R275 pn4_n0 pn4_t1 17.7155
R276 pn4 pn4_n0 17.3271
R277 pn28 pn28_t0 30.2572
R278 pn23_n1 pn23_n0 48.5128
R279 pn23 pn23_n1 25.106
R280 pn23_n1 pn23_t2 24.8013
R281 pn23_n0 pn23_t0 8.54633
R282 pn23_n0 pn23_t1 6.14002
R283 pn8 pn8_n0 17.5197
R284 pn8_n0 pn8_t1 15.4519
R285 pn8_n0 pn8_t0 8.76789
R286 pn6_n0 pn6_t1 34.0955
R287 pn6 pn6_n0 9.41086
R288 pn6_n0 pn6_t0 5.73312
R289 pn7_n0 pn7_t2 27.7009
R290 pn7_n1 pn7_t0 9.08096
R291 pn7 pn7_n1 8.55847
R292 pn7_n0 pn7_t1 5.66871
R293 pn7_n1 pn7_n0 1.19643
R294 s[4]_n2 s[4]_n1 65.8798
R295 s[4]_n0 s[4]_t0 34.6215
R296 s[4]_n2 s[4]_t3 33.4862
R297 s[4]_n0 s[4]_t1 15.0005
R298 s[4]_n1 s[4]_t2 4.49428
R299 s[4] s[4]_n2 0.936233
R300 s[4]_n1 s[4]_n0 0.618163
R301 s[3]_n1 s[3]_n0 47.7155
R302 s[3]_n0 s[3]_t0 33.638
R303 s[3]_n1 s[3]_t2 33.6062
R304 s[3]_n0 s[3]_t1 15.9878
R305 s[3] s[3]_n1 0.767567
R306 s[2]_n1 s[2]_n0 63.3186
R307 s[2]_n0 s[2]_t0 34.6239
R308 s[2]_n1 s[2]_t2 33.7314
R309 s[2]_n0 s[2]_t1 15.0019
R310 s[2] s[2]_n1 0.507967
R311 s[1]_n1 s[1]_n0 40.9424
R312 s[1]_n0 s[1]_t0 34.7523
R313 s[1]_n1 s[1]_t2 33.8528
R314 s[1]_n0 s[1]_t1 15.0005
R315 s[1] s[1]_n1 0.3811
R316 s[0]_n1 s[0]_t2 35.2795
R317 s[0]_n0 s[0]_t0 33.748
R318 s[0]_n1 s[0]_n0 20.1299
R319 s[0]_n0 s[0]_t1 16.0111
R320 s[0] s[0]_n1 0.243233
R321 AVDD_n353 AVDD_n345 32.5927
R322 AVDD_n350 AVDD_n349 28.6789
R323 AVDD_n352 AVDD_n346 28.052
R324 AVDD_n351 AVDD_n347 27.9973
R325 AVDD_n350 AVDD_n348 27.9973
R326 AVDD_n355 AVDD_n328 27.9416
R327 AVDD_n354 AVDD_n333 27.9229
R328 AVDD_n332 AVDD_n330 17.0555
R329 AVDD_n324 AVDD_n0 17.0199
R330 AVDD_n265 AVDD_n13 17.0005
R331 AVDD_n269 AVDD_n13 17.0005
R332 AVDD_n271 AVDD_n13 17.0005
R333 AVDD_n273 AVDD_n13 17.0005
R334 AVDD_t45 AVDD_n13 17.0005
R335 AVDD_n276 AVDD_n13 17.0005
R336 AVDD_t19 AVDD_n13 17.0005
R337 AVDD_n281 AVDD_n13 17.0005
R338 AVDD_n283 AVDD_n13 17.0005
R339 AVDD_n286 AVDD_n13 17.0005
R340 AVDD_n288 AVDD_n13 17.0005
R341 AVDD_n56 AVDD_n13 17.0005
R342 AVDD_n58 AVDD_n13 17.0005
R343 AVDD_t58 AVDD_n13 17.0005
R344 AVDD_n61 AVDD_n13 17.0005
R345 AVDD_n62 AVDD_n13 17.0005
R346 AVDD_n64 AVDD_n13 17.0005
R347 AVDD_n65 AVDD_n13 17.0005
R348 AVDD_n50 AVDD_n13 17.0005
R349 AVDD_n48 AVDD_n13 17.0005
R350 AVDD_n47 AVDD_n13 17.0005
R351 AVDD_t24 AVDD_n13 17.0005
R352 AVDD_n46 AVDD_n13 17.0005
R353 AVDD_n44 AVDD_n13 17.0005
R354 AVDD_n43 AVDD_n13 17.0005
R355 AVDD_n224 AVDD_n12 17.0005
R356 AVDD_n226 AVDD_n12 17.0005
R357 AVDD_n227 AVDD_n12 17.0005
R358 AVDD_n229 AVDD_n12 17.0005
R359 AVDD_n200 AVDD_t57 17.0005
R360 AVDD_n200 AVDD_n103 17.0005
R361 AVDD_n200 AVDD_n98 17.0005
R362 AVDD_n200 AVDD_t49 17.0005
R363 AVDD_n200 AVDD_n163 17.0005
R364 AVDD_n200 AVDD_n105 17.0005
R365 AVDD_n200 AVDD_n162 17.0005
R366 AVDD_n200 AVDD_n106 17.0005
R367 AVDD_n200 AVDD_n160 17.0005
R368 AVDD_n200 AVDD_n93 17.0005
R369 AVDD_n200 AVDD_n158 17.0005
R370 AVDD_n200 AVDD_t47 17.0005
R371 AVDD_n200 AVDD_t66 17.0005
R372 AVDD_n200 AVDD_n150 17.0005
R373 AVDD_n200 AVDD_t64 17.0005
R374 AVDD_n200 AVDD_n151 17.0005
R375 AVDD_n200 AVDD_t63 17.0005
R376 AVDD_n200 AVDD_n152 17.0005
R377 AVDD_n200 AVDD_n157 17.0005
R378 AVDD_n200 AVDD_t60 17.0005
R379 AVDD_n200 AVDD_n156 17.0005
R380 AVDD_n200 AVDD_n153 17.0005
R381 AVDD_n200 AVDD_n155 17.0005
R382 AVDD_n200 AVDD_n154 17.0005
R383 AVDD_n328 AVDD_n327 17.0005
R384 AVDD_n333 AVDD_n332 17.0005
R385 AVDD_n342 AVDD_n339 17.0005
R386 AVDD_n344 AVDD_n335 17.0005
R387 AVDD_n356 AVDD_n324 13.6618
R388 AVDD_n334 AVDD_t11 8.76154
R389 AVDD_n336 AVDD_t70 8.76154
R390 AVDD_n199 AVDD_n172 8.61936
R391 AVDD_n262 AVDD_n261 8.61464
R392 AVDD_t33 AVDD_n0 8.501
R393 AVDD_t33 AVDD_n34 8.501
R394 AVDD_t33 AVDD_n32 8.501
R395 AVDD_t33 AVDD_n31 8.501
R396 AVDD_t33 AVDD_n29 8.501
R397 AVDD_t33 AVDD_n28 8.501
R398 AVDD_t33 AVDD_n26 8.501
R399 AVDD_t33 AVDD_n25 8.501
R400 AVDD_n134 AVDD_n110 8.501
R401 AVDD_n132 AVDD_n111 8.501
R402 AVDD_n130 AVDD_n112 8.501
R403 AVDD_n144 AVDD_n143 8.501
R404 AVDD_n125 AVDD_n114 8.501
R405 AVDD_n122 AVDD_n121 8.501
R406 AVDD_n267 AVDD_n13 8.5005
R407 AVDD_n278 AVDD_n13 8.5005
R408 AVDD_n290 AVDD_n13 8.5005
R409 AVDD_n292 AVDD_n13 8.5005
R410 AVDD_t39 AVDD_n13 8.5005
R411 AVDD_t17 AVDD_n13 8.5005
R412 AVDD_n230 AVDD_n12 8.5005
R413 AVDD_t35 AVDD_n12 8.5005
R414 AVDD_n37 AVDD_n12 8.5005
R415 AVDD_n200 AVDD_n102 8.5005
R416 AVDD_n200 AVDD_t31 8.5005
R417 AVDD_n145 AVDD_n110 8.5005
R418 AVDD_n145 AVDD_n111 8.5005
R419 AVDD_n145 AVDD_n112 8.5005
R420 AVDD_n145 AVDD_n144 8.5005
R421 AVDD_n145 AVDD_n114 8.5005
R422 AVDD_n121 AVDD_n16 8.5005
R423 AVDD_n183 AVDD_n150 8.5005
R424 AVDD_n294 AVDD_t58 8.5005
R425 AVDD_n294 AVDD_n48 8.5005
R426 AVDD_n294 AVDD_n47 8.5005
R427 AVDD_n294 AVDD_n46 8.5005
R428 AVDD_n294 AVDD_n44 8.5005
R429 AVDD_n294 AVDD_n43 8.5005
R430 AVDD_n231 AVDD_n47 8.5005
R431 AVDD_n231 AVDD_n224 8.5005
R432 AVDD_n231 AVDD_n226 8.5005
R433 AVDD_n231 AVDD_n227 8.5005
R434 AVDD_n231 AVDD_n229 8.5005
R435 AVDD_n67 AVDD_n56 8.5005
R436 AVDD_n67 AVDD_n58 8.5005
R437 AVDD_n67 AVDD_n61 8.5005
R438 AVDD_n67 AVDD_n62 8.5005
R439 AVDD_n67 AVDD_n64 8.5005
R440 AVDD_n67 AVDD_n65 8.5005
R441 AVDD_t24 AVDD_n216 8.5005
R442 AVDD_n216 AVDD_n46 8.5005
R443 AVDD_n216 AVDD_n44 8.5005
R444 AVDD_n202 AVDD_n98 8.5005
R445 AVDD_n202 AVDD_n93 8.5005
R446 AVDD_n202 AVDD_t66 8.5005
R447 AVDD_t57 AVDD_n82 8.5005
R448 AVDD_n103 AVDD_n82 8.5005
R449 AVDD_n163 AVDD_n82 8.5005
R450 AVDD_n158 AVDD_n82 8.5005
R451 AVDD_t47 AVDD_n82 8.5005
R452 AVDD_t64 AVDD_n82 8.5005
R453 AVDD_n151 AVDD_n82 8.5005
R454 AVDD_t63 AVDD_n82 8.5005
R455 AVDD_n152 AVDD_n82 8.5005
R456 AVDD_n157 AVDD_n82 8.5005
R457 AVDD_t60 AVDD_n82 8.5005
R458 AVDD_n156 AVDD_n82 8.5005
R459 AVDD_n153 AVDD_n82 8.5005
R460 AVDD_n155 AVDD_n82 8.5005
R461 AVDD_n154 AVDD_n82 8.5005
R462 AVDD_n327 AVDD_n326 8.49851
R463 AVDD_n323 AVDD_n1 8.48401
R464 AVDD_n345 AVDD_n344 8.47111
R465 AVDD_n344 AVDD_n337 8.47111
R466 AVDD_n313 AVDD_n11 8.46995
R467 AVDD_n315 AVDD_n9 8.46995
R468 AVDD_n316 AVDD_n8 8.46995
R469 AVDD_n318 AVDD_n6 8.46995
R470 AVDD_n319 AVDD_n5 8.46995
R471 AVDD_n321 AVDD_n3 8.46995
R472 AVDD_n322 AVDD_n2 8.46995
R473 AVDD_n136 AVDD_n135 8.46995
R474 AVDD_n137 AVDD_n133 8.46995
R475 AVDD_n138 AVDD_n131 8.46995
R476 AVDD_n128 AVDD_n115 8.46995
R477 AVDD_n123 AVDD_n116 8.46995
R478 AVDD_n294 AVDD_n24 8.46995
R479 AVDD_n142 AVDD_n129 8.45904
R480 AVDD_n338 AVDD_t0 6.72012
R481 AVDD_n338 AVDD_t12 6.15759
R482 AVDD_n347 AVDD_t9 6.11392
R483 AVDD_n348 AVDD_t5 6.11392
R484 AVDD_n349 AVDD_t7 6.11392
R485 AVDD_n346 AVDD_t2 6.00228
R486 AVDD_n326 AVDD_t16 5.99877
R487 AVDD_n340 AVDD_t3 5.97212
R488 AVDD_n330 AVDD_t14 5.96578
R489 AVDD_t15 AVDD_n325 5.9589
R490 AVDD_n301 AVDD_t21 5.85707
R491 AVDD_t33 AVDD_n33 5.66778
R492 AVDD_t33 AVDD_n30 5.66778
R493 AVDD_t33 AVDD_n27 5.66778
R494 AVDD_n141 AVDD_t30 5.66778
R495 AVDD_n124 AVDD_n117 5.66778
R496 AVDD_t26 AVDD_n223 5.66767
R497 AVDD_n117 AVDD_n113 5.66767
R498 AVDD_t43 AVDD_n13 5.66717
R499 AVDD_n201 AVDD_n200 5.66717
R500 AVDD_n145 AVDD_t30 5.66717
R501 AVDD_n327 AVDD_t15 5.66717
R502 AVDD_n342 AVDD_n341 5.61485
R503 AVDD_n314 AVDD_n10 5.61281
R504 AVDD_n317 AVDD_n7 5.61281
R505 AVDD_n320 AVDD_n4 5.61281
R506 AVDD_n140 AVDD_n139 5.61281
R507 AVDD_n127 AVDD_n126 5.61281
R508 AVDD_n120 AVDD_n119 5.61281
R509 AVDD_n17 AVDD_n16 5.61281
R510 AVDD_n240 AVDD_n67 5.61281
R511 AVDD_n242 AVDD_t22 5.44448
R512 AVDD_n347 AVDD_t8 4.89166
R513 AVDD_n348 AVDD_t4 4.89166
R514 AVDD_n349 AVDD_t6 4.89166
R515 AVDD_n346 AVDD_t1 4.88395
R516 AVDD_n242 AVDD_n212 4.58883
R517 AVDD_n60 AVDD_n21 4.251
R518 AVDD_n63 AVDD_n21 4.251
R519 AVDD_n49 AVDD_n21 4.251
R520 AVDD_n219 AVDD_n21 4.251
R521 AVDD_n45 AVDD_n21 4.251
R522 AVDD_n270 AVDD_n19 4.251
R523 AVDD_n274 AVDD_n19 4.251
R524 AVDD_n280 AVDD_n19 4.251
R525 AVDD_n287 AVDD_n19 4.251
R526 AVDD_n183 AVDD_n175 4.251
R527 AVDD_n183 AVDD_n176 4.251
R528 AVDD_n183 AVDD_n177 4.251
R529 AVDD_n183 AVDD_n178 4.251
R530 AVDD_n183 AVDD_n179 4.251
R531 AVDD_n183 AVDD_n180 4.251
R532 AVDD_n183 AVDD_n181 4.251
R533 AVDD_n294 AVDD_n54 4.251
R534 AVDD_n294 AVDD_n53 4.251
R535 AVDD_n294 AVDD_n52 4.251
R536 AVDD_n294 AVDD_n41 4.251
R537 AVDD_n294 AVDD_n40 4.251
R538 AVDD_n294 AVDD_n38 4.251
R539 AVDD_n197 AVDD_n101 4.251
R540 AVDD_n197 AVDD_n100 4.251
R541 AVDD_n272 AVDD_n68 4.251
R542 AVDD_n275 AVDD_n68 4.251
R543 AVDD_n282 AVDD_n68 4.251
R544 AVDD_n231 AVDD_n220 4.251
R545 AVDD_n231 AVDD_n221 4.251
R546 AVDD_n225 AVDD_n216 4.251
R547 AVDD_n228 AVDD_n216 4.251
R548 AVDD_n252 AVDD_n73 4.251
R549 AVDD_n252 AVDD_n74 4.251
R550 AVDD_n252 AVDD_n75 4.251
R551 AVDD_n252 AVDD_n77 4.251
R552 AVDD_n252 AVDD_n78 4.251
R553 AVDD_n252 AVDD_n80 4.251
R554 AVDD_n202 AVDD_n99 4.251
R555 AVDD_n202 AVDD_n97 4.251
R556 AVDD_n202 AVDD_n94 4.251
R557 AVDD_n202 AVDD_n92 4.251
R558 AVDD_n202 AVDD_n91 4.251
R559 AVDD_n202 AVDD_n90 4.251
R560 AVDD_n202 AVDD_n88 4.251
R561 AVDD_n202 AVDD_n87 4.251
R562 AVDD_n202 AVDD_n86 4.251
R563 AVDD_n104 AVDD_n82 4.251
R564 AVDD_n161 AVDD_n82 4.251
R565 AVDD_n159 AVDD_n82 4.251
R566 AVDD_n149 AVDD_n82 4.251
R567 AVDD_n343 AVDD_n342 4.251
R568 AVDD_n294 AVDD_t39 4.2505
R569 AVDD_n292 AVDD_n68 4.2505
R570 AVDD_n231 AVDD_t26 4.2505
R571 AVDD_n231 AVDD_n230 4.2505
R572 AVDD_n105 AVDD_n82 4.2505
R573 AVDD_t31 AVDD_n82 4.2505
R574 AVDD_n231 AVDD_n217 4.18423
R575 AVDD_n254 AVDD_t34 4.13361
R576 AVDD_n165 AVDD_t32 4.1325
R577 AVDD_n331 AVDD_n329 3.99818
R578 AVDD_n218 AVDD_t27 3.99681
R579 AVDD_n184 AVDD_t61 3.52701
R580 AVDD_n184 AVDD_t65 3.52661
R581 AVDD_n344 AVDD_t10 3.4015
R582 AVDD_n332 AVDD_n331 3.25209
R583 AVDD_n118 AVDD_n69 2.83447
R584 AVDD_n266 AVDD_n19 2.83444
R585 AVDD_n277 AVDD_n19 2.83444
R586 AVDD_n291 AVDD_n19 2.83444
R587 AVDD_n294 AVDD_n42 2.83444
R588 AVDD_n268 AVDD_n68 2.83444
R589 AVDD_n279 AVDD_n68 2.83444
R590 AVDD_n289 AVDD_n68 2.83444
R591 AVDD_n67 AVDD_n59 2.83444
R592 AVDD_n222 AVDD_n216 2.83444
R593 AVDD_n252 AVDD_n72 2.83444
R594 AVDD_n252 AVDD_n76 2.83444
R595 AVDD_n252 AVDD_n79 2.83444
R596 AVDD_n202 AVDD_n96 2.83444
R597 AVDD_n202 AVDD_n89 2.83444
R598 AVDD_n57 AVDD_n21 2.83433
R599 AVDD_n294 AVDD_n39 2.83433
R600 AVDD_n197 AVDD_n195 2.83433
R601 AVDD_n109 AVDD_n108 2.83428
R602 AVDD_n239 AVDD_t59 2.80002
R603 AVDD_n303 AVDD_n19 2.72834
R604 AVDD_n189 AVDD_n183 2.7239
R605 AVDD_n312 AVDD_n311 2.68983
R606 AVDD_n352 AVDD_n351 2.56394
R607 AVDD_n22 AVDD_t18 2.53359
R608 AVDD_t41 AVDD_n13 2.42907
R609 AVDD_n184 AVDD_t62 2.3167
R610 AVDD_n238 AVDD_n67 2.29499
R611 AVDD_n242 AVDD_t23 2.28096
R612 AVDD_n258 AVDD_t42 2.14663
R613 AVDD_n254 AVDD_t36 2.1463
R614 AVDD_n171 AVDD_t56 2.14623
R615 AVDD_n256 AVDD_t38 2.14621
R616 AVDD_n168 AVDD_t53 2.14587
R617 AVDD_n170 AVDD_t55 2.14586
R618 AVDD_n166 AVDD_t50 2.1458
R619 AVDD_n259 AVDD_t44 2.14579
R620 AVDD_n169 AVDD_t54 2.14574
R621 AVDD_n255 AVDD_t37 2.14573
R622 AVDD_n167 AVDD_t52 2.14565
R623 AVDD_n257 AVDD_t40 2.14558
R624 AVDD_n165 AVDD_t48 2.14556
R625 AVDD_n260 AVDD_t46 2.1452
R626 AVDD_n285 AVDD_n68 2.12619
R627 AVDD_n284 AVDD_n19 2.126
R628 AVDD_n166 AVDD_n165 1.98738
R629 AVDD_n167 AVDD_n166 1.98738
R630 AVDD_n168 AVDD_n167 1.98738
R631 AVDD_n169 AVDD_n168 1.98738
R632 AVDD_n170 AVDD_n169 1.98738
R633 AVDD_n171 AVDD_n170 1.98738
R634 AVDD_n255 AVDD_n254 1.98738
R635 AVDD_n256 AVDD_n255 1.98738
R636 AVDD_n257 AVDD_n256 1.98738
R637 AVDD_n258 AVDD_n257 1.98738
R638 AVDD_n259 AVDD_n258 1.98738
R639 AVDD_n260 AVDD_n259 1.98738
R640 AVDD_n16 AVDD_n15 1.97072
R641 AVDD_n202 AVDD_n95 1.97072
R642 AVDD_n301 AVDD_t20 1.96535
R643 AVDD_n207 AVDD_t68 1.94119
R644 AVDD_n84 AVDD_t67 1.94019
R645 AVDD_n193 AVDD_n192 1.93283
R646 AVDD_n295 AVDD_t25 1.83564
R647 AVDD_n186 AVDD_n183 1.71723
R648 AVDD_n216 AVDD_n214 1.71482
R649 AVDD_n66 AVDD_n21 1.70124
R650 AVDD_n294 AVDD_n51 1.70096
R651 AVDD_n187 AVDD_n164 1.53209
R652 AVDD_n296 AVDD_n295 1.52027
R653 AVDD_n185 AVDD_n174 1.51606
R654 AVDD_n233 AVDD_n232 1.51383
R655 AVDD_n243 AVDD_n211 1.50512
R656 AVDD_n204 AVDD_n203 1.50486
R657 AVDD_n148 AVDD_n147 1.47145
R658 AVDD_n172 AVDD_n164 1.46989
R659 AVDD_n146 AVDD_n15 1.46015
R660 AVDD_n306 AVDD_n305 1.45558
R661 AVDD_n136 AVDD_n107 1.43885
R662 AVDD_n311 AVDD_n310 1.43858
R663 AVDD_n237 AVDD_n213 1.43841
R664 AVDD_n232 AVDD_n218 1.42233
R665 AVDD_n235 AVDD_n234 1.41968
R666 AVDD_n297 AVDD_n296 1.41878
R667 AVDD_n205 AVDD_n81 1.41345
R668 AVDD_n203 AVDD_n84 1.40923
R669 AVDD_n305 AVDD_n304 1.38007
R670 AVDD_n147 AVDD_n107 1.37996
R671 AVDD_n251 AVDD_n250 1.36727
R672 AVDD_n236 AVDD_n235 1.36581
R673 AVDD_n193 AVDD_n173 1.36249
R674 AVDD_n251 AVDD_n210 1.35935
R675 AVDD_n191 AVDD_n173 1.35905
R676 AVDD_n249 AVDD_n211 1.35367
R677 AVDD_n14 AVDD_n13 1.34081
R678 AVDD_n248 AVDD_n68 1.34081
R679 AVDD_n209 AVDD_n81 1.33979
R680 AVDD_n331 AVDD_t13 1.33349
R681 AVDD_n241 AVDD_n213 1.3318
R682 AVDD_n190 AVDD_n174 1.31346
R683 AVDD_n302 AVDD_n18 1.31055
R684 AVDD_n216 AVDD_n215 1.30869
R685 AVDD_n230 AVDD_n216 1.30819
R686 AVDD_n187 AVDD_n148 1.30663
R687 AVDD_n306 AVDD_n18 1.30149
R688 AVDD_n299 AVDD_n298 1.29653
R689 AVDD_n308 AVDD_n307 1.28673
R690 AVDD_n313 AVDD_n312 1.2616
R691 AVDD_n209 AVDD_n208 1.25624
R692 AVDD_n300 AVDD_n299 1.24686
R693 AVDD_n250 AVDD_n70 1.23239
R694 AVDD_n210 AVDD_n70 1.22679
R695 AVDD_n309 AVDD_n308 1.22198
R696 AVDD_n231 AVDD_n48 1.21479
R697 AVDD_n231 AVDD_t35 1.21479
R698 AVDD_n247 AVDD_n212 1.20317
R699 AVDD_n246 AVDD_n68 1.19727
R700 AVDD_n208 AVDD_n207 1.18096
R701 AVDD_t33 AVDD_n35 1.13433
R702 AVDD_n43 AVDD_n21 1.13383
R703 AVDD_n294 AVDD_t41 1.13383
R704 AVDD_n202 AVDD_n201 1.13383
R705 AVDD_n202 AVDD_n85 1.13383
R706 AVDD_n201 AVDD_n82 1.13383
R707 AVDD_n85 AVDD_n82 1.13383
R708 AVDD_n353 AVDD_n352 1.0873
R709 AVDD_n192 AVDD_n83 1.07012
R710 AVDD_n23 AVDD_n22 1.06654
R711 AVDD_n197 AVDD_n196 1.0635
R712 AVDD_n198 AVDD_n197 1.0635
R713 AVDD_n307 AVDD_n306 1.02487
R714 AVDD_n55 AVDD_n21 1.001
R715 AVDD_n294 AVDD_n36 1.001
R716 AVDD_n298 AVDD_n23 0.986331
R717 AVDD_n206 AVDD_n82 0.967806
R718 AVDD_n197 AVDD_n194 0.966768
R719 AVDD_n244 AVDD_n243 0.954733
R720 AVDD_n304 AVDD_n300 0.942375
R721 AVDD_n300 AVDD_n20 0.938447
R722 AVDD_n204 AVDD_n83 0.934976
R723 AVDD_n245 AVDD_n244 0.922086
R724 AVDD_n147 AVDD_n146 0.891042
R725 AVDD_n22 AVDD_n20 0.877989
R726 AVDD_n207 AVDD_n206 0.875268
R727 AVDD_n212 AVDD_t29 0.853128
R728 AVDD_n237 AVDD_n236 0.804875
R729 AVDD_n172 AVDD_n171 0.798
R730 AVDD_n261 AVDD_n260 0.798
R731 AVDD_n298 AVDD_n297 0.791125
R732 AVDD_n263 AVDD_n19 0.773227
R733 AVDD_n210 AVDD_n209 0.752167
R734 AVDD_n188 AVDD_n187 0.743
R735 AVDD_n302 AVDD_n301 0.743
R736 AVDD_n247 AVDD_n246 0.739166
R737 AVDD_n206 AVDD_n205 0.724239
R738 AVDD_n244 AVDD_n68 0.720216
R739 AVDD_n351 AVDD_n350 0.71902
R740 AVDD_n21 AVDD_n20 0.718841
R741 AVDD_n355 AVDD_n354 0.71022
R742 AVDD_n293 AVDD_n19 0.709333
R743 AVDD_n183 AVDD_n160 0.708833
R744 AVDD_t41 AVDD_n67 0.708833
R745 AVDD_n67 AVDD_t17 0.708833
R746 AVDD_n249 AVDD_n248 0.706216
R747 AVDD_n248 AVDD_n247 0.690971
R748 AVDD_n194 AVDD_n193 0.688891
R749 AVDD_n194 AVDD_n191 0.687
R750 AVDD_n250 AVDD_n249 0.656833
R751 AVDD_n310 AVDD_n309 0.656833
R752 AVDD_n146 AVDD_n145 0.651661
R753 AVDD_n261 AVDD_n14 0.643883
R754 AVDD_n246 AVDD_n245 0.632917
R755 AVDD_n245 AVDD_n241 0.6165
R756 AVDD_n263 AVDD_n262 0.61023
R757 AVDD_n339 AVDD_n338 0.608548
R758 AVDD_n183 AVDD_n182 0.608092
R759 AVDD_n310 AVDD_n14 0.606638
R760 AVDD_n188 AVDD_n186 0.600916
R761 AVDD_n341 AVDD_n335 0.597986
R762 AVDD_n200 AVDD_n85 0.586707
R763 AVDD_n95 AVDD_n84 0.570737
R764 AVDD AVDD_n356 0.56722
R765 AVDD_n191 AVDD_n190 0.554167
R766 AVDD_n309 AVDD_n15 0.546904
R767 AVDD_n202 AVDD_n83 0.541445
R768 AVDD_n23 AVDD_n21 0.541111
R769 AVDD_n234 AVDD_n233 0.529875
R770 AVDD_n236 AVDD_n214 0.49268
R771 AVDD_n243 AVDD_n242 0.48175
R772 AVDD_n186 AVDD_n185 0.481483
R773 AVDD_n145 AVDD_n85 0.472722
R774 AVDD_t41 AVDD_n68 0.472722
R775 AVDD_n264 AVDD_n68 0.448368
R776 AVDD_n252 AVDD_n71 0.448368
R777 AVDD_n263 AVDD_n16 0.447868
R778 AVDD_n234 AVDD_n214 0.441449
R779 AVDD_n192 AVDD_n95 0.421413
R780 AVDD_n190 AVDD_n189 0.410171
R781 AVDD_n239 AVDD_n238 0.405803
R782 AVDD_n253 AVDD_n252 0.405632
R783 AVDD_n205 AVDD_n204 0.403833
R784 AVDD_n304 AVDD_n303 0.396912
R785 AVDD_n303 AVDD_n302 0.395585
R786 AVDD_n238 AVDD_n237 0.394531
R787 AVDD_n318 AVDD_n317 0.389698
R788 AVDD_n185 AVDD_n184 0.378625
R789 AVDD_n119 AVDD_n17 0.374678
R790 AVDD_n252 AVDD_n70 0.344981
R791 AVDD_n139 AVDD_n129 0.334509
R792 AVDD_n312 AVDD_n12 0.320988
R793 AVDD_n315 AVDD_n314 0.312698
R794 AVDD_n321 AVDD_n320 0.312698
R795 AVDD_n127 AVDD_n116 0.312698
R796 AVDD_n314 AVDD_n313 0.312358
R797 AVDD_n317 AVDD_n316 0.312358
R798 AVDD_n320 AVDD_n319 0.312358
R799 AVDD_n119 AVDD_n116 0.312358
R800 AVDD_n128 AVDD_n127 0.312358
R801 AVDD_n139 AVDD_n138 0.312358
R802 AVDD_n218 AVDD_n217 0.279676
R803 AVDD_n129 AVDD_n128 0.272189
R804 AVDD_n208 AVDD_n82 0.266767
R805 AVDD_n189 AVDD_n188 0.262095
R806 AVDD_n316 AVDD_n315 0.250378
R807 AVDD_n319 AVDD_n318 0.250378
R808 AVDD_n322 AVDD_n321 0.250378
R809 AVDD_n138 AVDD_n137 0.250378
R810 AVDD_n137 AVDD_n136 0.250378
R811 AVDD_n241 AVDD_n240 0.250092
R812 AVDD_n199 AVDD_t51 0.249701
R813 AVDD_n240 AVDD_n239 0.231419
R814 AVDD_n323 AVDD_n322 0.222252
R815 AVDD_n299 AVDD_n21 0.205691
R816 AVDD_n197 AVDD_n173 0.191084
R817 AVDD_n297 AVDD_n24 0.187772
R818 AVDD_n307 AVDD_n17 0.187759
R819 AVDD_n295 AVDD_n24 0.182272
R820 AVDD_n341 AVDD_n340 0.168325
R821 AVDD_n356 AVDD_n355 0.15626
R822 AVDD_n326 AVDD_n325 0.148386
R823 AVDD_n354 AVDD_n353 0.14834
R824 AVDD_n337 AVDD_n336 0.147039
R825 AVDD_n233 AVDD_n217 0.146176
R826 AVDD_n308 AVDD_n16 0.144596
R827 AVDD_n19 AVDD_n18 0.143444
R828 AVDD_n345 AVDD_n334 0.132039
R829 AVDD_n235 AVDD_n216 0.125664
R830 AVDD_n145 AVDD_n107 0.125147
R831 AVDD_n333 AVDD_n329 0.1205
R832 AVDD_n337 AVDD_n334 0.109539
R833 AVDD_n200 AVDD_n148 0.101752
R834 AVDD_n82 AVDD_n81 0.0810905
R835 AVDD_n340 AVDD_n339 0.073
R836 AVDD_n324 AVDD_n323 0.069551
R837 AVDD_n330 AVDD_n329 0.0655
R838 AVDD_n305 AVDD_n19 0.0534423
R839 AVDD_n232 AVDD_n231 0.0416869
R840 AVDD_n336 AVDD_n335 0.03425
R841 AVDD_n203 AVDD_n202 0.0270412
R842 AVDD_n213 AVDD_n67 0.0260595
R843 AVDD_n311 AVDD_n13 0.0157345
R844 AVDD_n183 AVDD_n174 0.0111532
R845 AVDD_n262 AVDD_n13 0.00772326
R846 AVDD_n211 AVDD_n68 0.00674758
R847 AVDD_n328 AVDD_n325 0.0055
R848 AVDD_n200 AVDD_n164 0.00402211
R849 AVDD_n200 AVDD_n199 0.00394628
R850 AVDD_n253 AVDD_n69 0.00283299
R851 AVDD_n296 AVDD_n294 0.0027407
R852 AVDD_n120 AVDD_n118 0.00208324
R853 AVDD_n252 AVDD_n251 0.00205444
R854 AVDD_n182 AVDD_n154 0.00192854
R855 AVDD_n118 AVDD_n16 0.00191666
R856 AVDD_n135 AVDD_n109 0.00183333
R857 AVDD_n51 AVDD_n50 0.00179999
R858 AVDD_n284 AVDD_n283 0.00175
R859 AVDD_n162 AVDD_n96 0.00166667
R860 AVDD_n224 AVDD_n42 0.00166667
R861 AVDD_n222 AVDD_n43 0.00166667
R862 AVDD_n59 AVDD_t58 0.00166667
R863 AVDD_n292 AVDD_n291 0.00166667
R864 AVDD_n289 AVDD_n288 0.00166667
R865 AVDD_t19 AVDD_n279 0.00166667
R866 AVDD_n277 AVDD_n276 0.00166667
R867 AVDD_n269 AVDD_n268 0.00166667
R868 AVDD_n266 AVDD_n265 0.00166667
R869 AVDD_n121 AVDD_n79 0.00166667
R870 AVDD_n144 AVDD_n76 0.00166667
R871 AVDD_n110 AVDD_n72 0.00166667
R872 AVDD_n152 AVDD_n89 0.00166667
R873 AVDD_n33 AVDD_n9 0.00166667
R874 AVDD_n30 AVDD_n6 0.00166667
R875 AVDD_n27 AVDD_n3 0.00166667
R876 AVDD_n124 AVDD_n123 0.00166667
R877 AVDD_n142 AVDD_n141 0.00166667
R878 AVDD_n286 AVDD_n285 0.00162501
R879 AVDD_n66 AVDD_n65 0.00160001
R880 AVDD_t17 AVDD_n66 0.00139996
R881 AVDD_n285 AVDD_t43 0.00137497
R882 AVDD_n33 AVDD_n10 0.00133332
R883 AVDD_n30 AVDD_n7 0.00133332
R884 AVDD_n27 AVDD_n4 0.00133332
R885 AVDD_n141 AVDD_n140 0.00133332
R886 AVDD_n126 AVDD_n124 0.00133332
R887 AVDD_n267 AVDD_n266 0.00133331
R888 AVDD_n278 AVDD_n277 0.00133331
R889 AVDD_n291 AVDD_n290 0.00133331
R890 AVDD_t26 AVDD_n42 0.00133331
R891 AVDD_n268 AVDD_n267 0.00133331
R892 AVDD_n279 AVDD_n278 0.00133331
R893 AVDD_n290 AVDD_n289 0.00133331
R894 AVDD_n59 AVDD_t39 0.00133331
R895 AVDD_t26 AVDD_n222 0.00133331
R896 AVDD_n108 AVDD_n72 0.00133331
R897 AVDD_t30 AVDD_n76 0.00133331
R898 AVDD_n117 AVDD_n79 0.00133331
R899 AVDD_t31 AVDD_n89 0.00133331
R900 AVDD_n105 AVDD_n96 0.00133331
R901 AVDD_t43 AVDD_n284 0.00124997
R902 AVDD_t17 AVDD_n51 0.00119997
R903 AVDD_n145 AVDD_n109 0.00116665
R904 AVDD_n263 AVDD_n253 0.00116658
R905 AVDD_n182 AVDD_n85 0.00107141
R906 AVDD_n1 AVDD_n0 0.001
R907 AVDD_n35 AVDD_n11 0.001
R908 AVDD_n34 AVDD_n10 0.001
R909 AVDD_n32 AVDD_n8 0.001
R910 AVDD_n31 AVDD_n7 0.001
R911 AVDD_n29 AVDD_n5 0.001
R912 AVDD_n28 AVDD_n4 0.001
R913 AVDD_n26 AVDD_n2 0.001
R914 AVDD_n25 AVDD_n1 0.001
R915 AVDD_n223 AVDD_n13 0.001
R916 AVDD_n223 AVDD_n12 0.001
R917 AVDD_n35 AVDD_n12 0.001
R918 AVDD_n34 AVDD_n11 0.001
R919 AVDD_n32 AVDD_n9 0.001
R920 AVDD_n31 AVDD_n8 0.001
R921 AVDD_n29 AVDD_n6 0.001
R922 AVDD_n28 AVDD_n5 0.001
R923 AVDD_n26 AVDD_n3 0.001
R924 AVDD_n25 AVDD_n2 0.001
R925 AVDD_n135 AVDD_n134 0.001
R926 AVDD_n133 AVDD_n132 0.001
R927 AVDD_n131 AVDD_n130 0.001
R928 AVDD_n143 AVDD_n142 0.001
R929 AVDD_n125 AVDD_n115 0.001
R930 AVDD_n123 AVDD_n122 0.001
R931 AVDD_n145 AVDD_n113 0.001
R932 AVDD_t41 AVDD_n55 0.001
R933 AVDD_n57 AVDD_t39 0.001
R934 AVDD_n60 AVDD_t58 0.001
R935 AVDD_n64 AVDD_n63 0.001
R936 AVDD_n49 AVDD_n48 0.001
R937 AVDD_t24 AVDD_n219 0.001
R938 AVDD_n45 AVDD_n44 0.001
R939 AVDD_n270 AVDD_n269 0.001
R940 AVDD_t45 AVDD_n274 0.001
R941 AVDD_n281 AVDD_n280 0.001
R942 AVDD_n288 AVDD_n287 0.001
R943 AVDD_n293 AVDD_n292 0.001
R944 AVDD_n175 AVDD_n158 0.001
R945 AVDD_n176 AVDD_t66 0.001
R946 AVDD_n177 AVDD_n151 0.001
R947 AVDD_n178 AVDD_t63 0.001
R948 AVDD_n179 AVDD_t31 0.001
R949 AVDD_n180 AVDD_n156 0.001
R950 AVDD_n181 AVDD_n153 0.001
R951 AVDD_n58 AVDD_n54 0.001
R952 AVDD_n62 AVDD_n53 0.001
R953 AVDD_n64 AVDD_n52 0.001
R954 AVDD_n226 AVDD_n41 0.001
R955 AVDD_n229 AVDD_n40 0.001
R956 AVDD_n230 AVDD_n39 0.001
R957 AVDD_n38 AVDD_n37 0.001
R958 AVDD_n36 AVDD_t33 0.001
R959 AVDD_t51 AVDD_n198 0.001
R960 AVDD_n201 AVDD_n101 0.001
R961 AVDD_n201 AVDD_n100 0.001
R962 AVDD_n195 AVDD_n103 0.001
R963 AVDD_n196 AVDD_n163 0.001
R964 AVDD_n265 AVDD_n264 0.001
R965 AVDD_n272 AVDD_n271 0.001
R966 AVDD_n275 AVDD_t45 0.001
R967 AVDD_n283 AVDD_n282 0.001
R968 AVDD_n220 AVDD_n46 0.001
R969 AVDD_n221 AVDD_n44 0.001
R970 AVDD_n215 AVDD_n48 0.001
R971 AVDD_n226 AVDD_n225 0.001
R972 AVDD_n229 AVDD_n228 0.001
R973 AVDD_n85 AVDD_n71 0.001
R974 AVDD_n110 AVDD_n73 0.001
R975 AVDD_n112 AVDD_n74 0.001
R976 AVDD_n112 AVDD_n75 0.001
R977 AVDD_n114 AVDD_n77 0.001
R978 AVDD_n114 AVDD_n78 0.001
R979 AVDD_n121 AVDD_n80 0.001
R980 AVDD_n103 AVDD_n99 0.001
R981 AVDD_t49 AVDD_n97 0.001
R982 AVDD_n160 AVDD_n94 0.001
R983 AVDD_t47 AVDD_n92 0.001
R984 AVDD_n150 AVDD_n91 0.001
R985 AVDD_n151 AVDD_n90 0.001
R986 AVDD_t60 AVDD_n88 0.001
R987 AVDD_n153 AVDD_n87 0.001
R988 AVDD_n154 AVDD_n86 0.001
R989 AVDD_t49 AVDD_n104 0.001
R990 AVDD_n162 AVDD_n161 0.001
R991 AVDD_n160 AVDD_n159 0.001
R992 AVDD_n150 AVDD_n149 0.001
R993 AVDD_n37 AVDD_n36 0.001
R994 AVDD_t35 AVDD_n38 0.001
R995 AVDD_t35 AVDD_n39 0.001
R996 AVDD_n230 AVDD_n40 0.001
R997 AVDD_n228 AVDD_n227 0.001
R998 AVDD_n227 AVDD_n41 0.001
R999 AVDD_n225 AVDD_n224 0.001
R1000 AVDD_n221 AVDD_n43 0.001
R1001 AVDD_n46 AVDD_n45 0.001
R1002 AVDD_n220 AVDD_t24 0.001
R1003 AVDD_n219 AVDD_n47 0.001
R1004 AVDD_n215 AVDD_n47 0.001
R1005 AVDD_n50 AVDD_n49 0.001
R1006 AVDD_n65 AVDD_n52 0.001
R1007 AVDD_n63 AVDD_n62 0.001
R1008 AVDD_n61 AVDD_n53 0.001
R1009 AVDD_n61 AVDD_n60 0.001
R1010 AVDD_n58 AVDD_n57 0.001
R1011 AVDD_n56 AVDD_n54 0.001
R1012 AVDD_n56 AVDD_n55 0.001
R1013 AVDD_t41 AVDD_n293 0.001
R1014 AVDD_n287 AVDD_n286 0.001
R1015 AVDD_n282 AVDD_n281 0.001
R1016 AVDD_n280 AVDD_t19 0.001
R1017 AVDD_n276 AVDD_n275 0.001
R1018 AVDD_n274 AVDD_n273 0.001
R1019 AVDD_n273 AVDD_n272 0.001
R1020 AVDD_n271 AVDD_n270 0.001
R1021 AVDD_n264 AVDD_n263 0.001
R1022 AVDD_n80 AVDD_n69 0.001
R1023 AVDD_n117 AVDD_n78 0.001
R1024 AVDD_n144 AVDD_n77 0.001
R1025 AVDD_t30 AVDD_n75 0.001
R1026 AVDD_n111 AVDD_n74 0.001
R1027 AVDD_n111 AVDD_n73 0.001
R1028 AVDD_n108 AVDD_n71 0.001
R1029 AVDD_n155 AVDD_n86 0.001
R1030 AVDD_n181 AVDD_n155 0.001
R1031 AVDD_n156 AVDD_n87 0.001
R1032 AVDD_n180 AVDD_t60 0.001
R1033 AVDD_n157 AVDD_n88 0.001
R1034 AVDD_n179 AVDD_n157 0.001
R1035 AVDD_n178 AVDD_n152 0.001
R1036 AVDD_t63 AVDD_n90 0.001
R1037 AVDD_n177 AVDD_t64 0.001
R1038 AVDD_t64 AVDD_n91 0.001
R1039 AVDD_n149 AVDD_t66 0.001
R1040 AVDD_n176 AVDD_t47 0.001
R1041 AVDD_n158 AVDD_n92 0.001
R1042 AVDD_n175 AVDD_n93 0.001
R1043 AVDD_n159 AVDD_n93 0.001
R1044 AVDD_n106 AVDD_n94 0.001
R1045 AVDD_n161 AVDD_n106 0.001
R1046 AVDD_n196 AVDD_n105 0.001
R1047 AVDD_n163 AVDD_n97 0.001
R1048 AVDD_n104 AVDD_n98 0.001
R1049 AVDD_n195 AVDD_n98 0.001
R1050 AVDD_t57 AVDD_n99 0.001
R1051 AVDD_t57 AVDD_n100 0.001
R1052 AVDD_n102 AVDD_n101 0.001
R1053 AVDD_n198 AVDD_n102 0.001
R1054 AVDD_n113 AVDD_n16 0.001
R1055 AVDD_n122 AVDD_n120 0.001
R1056 AVDD_n126 AVDD_n125 0.001
R1057 AVDD_n143 AVDD_n115 0.001
R1058 AVDD_n140 AVDD_n130 0.001
R1059 AVDD_n132 AVDD_n131 0.001
R1060 AVDD_n134 AVDD_n133 0.001
R1061 AVDD_t10 AVDD_n343 0.001
R1062 AVDD_n343 AVDD_t0 0.001
R1063 AVSS_n57 AVSS_n56 8656.69
R1064 AVSS_n681 AVSS_t11 7788.72
R1065 AVSS_n60 AVSS_t17 5259.55
R1066 AVSS_n821 AVSS_t11 5055.03
R1067 AVSS_n821 AVSS_n62 4000
R1068 AVSS_n62 AVSS_n61 3356.2
R1069 AVSS_t63 AVSS_t31 3266
R1070 AVSS_n821 AVSS_n4 2843.06
R1071 AVSS_n821 AVSS_n12 2605.04
R1072 AVSS_n59 AVSS_t5 2564.31
R1073 AVSS_n62 AVSS_n13 2058.25
R1074 AVSS_n59 AVSS_n58 2005.14
R1075 AVSS_t20 AVSS_n57 1998.02
R1076 AVSS_n821 AVSS_n9 1828.17
R1077 AVSS_n10 AVSS_t37 1560.98
R1078 AVSS_n61 AVSS_n60 1540.31
R1079 AVSS_t17 AVSS_n14 1527.7
R1080 AVSS_n821 AVSS_n7 1289.21
R1081 AVSS_n3 AVSS_t6 1043.48
R1082 AVSS_n11 AVSS_t23 1024.91
R1083 AVSS_n5 AVSS_t3 982.936
R1084 AVSS_n60 AVSS_t12 966.465
R1085 AVSS_n6 AVSS_t34 939.641
R1086 AVSS_n56 AVSS_n55 876.543
R1087 AVSS_n56 AVSS_t18 839.506
R1088 AVSS_t18 AVSS_t36 788.85
R1089 AVSS_t19 AVSS_t22 772.216
R1090 AVSS_n62 AVSS_n14 649.077
R1091 AVSS_n58 AVSS_t20 629.206
R1092 AVSS_n821 AVSS_t63 603.909
R1093 AVSS_t33 AVSS_n4 549.297
R1094 AVSS_n821 AVSS_n8 512.518
R1095 AVSS_t10 AVSS_n12 473.389
R1096 AVSS_n57 AVSS_t33 431.591
R1097 AVSS_n13 AVSS_t10 417.368
R1098 AVSS_n821 AVSS_n10 406.505
R1099 AVSS_t12 AVSS_n13 396.005
R1100 AVSS_t31 AVSS_n820 342.409
R1101 AVSS_t36 AVSS_n9 309.358
R1102 AVSS_n821 AVSS_n3 271.74
R1103 AVSS_n821 AVSS_n11 266.904
R1104 AVSS_n55 AVSS_t8 263.375
R1105 AVSS_n821 AVSS_n5 255.974
R1106 AVSS_n821 AVSS_n6 244.698
R1107 AVSS_t2 AVSS_n7 231.189
R1108 AVSS_n744 AVSS_t26 230.394
R1109 AVSS_n597 AVSS_t26 219.423
R1110 AVSS_n58 AVSS_t2 202.63
R1111 AVSS_t30 AVSS_t25 160.52
R1112 AVSS_t22 AVSS_n8 117.523
R1113 AVSS_n822 AVSS_t14 113.677
R1114 AVSS_n59 AVSS_t30 112.365
R1115 AVSS_n61 AVSS_t14 93.547
R1116 AVSS_n249 AVSS_n244 67.0464
R1117 AVSS_t40 AVSS_n184 60.3418
R1118 AVSS_n53 AVSS_n52 59.3973
R1119 AVSS_n825 AVSS_n824 45.8404
R1120 AVSS_n60 AVSS_t19 42.9969
R1121 AVSS_n778 AVSS_t51 39.009
R1122 AVSS_n244 AVSS_n153 39.009
R1123 AVSS_n190 AVSS_n172 39.009
R1124 AVSS_n191 AVSS_n174 39.009
R1125 AVSS_n189 AVSS_n171 39.009
R1126 AVSS_n192 AVSS_n175 39.009
R1127 AVSS_n669 AVSS_n414 36.571
R1128 AVSS_n448 AVSS_n412 36.571
R1129 AVSS_n447 AVSS_n411 36.571
R1130 AVSS_n446 AVSS_n410 36.571
R1131 AVSS_n747 AVSS_n261 35.352
R1132 AVSS_n748 AVSS_n146 35.352
R1133 AVSS_n274 AVSS_n145 35.352
R1134 AVSS_n273 AVSS_n144 35.352
R1135 AVSS_n272 AVSS_n143 35.352
R1136 AVSS_n193 AVSS_t44 32.9139
R1137 AVSS_n451 AVSS_n450 31.6949
R1138 AVSS_n449 AVSS_n391 31.6949
R1139 AVSS_n268 AVSS_n141 30.4759
R1140 AVSS_n267 AVSS_n140 30.4759
R1141 AVSS_n266 AVSS_n139 30.4759
R1142 AVSS_n265 AVSS_n138 30.4759
R1143 AVSS_n264 AVSS_n137 30.4759
R1144 AVSS_n327 AVSS_n136 30.4759
R1145 AVSS_n822 AVSS_n821 29.6038
R1146 AVSS_n682 AVSS_n389 26.8189
R1147 AVSS_n693 AVSS_n388 26.8189
R1148 AVSS_n456 AVSS_n387 26.8189
R1149 AVSS_n464 AVSS_n386 26.8189
R1150 AVSS_n484 AVSS_t39 25.5998
R1151 AVSS_n498 AVSS_n357 24.3808
R1152 AVSS_n497 AVSS_n356 24.3808
R1153 AVSS_n445 AVSS_t53 23.7713
R1154 AVSS_t47 AVSS_n355 23.7713
R1155 AVSS_t0 AVSS_t28 23.3201
R1156 AVSS_n442 AVSS_n364 23.1618
R1157 AVSS_n441 AVSS_n363 23.1618
R1158 AVSS_n440 AVSS_n362 23.1618
R1159 AVSS_n439 AVSS_n361 23.1618
R1160 AVSS_n438 AVSS_n360 23.1618
R1161 AVSS_n436 AVSS_n359 23.1618
R1162 AVSS_n435 AVSS_n358 23.1618
R1163 AVSS_n434 AVSS_t57 23.1618
R1164 AVSS_n496 AVSS_n354 23.1618
R1165 AVSS_n110 AVSS_n84 23.1618
R1166 AVSS_n134 AVSS_n88 23.1618
R1167 AVSS_n133 AVSS_n83 23.1618
R1168 AVSS_n132 AVSS_n89 23.1618
R1169 AVSS_n131 AVSS_n82 23.1618
R1170 AVSS_n129 AVSS_n90 23.1618
R1171 AVSS_n128 AVSS_n81 23.1618
R1172 AVSS_n127 AVSS_n91 23.1618
R1173 AVSS_n126 AVSS_n80 23.1618
R1174 AVSS_n125 AVSS_n92 23.1618
R1175 AVSS_n98 AVSS_n79 23.1618
R1176 AVSS_n804 AVSS_n93 23.1618
R1177 AVSS_n408 AVSS_n367 21.9428
R1178 AVSS_n406 AVSS_n366 21.9428
R1179 AVSS_n655 AVSS_n365 21.9428
R1180 AVSS_n516 AVSS_n352 21.9428
R1181 AVSS_n517 AVSS_n351 21.9428
R1182 AVSS_n518 AVSS_n350 21.9428
R1183 AVSS_n519 AVSS_n349 21.9428
R1184 AVSS_n520 AVSS_n348 21.9428
R1185 AVSS_n554 AVSS_n343 21.9428
R1186 AVSS_n187 AVSS_n170 21.9428
R1187 AVSS_n194 AVSS_n176 21.9428
R1188 AVSS_n215 AVSS_n169 21.9428
R1189 AVSS_n234 AVSS_n178 21.9428
R1190 AVSS_n454 AVSS_n384 20.7238
R1191 AVSS_n455 AVSS_n383 20.7238
R1192 AVSS_n477 AVSS_n382 20.7238
R1193 AVSS_n409 AVSS_n369 19.5048
R1194 AVSS_n533 AVSS_n353 19.5048
R1195 AVSS_n600 AVSS_n352 19.5048
R1196 AVSS_n516 AVSS_n351 19.5048
R1197 AVSS_n593 AVSS_n347 19.5048
R1198 AVSS_n556 AVSS_n345 19.5048
R1199 AVSS_n554 AVSS_n344 19.5048
R1200 AVSS_n553 AVSS_n343 19.5048
R1201 AVSS_n193 AVSS_n170 19.5048
R1202 AVSS_n187 AVSS_n176 19.5048
R1203 AVSS_n194 AVSS_n169 19.5048
R1204 AVSS_n234 AVSS_n215 19.5048
R1205 AVSS_n196 AVSS_t40 18.8953
R1206 AVSS_n135 AVSS_n118 18.6794
R1207 AVSS_n444 AVSS_n368 18.2857
R1208 AVSS_n443 AVSS_n367 18.2857
R1209 AVSS_n654 AVSS_n366 18.2857
R1210 AVSS_n442 AVSS_n365 18.2857
R1211 AVSS_n441 AVSS_n364 18.2857
R1212 AVSS_n635 AVSS_t57 18.2857
R1213 AVSS_n494 AVSS_n354 18.2857
R1214 AVSS_n608 AVSS_n353 18.2857
R1215 AVSS_n270 AVSS_t49 18.2857
R1216 AVSS_n778 AVSS_n110 18.2857
R1217 AVSS_n134 AVSS_n84 18.2857
R1218 AVSS_n133 AVSS_n88 18.2857
R1219 AVSS_n132 AVSS_n83 18.2857
R1220 AVSS_n131 AVSS_n89 18.2857
R1221 AVSS_n147 AVSS_n82 18.2857
R1222 AVSS_t45 AVSS_n90 18.2857
R1223 AVSS_n129 AVSS_n81 18.2857
R1224 AVSS_n128 AVSS_n91 18.2857
R1225 AVSS_n127 AVSS_n80 18.2857
R1226 AVSS_n126 AVSS_n92 18.2857
R1227 AVSS_n125 AVSS_n79 18.2857
R1228 AVSS_n804 AVSS_n98 18.2857
R1229 AVSS_n42 AVSS_n7 18.0726
R1230 AVSS_n34 AVSS_n12 18.0501
R1231 AVSS_n30 AVSS_n14 18.0201
R1232 AVSS_n38 AVSS_n8 18.0051
R1233 AVSS_n26 AVSS_t29 17.3263
R1234 AVSS_n18 AVSS_t1 17.2247
R1235 AVSS_t55 AVSS_n368 17.0667
R1236 AVSS_n620 AVSS_n363 17.0667
R1237 AVSS_n503 AVSS_n362 17.0667
R1238 AVSS_n502 AVSS_n361 17.0667
R1239 AVSS_n501 AVSS_n360 17.0667
R1240 AVSS_n500 AVSS_n359 17.0667
R1241 AVSS_n499 AVSS_n358 17.0667
R1242 AVSS_n627 AVSS_n357 17.0667
R1243 AVSS_n498 AVSS_n356 17.0667
R1244 AVSS_n497 AVSS_n355 17.0667
R1245 AVSS_n694 AVSS_n693 17.0005
R1246 AVSS_n692 AVSS_n382 17.0005
R1247 AVSS_n692 AVSS_n383 17.0005
R1248 AVSS_n692 AVSS_n384 17.0005
R1249 AVSS_n692 AVSS_n392 17.0005
R1250 AVSS_n692 AVSS_n393 17.0005
R1251 AVSS_n692 AVSS_n386 17.0005
R1252 AVSS_n692 AVSS_n387 17.0005
R1253 AVSS_n693 AVSS_n692 17.0005
R1254 AVSS_n694 AVSS_n382 17.0005
R1255 AVSS_n694 AVSS_n383 17.0005
R1256 AVSS_n694 AVSS_n384 17.0005
R1257 AVSS_n694 AVSS_n386 17.0005
R1258 AVSS_n694 AVSS_n387 17.0005
R1259 AVSS_n376 AVSS_n339 17.0005
R1260 AVSS_n376 AVSS_n340 17.0005
R1261 AVSS_n376 AVSS_n341 17.0005
R1262 AVSS_n376 AVSS_n342 17.0005
R1263 AVSS_n376 AVSS_n343 17.0005
R1264 AVSS_n376 AVSS_n344 17.0005
R1265 AVSS_n376 AVSS_n345 17.0005
R1266 AVSS_n376 AVSS_n346 17.0005
R1267 AVSS_n376 AVSS_n347 17.0005
R1268 AVSS_n376 AVSS_n348 17.0005
R1269 AVSS_n376 AVSS_n349 17.0005
R1270 AVSS_n376 AVSS_n350 17.0005
R1271 AVSS_n376 AVSS_n351 17.0005
R1272 AVSS_n376 AVSS_n352 17.0005
R1273 AVSS_n376 AVSS_n353 17.0005
R1274 AVSS_n376 AVSS_n354 17.0005
R1275 AVSS_n376 AVSS_n355 17.0005
R1276 AVSS_n376 AVSS_n356 17.0005
R1277 AVSS_n376 AVSS_n357 17.0005
R1278 AVSS_n376 AVSS_t57 17.0005
R1279 AVSS_n376 AVSS_n358 17.0005
R1280 AVSS_n376 AVSS_n359 17.0005
R1281 AVSS_n376 AVSS_n360 17.0005
R1282 AVSS_n376 AVSS_n361 17.0005
R1283 AVSS_n376 AVSS_n362 17.0005
R1284 AVSS_n376 AVSS_n363 17.0005
R1285 AVSS_n376 AVSS_n364 17.0005
R1286 AVSS_n376 AVSS_n365 17.0005
R1287 AVSS_n376 AVSS_n366 17.0005
R1288 AVSS_n376 AVSS_n367 17.0005
R1289 AVSS_n376 AVSS_n368 17.0005
R1290 AVSS_n376 AVSS_n369 17.0005
R1291 AVSS_n710 AVSS_n339 17.0005
R1292 AVSS_n710 AVSS_n340 17.0005
R1293 AVSS_n710 AVSS_n341 17.0005
R1294 AVSS_n710 AVSS_n342 17.0005
R1295 AVSS_n710 AVSS_n343 17.0005
R1296 AVSS_n710 AVSS_n344 17.0005
R1297 AVSS_n710 AVSS_n345 17.0005
R1298 AVSS_n710 AVSS_n346 17.0005
R1299 AVSS_n710 AVSS_n347 17.0005
R1300 AVSS_n710 AVSS_n348 17.0005
R1301 AVSS_n710 AVSS_n349 17.0005
R1302 AVSS_n710 AVSS_n350 17.0005
R1303 AVSS_n710 AVSS_n351 17.0005
R1304 AVSS_n710 AVSS_n352 17.0005
R1305 AVSS_n710 AVSS_n353 17.0005
R1306 AVSS_n710 AVSS_n354 17.0005
R1307 AVSS_n710 AVSS_n355 17.0005
R1308 AVSS_n710 AVSS_n356 17.0005
R1309 AVSS_n710 AVSS_n357 17.0005
R1310 AVSS_n710 AVSS_t57 17.0005
R1311 AVSS_n710 AVSS_n358 17.0005
R1312 AVSS_n710 AVSS_n359 17.0005
R1313 AVSS_n710 AVSS_n360 17.0005
R1314 AVSS_n710 AVSS_n361 17.0005
R1315 AVSS_n710 AVSS_n362 17.0005
R1316 AVSS_n710 AVSS_n363 17.0005
R1317 AVSS_n710 AVSS_n364 17.0005
R1318 AVSS_n710 AVSS_n365 17.0005
R1319 AVSS_n710 AVSS_n366 17.0005
R1320 AVSS_n710 AVSS_n367 17.0005
R1321 AVSS_n710 AVSS_n368 17.0005
R1322 AVSS_n710 AVSS_n369 17.0005
R1323 AVSS_n591 AVSS_n339 17.0005
R1324 AVSS_n591 AVSS_n340 17.0005
R1325 AVSS_n591 AVSS_n341 17.0005
R1326 AVSS_n591 AVSS_n553 17.0005
R1327 AVSS_n591 AVSS_n554 17.0005
R1328 AVSS_n591 AVSS_n556 17.0005
R1329 AVSS_n591 AVSS_n558 17.0005
R1330 AVSS_n595 AVSS_n339 17.0005
R1331 AVSS_n595 AVSS_n340 17.0005
R1332 AVSS_n595 AVSS_n341 17.0005
R1333 AVSS_n595 AVSS_n553 17.0005
R1334 AVSS_n595 AVSS_n554 17.0005
R1335 AVSS_n595 AVSS_n556 17.0005
R1336 AVSS_n595 AVSS_n558 17.0005
R1337 AVSS_n148 AVSS_n93 17.0005
R1338 AVSS_n148 AVSS_n98 17.0005
R1339 AVSS_n148 AVSS_n125 17.0005
R1340 AVSS_n148 AVSS_n126 17.0005
R1341 AVSS_n148 AVSS_n127 17.0005
R1342 AVSS_n148 AVSS_n128 17.0005
R1343 AVSS_n148 AVSS_n129 17.0005
R1344 AVSS_n148 AVSS_t45 17.0005
R1345 AVSS_n148 AVSS_n147 17.0005
R1346 AVSS_n148 AVSS_n131 17.0005
R1347 AVSS_n148 AVSS_n132 17.0005
R1348 AVSS_n148 AVSS_n133 17.0005
R1349 AVSS_n148 AVSS_n134 17.0005
R1350 AVSS_n148 AVSS_n110 17.0005
R1351 AVSS_n292 AVSS_n148 17.0005
R1352 AVSS_n148 AVSS_n136 17.0005
R1353 AVSS_n148 AVSS_n137 17.0005
R1354 AVSS_n148 AVSS_n138 17.0005
R1355 AVSS_n148 AVSS_n139 17.0005
R1356 AVSS_n148 AVSS_n140 17.0005
R1357 AVSS_n148 AVSS_n141 17.0005
R1358 AVSS_n269 AVSS_n148 17.0005
R1359 AVSS_n271 AVSS_n148 17.0005
R1360 AVSS_n148 AVSS_n143 17.0005
R1361 AVSS_n148 AVSS_n144 17.0005
R1362 AVSS_n148 AVSS_n145 17.0005
R1363 AVSS_n748 AVSS_n148 17.0005
R1364 AVSS_n749 AVSS_n121 17.0005
R1365 AVSS_n749 AVSS_n98 17.0005
R1366 AVSS_n749 AVSS_n125 17.0005
R1367 AVSS_n749 AVSS_n126 17.0005
R1368 AVSS_n749 AVSS_n127 17.0005
R1369 AVSS_n749 AVSS_n128 17.0005
R1370 AVSS_n749 AVSS_n129 17.0005
R1371 AVSS_n749 AVSS_n131 17.0005
R1372 AVSS_n749 AVSS_n132 17.0005
R1373 AVSS_n749 AVSS_n133 17.0005
R1374 AVSS_n749 AVSS_n134 17.0005
R1375 AVSS_n749 AVSS_n110 17.0005
R1376 AVSS_n750 AVSS_n749 17.0005
R1377 AVSS_n749 AVSS_n136 17.0005
R1378 AVSS_n749 AVSS_n137 17.0005
R1379 AVSS_n749 AVSS_n138 17.0005
R1380 AVSS_n749 AVSS_n139 17.0005
R1381 AVSS_n749 AVSS_n140 17.0005
R1382 AVSS_n749 AVSS_n141 17.0005
R1383 AVSS_n749 AVSS_n143 17.0005
R1384 AVSS_n749 AVSS_n144 17.0005
R1385 AVSS_n749 AVSS_n145 17.0005
R1386 AVSS_n749 AVSS_n748 17.0005
R1387 AVSS_n482 AVSS_n455 17.0005
R1388 AVSS_n482 AVSS_n454 17.0005
R1389 AVSS_n483 AVSS_n482 17.0005
R1390 AVSS_n482 AVSS_n464 17.0005
R1391 AVSS_n482 AVSS_n456 17.0005
R1392 AVSS_n482 AVSS_n388 17.0005
R1393 AVSS_n482 AVSS_n389 17.0005
R1394 AVSS_n455 AVSS_n399 17.0005
R1395 AVSS_n454 AVSS_n399 17.0005
R1396 AVSS_n483 AVSS_n399 17.0005
R1397 AVSS_n464 AVSS_n399 17.0005
R1398 AVSS_n456 AVSS_n399 17.0005
R1399 AVSS_n399 AVSS_n388 17.0005
R1400 AVSS_n399 AVSS_n389 17.0005
R1401 AVSS_n420 AVSS_n406 17.0005
R1402 AVSS_n420 AVSS_n408 17.0005
R1403 AVSS_n420 AVSS_n409 17.0005
R1404 AVSS_n420 AVSS_n372 17.0005
R1405 AVSS_n420 AVSS_n410 17.0005
R1406 AVSS_n420 AVSS_n411 17.0005
R1407 AVSS_n420 AVSS_n412 17.0005
R1408 AVSS_n671 AVSS_n405 17.0005
R1409 AVSS_n671 AVSS_n406 17.0005
R1410 AVSS_n671 AVSS_n408 17.0005
R1411 AVSS_n671 AVSS_n409 17.0005
R1412 AVSS_n671 AVSS_n372 17.0005
R1413 AVSS_n671 AVSS_n410 17.0005
R1414 AVSS_n671 AVSS_n411 17.0005
R1415 AVSS_n671 AVSS_n412 17.0005
R1416 AVSS_n494 AVSS_n491 17.0005
R1417 AVSS_n496 AVSS_n491 17.0005
R1418 AVSS_n497 AVSS_n491 17.0005
R1419 AVSS_n498 AVSS_n491 17.0005
R1420 AVSS_n627 AVSS_n491 17.0005
R1421 AVSS_n499 AVSS_n491 17.0005
R1422 AVSS_n500 AVSS_n491 17.0005
R1423 AVSS_n501 AVSS_n491 17.0005
R1424 AVSS_n502 AVSS_n491 17.0005
R1425 AVSS_n503 AVSS_n491 17.0005
R1426 AVSS_n626 AVSS_n494 17.0005
R1427 AVSS_n626 AVSS_n496 17.0005
R1428 AVSS_n626 AVSS_n497 17.0005
R1429 AVSS_n626 AVSS_n498 17.0005
R1430 AVSS_n627 AVSS_n626 17.0005
R1431 AVSS_n626 AVSS_n499 17.0005
R1432 AVSS_n626 AVSS_n500 17.0005
R1433 AVSS_n626 AVSS_n501 17.0005
R1434 AVSS_n626 AVSS_n502 17.0005
R1435 AVSS_n626 AVSS_n503 17.0005
R1436 AVSS_n434 AVSS_n430 17.0005
R1437 AVSS_n435 AVSS_n430 17.0005
R1438 AVSS_n436 AVSS_n430 17.0005
R1439 AVSS_n438 AVSS_n430 17.0005
R1440 AVSS_n439 AVSS_n430 17.0005
R1441 AVSS_n440 AVSS_n430 17.0005
R1442 AVSS_n441 AVSS_n430 17.0005
R1443 AVSS_n442 AVSS_n430 17.0005
R1444 AVSS_n654 AVSS_n430 17.0005
R1445 AVSS_n443 AVSS_n430 17.0005
R1446 AVSS_n444 AVSS_n430 17.0005
R1447 AVSS_n445 AVSS_n430 17.0005
R1448 AVSS_n446 AVSS_n430 17.0005
R1449 AVSS_n447 AVSS_n430 17.0005
R1450 AVSS_n448 AVSS_n430 17.0005
R1451 AVSS_n430 AVSS_n414 17.0005
R1452 AVSS_n430 AVSS_n417 17.0005
R1453 AVSS_n449 AVSS_n430 17.0005
R1454 AVSS_n451 AVSS_n430 17.0005
R1455 AVSS_n452 AVSS_n430 17.0005
R1456 AVSS_n453 AVSS_n430 17.0005
R1457 AVSS_n484 AVSS_n430 17.0005
R1458 AVSS_n653 AVSS_n434 17.0005
R1459 AVSS_n653 AVSS_n435 17.0005
R1460 AVSS_n653 AVSS_n436 17.0005
R1461 AVSS_n653 AVSS_n438 17.0005
R1462 AVSS_n653 AVSS_n439 17.0005
R1463 AVSS_n653 AVSS_n440 17.0005
R1464 AVSS_n653 AVSS_n441 17.0005
R1465 AVSS_n653 AVSS_n442 17.0005
R1466 AVSS_n654 AVSS_n653 17.0005
R1467 AVSS_n653 AVSS_n443 17.0005
R1468 AVSS_n653 AVSS_n444 17.0005
R1469 AVSS_n653 AVSS_n445 17.0005
R1470 AVSS_n653 AVSS_n446 17.0005
R1471 AVSS_n653 AVSS_n447 17.0005
R1472 AVSS_n653 AVSS_n448 17.0005
R1473 AVSS_n653 AVSS_n414 17.0005
R1474 AVSS_n653 AVSS_n417 17.0005
R1475 AVSS_n653 AVSS_n449 17.0005
R1476 AVSS_n653 AVSS_n451 17.0005
R1477 AVSS_n653 AVSS_n452 17.0005
R1478 AVSS_n653 AVSS_n453 17.0005
R1479 AVSS_n653 AVSS_n484 17.0005
R1480 AVSS_n236 AVSS_n169 17.0005
R1481 AVSS_n236 AVSS_n176 17.0005
R1482 AVSS_n236 AVSS_n170 17.0005
R1483 AVSS_n236 AVSS_n175 17.0005
R1484 AVSS_n236 AVSS_n171 17.0005
R1485 AVSS_n236 AVSS_n174 17.0005
R1486 AVSS_n236 AVSS_n172 17.0005
R1487 AVSS_n232 AVSS_n169 17.0005
R1488 AVSS_n232 AVSS_n176 17.0005
R1489 AVSS_n232 AVSS_n170 17.0005
R1490 AVSS_n232 AVSS_n175 17.0005
R1491 AVSS_n232 AVSS_n171 17.0005
R1492 AVSS_n232 AVSS_n174 17.0005
R1493 AVSS_n232 AVSS_n172 17.0005
R1494 AVSS_n264 AVSS_n149 17.0005
R1495 AVSS_n265 AVSS_n149 17.0005
R1496 AVSS_n266 AVSS_n149 17.0005
R1497 AVSS_n267 AVSS_n149 17.0005
R1498 AVSS_n268 AVSS_n149 17.0005
R1499 AVSS_n270 AVSS_n149 17.0005
R1500 AVSS_n272 AVSS_n149 17.0005
R1501 AVSS_n273 AVSS_n149 17.0005
R1502 AVSS_n274 AVSS_n149 17.0005
R1503 AVSS_n149 AVSS_n146 17.0005
R1504 AVSS_n747 AVSS_n149 17.0005
R1505 AVSS_n746 AVSS_n264 17.0005
R1506 AVSS_n746 AVSS_n265 17.0005
R1507 AVSS_n746 AVSS_n266 17.0005
R1508 AVSS_n746 AVSS_n267 17.0005
R1509 AVSS_n746 AVSS_n268 17.0005
R1510 AVSS_n746 AVSS_n270 17.0005
R1511 AVSS_n746 AVSS_n272 17.0005
R1512 AVSS_n746 AVSS_n273 17.0005
R1513 AVSS_n746 AVSS_n274 17.0005
R1514 AVSS_n746 AVSS_n146 17.0005
R1515 AVSS_n747 AVSS_n746 17.0005
R1516 AVSS_n806 AVSS_n79 17.0005
R1517 AVSS_n806 AVSS_n92 17.0005
R1518 AVSS_n806 AVSS_n80 17.0005
R1519 AVSS_n806 AVSS_n91 17.0005
R1520 AVSS_n806 AVSS_n81 17.0005
R1521 AVSS_n806 AVSS_n90 17.0005
R1522 AVSS_n806 AVSS_n82 17.0005
R1523 AVSS_n806 AVSS_n89 17.0005
R1524 AVSS_n806 AVSS_n83 17.0005
R1525 AVSS_n806 AVSS_n88 17.0005
R1526 AVSS_n806 AVSS_n84 17.0005
R1527 AVSS_n107 AVSS_n79 17.0005
R1528 AVSS_n107 AVSS_n92 17.0005
R1529 AVSS_n107 AVSS_n80 17.0005
R1530 AVSS_n107 AVSS_n91 17.0005
R1531 AVSS_n107 AVSS_n81 17.0005
R1532 AVSS_n107 AVSS_n90 17.0005
R1533 AVSS_n107 AVSS_n82 17.0005
R1534 AVSS_n107 AVSS_n89 17.0005
R1535 AVSS_n107 AVSS_n83 17.0005
R1536 AVSS_n107 AVSS_n88 17.0005
R1537 AVSS_n107 AVSS_n84 17.0005
R1538 AVSS_n214 AVSS_n181 17.0005
R1539 AVSS_n214 AVSS_n209 17.0005
R1540 AVSS_n214 AVSS_n182 17.0005
R1541 AVSS_n214 AVSS_n206 17.0005
R1542 AVSS_n214 AVSS_n183 17.0005
R1543 AVSS_n214 AVSS_n203 17.0005
R1544 AVSS_n214 AVSS_n184 17.0005
R1545 AVSS_n214 AVSS_n196 17.0005
R1546 AVSS_n214 AVSS_n186 17.0005
R1547 AVSS_n214 AVSS_n178 17.0005
R1548 AVSS_n215 AVSS_n214 17.0005
R1549 AVSS_n214 AVSS_n194 17.0005
R1550 AVSS_n214 AVSS_n187 17.0005
R1551 AVSS_n214 AVSS_n193 17.0005
R1552 AVSS_n214 AVSS_n188 17.0005
R1553 AVSS_n214 AVSS_n192 17.0005
R1554 AVSS_n214 AVSS_n189 17.0005
R1555 AVSS_n214 AVSS_n191 17.0005
R1556 AVSS_n214 AVSS_n190 17.0005
R1557 AVSS_n212 AVSS_n68 17.0005
R1558 AVSS_n198 AVSS_n68 17.0005
R1559 AVSS_n184 AVSS_n68 17.0005
R1560 AVSS_n196 AVSS_n68 17.0005
R1561 AVSS_n215 AVSS_n68 17.0005
R1562 AVSS_n194 AVSS_n68 17.0005
R1563 AVSS_n187 AVSS_n68 17.0005
R1564 AVSS_n193 AVSS_n68 17.0005
R1565 AVSS_n188 AVSS_n68 17.0005
R1566 AVSS_n192 AVSS_n68 17.0005
R1567 AVSS_n189 AVSS_n68 17.0005
R1568 AVSS_n191 AVSS_n68 17.0005
R1569 AVSS_n190 AVSS_n68 17.0005
R1570 AVSS_n24 AVSS_n15 17.0005
R1571 AVSS_n20 AVSS_n15 17.0005
R1572 AVSS_n50 AVSS_n49 17.0005
R1573 AVSS_n41 AVSS_n40 17.0005
R1574 AVSS_n46 AVSS_n45 17.0005
R1575 AVSS_n37 AVSS_n36 17.0005
R1576 AVSS_n33 AVSS_n32 17.0005
R1577 AVSS_n823 AVSS_n2 17.0005
R1578 AVSS_t51 AVSS_n750 15.8477
R1579 AVSS_n550 AVSS_t27 15.182
R1580 AVSS_n682 AVSS_n681 14.6287
R1581 AVSS_n693 AVSS_n389 14.6287
R1582 AVSS_n388 AVSS_n387 14.6287
R1583 AVSS_n456 AVSS_n386 14.6287
R1584 AVSS_n825 AVSS_n0 14.0432
R1585 AVSS_t28 AVSS_t64 13.7179
R1586 AVSS_n45 AVSS_n9 13.219
R1587 AVSS_n464 AVSS_t59 12.8002
R1588 AVSS_n48 AVSS_n4 12.4175
R1589 AVSS_n558 AVSS_n557 12.1907
R1590 AVSS_n556 AVSS_n555 12.1907
R1591 AVSS_t49 AVSS_n269 12.1907
R1592 AVSS_n483 AVSS_n392 10.9717
R1593 AVSS_n484 AVSS_n454 10.9717
R1594 AVSS_n455 AVSS_n453 10.9717
R1595 AVSS_n477 AVSS_n452 10.9717
R1596 AVSS_n445 AVSS_n369 10.9717
R1597 AVSS_t61 AVSS_n346 10.9717
R1598 AVSS_n553 AVSS_t43 10.9717
R1599 AVSS_t43 AVSS_n342 10.9717
R1600 AVSS_n270 AVSS_n141 10.9717
R1601 AVSS_n268 AVSS_n140 10.9717
R1602 AVSS_n267 AVSS_n139 10.9717
R1603 AVSS_n266 AVSS_n138 10.9717
R1604 AVSS_n265 AVSS_n137 10.9717
R1605 AVSS_n264 AVSS_n136 10.9717
R1606 AVSS_n327 AVSS_n292 10.9717
R1607 AVSS_n453 AVSS_n384 9.75263
R1608 AVSS_n452 AVSS_n383 9.75263
R1609 AVSS_n451 AVSS_n382 9.75263
R1610 AVSS_n450 AVSS_n449 9.75263
R1611 AVSS_n417 AVSS_n391 9.75263
R1612 AVSS_n583 AVSS_n517 9.75263
R1613 AVSS_n583 AVSS_n350 9.75263
R1614 AVSS_n539 AVSS_n518 9.75263
R1615 AVSS_n539 AVSS_n349 9.75263
R1616 AVSS_n540 AVSS_n519 9.75263
R1617 AVSS_n540 AVSS_n348 9.75263
R1618 AVSS_n541 AVSS_n520 9.75263
R1619 AVSS_n541 AVSS_n347 9.75263
R1620 AVSS_n542 AVSS_n521 9.75263
R1621 AVSS_n542 AVSS_n346 9.75263
R1622 AVSS_n557 AVSS_n345 9.75263
R1623 AVSS_n392 AVSS_n385 9.33995
R1624 AVSS_n750 AVSS_n118 9.33995
R1625 AVSS_n249 AVSS_n123 9.33995
R1626 AVSS_t45 AVSS_n130 9.33995
R1627 AVSS_n269 AVSS_n142 9.33995
R1628 AVSS_n213 AVSS_n212 9.33995
R1629 AVSS_n201 AVSS_n199 9.33995
R1630 AVSS_n211 AVSS_n210 9.33995
R1631 AVSS_n209 AVSS_n208 9.33995
R1632 AVSS_n206 AVSS_n205 9.33995
R1633 AVSS_n203 AVSS_n202 9.33995
R1634 AVSS_n186 AVSS_n185 9.33995
R1635 AVSS_n393 AVSS_n385 9.33995
R1636 AVSS_n271 AVSS_n142 9.33995
R1637 AVSS_n292 AVSS_n135 9.33995
R1638 AVSS_n147 AVSS_n130 9.33995
R1639 AVSS_n123 AVSS_n93 9.33995
R1640 AVSS_n185 AVSS_n178 9.33995
R1641 AVSS_n199 AVSS_n198 9.33995
R1642 AVSS_n202 AVSS_n201 9.33995
R1643 AVSS_n205 AVSS_n183 9.33995
R1644 AVSS_n208 AVSS_n182 9.33995
R1645 AVSS_n210 AVSS_n181 9.33995
R1646 AVSS_n213 AVSS_n211 9.33995
R1647 AVSS_n676 AVSS_t60 9.12784
R1648 AVSS_n660 AVSS_t54 9.12784
R1649 AVSS_n17 AVSS_t32 8.83825
R1650 AVSS_n44 AVSS_t38 8.75631
R1651 AVSS_n43 AVSS_t35 8.75631
R1652 AVSS_n27 AVSS_t4 8.75631
R1653 AVSS_n28 AVSS_t24 8.75631
R1654 AVSS_n29 AVSS_t7 8.75631
R1655 AVSS_n1 AVSS_t15 8.75631
R1656 AVSS_n21 AVSS_t9 8.75631
R1657 AVSS_n23 AVSS_t16 8.75631
R1658 AVSS_n558 AVSS_t61 8.53362
R1659 AVSS_t44 AVSS_n188 8.53362
R1660 AVSS_n682 AVSS_n380 8.501
R1661 AVSS_n450 AVSS_n381 8.501
R1662 AVSS_n708 AVSS_n373 8.501
R1663 AVSS_n708 AVSS_n707 8.501
R1664 AVSS_n708 AVSS_n375 8.501
R1665 AVSS_n708 AVSS_n374 8.501
R1666 AVSS_n708 AVSS_n371 8.501
R1667 AVSS_n593 AVSS_n560 8.501
R1668 AVSS_n593 AVSS_n561 8.501
R1669 AVSS_n593 AVSS_n592 8.501
R1670 AVSS_n597 AVSS_n546 8.501
R1671 AVSS_n261 AVSS_n260 8.501
R1672 AVSS_n250 AVSS_n249 8.501
R1673 AVSS_n249 AVSS_n152 8.501
R1674 AVSS_n249 AVSS_n248 8.501
R1675 AVSS_n249 AVSS_n122 8.501
R1676 AVSS_n477 AVSS_n465 8.501
R1677 AVSS_n681 AVSS_n394 8.501
R1678 AVSS_n681 AVSS_n395 8.501
R1679 AVSS_n681 AVSS_n398 8.501
R1680 AVSS_n681 AVSS_n397 8.501
R1681 AVSS_n681 AVSS_n396 8.501
R1682 AVSS_n478 AVSS_n477 8.501
R1683 AVSS_n477 AVSS_n470 8.501
R1684 AVSS_n477 AVSS_n471 8.501
R1685 AVSS_n669 AVSS_n418 8.501
R1686 AVSS_n669 AVSS_n416 8.501
R1687 AVSS_n655 AVSS_n422 8.501
R1688 AVSS_n655 AVSS_n429 8.501
R1689 AVSS_n655 AVSS_n423 8.501
R1690 AVSS_n621 AVSS_n620 8.501
R1691 AVSS_n620 AVSS_n508 8.501
R1692 AVSS_n608 AVSS_n510 8.501
R1693 AVSS_n608 AVSS_n601 8.501
R1694 AVSS_n583 AVSS_n575 8.501
R1695 AVSS_n583 AVSS_n577 8.501
R1696 AVSS_n583 AVSS_n582 8.501
R1697 AVSS_n487 AVSS_n392 8.501
R1698 AVSS_n485 AVSS_n392 8.501
R1699 AVSS_n645 AVSS_n392 8.501
R1700 AVSS_n635 AVSS_n490 8.501
R1701 AVSS_n635 AVSS_n634 8.501
R1702 AVSS_n534 AVSS_n533 8.501
R1703 AVSS_n533 AVSS_n527 8.501
R1704 AVSS_n533 AVSS_n532 8.501
R1705 AVSS_n226 AVSS_n153 8.501
R1706 AVSS_n224 AVSS_n153 8.501
R1707 AVSS_n173 AVSS_n153 8.501
R1708 AVSS_n235 AVSS_n234 8.501
R1709 AVSS_n234 AVSS_n180 8.501
R1710 AVSS_n234 AVSS_n179 8.501
R1711 AVSS_n328 AVSS_n327 8.501
R1712 AVSS_n744 AVSS_n286 8.501
R1713 AVSS_n744 AVSS_n743 8.501
R1714 AVSS_n744 AVSS_n276 8.501
R1715 AVSS_n744 AVSS_n289 8.501
R1716 AVSS_n744 AVSS_n288 8.501
R1717 AVSS_n744 AVSS_n277 8.501
R1718 AVSS_n744 AVSS_n279 8.501
R1719 AVSS_n744 AVSS_n287 8.501
R1720 AVSS_n744 AVSS_n280 8.501
R1721 AVSS_n744 AVSS_n281 8.501
R1722 AVSS_n744 AVSS_n282 8.501
R1723 AVSS_n744 AVSS_n283 8.501
R1724 AVSS_n744 AVSS_n284 8.501
R1725 AVSS_n744 AVSS_n285 8.501
R1726 AVSS_n327 AVSS_n291 8.501
R1727 AVSS_n327 AVSS_n300 8.501
R1728 AVSS_n327 AVSS_n301 8.501
R1729 AVSS_n327 AVSS_n302 8.501
R1730 AVSS_n327 AVSS_n326 8.501
R1731 AVSS_n327 AVSS_n295 8.501
R1732 AVSS_n327 AVSS_n294 8.501
R1733 AVSS_n327 AVSS_n293 8.501
R1734 AVSS_n778 AVSS_n109 8.501
R1735 AVSS_n778 AVSS_n777 8.501
R1736 AVSS_n778 AVSS_n753 8.501
R1737 AVSS_n778 AVSS_n752 8.501
R1738 AVSS_n778 AVSS_n112 8.501
R1739 AVSS_n778 AVSS_n113 8.501
R1740 AVSS_n778 AVSS_n114 8.501
R1741 AVSS_n778 AVSS_n115 8.501
R1742 AVSS_n778 AVSS_n117 8.501
R1743 AVSS_n804 AVSS_n96 8.501
R1744 AVSS_n804 AVSS_n101 8.501
R1745 AVSS_n804 AVSS_n102 8.501
R1746 AVSS_n804 AVSS_n103 8.501
R1747 AVSS_n804 AVSS_n95 8.501
R1748 AVSS_n804 AVSS_n106 8.501
R1749 AVSS_n820 AVSS_n65 8.501
R1750 AVSS_n244 AVSS_n155 8.501
R1751 AVSS_n244 AVSS_n158 8.501
R1752 AVSS_n244 AVSS_n157 8.501
R1753 AVSS_n244 AVSS_n154 8.501
R1754 AVSS_n244 AVSS_n156 8.501
R1755 AVSS_n820 AVSS_n63 8.501
R1756 AVSS_n820 AVSS_n66 8.501
R1757 AVSS_n820 AVSS_n67 8.501
R1758 AVSS_n545 AVSS_n343 8.5005
R1759 AVSS_n555 AVSS_n545 8.5005
R1760 AVSS_n557 AVSS_n545 8.5005
R1761 AVSS_n545 AVSS_n542 8.5005
R1762 AVSS_n545 AVSS_n541 8.5005
R1763 AVSS_n545 AVSS_n540 8.5005
R1764 AVSS_n545 AVSS_n539 8.5005
R1765 AVSS_n599 AVSS_n342 8.5005
R1766 AVSS_n599 AVSS_n343 8.5005
R1767 AVSS_n599 AVSS_n344 8.5005
R1768 AVSS_n599 AVSS_n345 8.5005
R1769 AVSS_n599 AVSS_n521 8.5005
R1770 AVSS_n599 AVSS_n520 8.5005
R1771 AVSS_n599 AVSS_n519 8.5005
R1772 AVSS_n599 AVSS_n518 8.5005
R1773 AVSS_n599 AVSS_n517 8.5005
R1774 AVSS_n599 AVSS_n516 8.5005
R1775 AVSS_n600 AVSS_n599 8.5005
R1776 AVSS_n211 AVSS_n75 8.5005
R1777 AVSS_n201 AVSS_n75 8.5005
R1778 AVSS_n178 AVSS_n75 8.5005
R1779 AVSS_n215 AVSS_n75 8.5005
R1780 AVSS_n194 AVSS_n75 8.5005
R1781 AVSS_n187 AVSS_n75 8.5005
R1782 AVSS_n193 AVSS_n75 8.5005
R1783 AVSS_n188 AVSS_n75 8.5005
R1784 AVSS_n192 AVSS_n75 8.5005
R1785 AVSS_n189 AVSS_n75 8.5005
R1786 AVSS_n191 AVSS_n75 8.5005
R1787 AVSS_n190 AVSS_n75 8.5005
R1788 AVSS_n591 AVSS_n590 8.48362
R1789 AVSS_n671 AVSS_n403 8.48362
R1790 AVSS_n626 AVSS_n492 8.48362
R1791 AVSS_n626 AVSS_n625 8.48362
R1792 AVSS_n653 AVSS_n432 8.48362
R1793 AVSS_n232 AVSS_n231 8.48362
R1794 AVSS_n806 AVSS_n86 8.48362
R1795 AVSS_n19 AVSS_n16 8.47111
R1796 AVSS_n22 AVSS_n15 8.47111
R1797 AVSS_n54 AVSS_n53 8.47111
R1798 AVSS_n51 AVSS_n50 8.47111
R1799 AVSS_n40 AVSS_n39 8.47111
R1800 AVSS_n47 AVSS_n46 8.47111
R1801 AVSS_n36 AVSS_n35 8.47111
R1802 AVSS_n32 AVSS_n31 8.47111
R1803 AVSS_n824 AVSS_n823 8.47111
R1804 AVSS_n704 AVSS_n370 8.46995
R1805 AVSS_n706 AVSS_n705 8.46995
R1806 AVSS_n701 AVSS_n700 8.46995
R1807 AVSS_n699 AVSS_n698 8.46995
R1808 AVSS_n564 AVSS_n559 8.46995
R1809 AVSS_n568 AVSS_n562 8.46995
R1810 AVSS_n572 AVSS_n571 8.46995
R1811 AVSS_n570 AVSS_n547 8.46995
R1812 AVSS_n595 AVSS_n548 8.46995
R1813 AVSS_n259 AVSS_n258 8.46995
R1814 AVSS_n252 AVSS_n251 8.46995
R1815 AVSS_n246 AVSS_n245 8.46995
R1816 AVSS_n679 AVSS_n678 8.46995
R1817 AVSS_n401 AVSS_n400 8.46995
R1818 AVSS_n461 AVSS_n458 8.46995
R1819 AVSS_n462 AVSS_n457 8.46995
R1820 AVSS_n480 AVSS_n479 8.46995
R1821 AVSS_n469 AVSS_n468 8.46995
R1822 AVSS_n402 AVSS_n399 8.46995
R1823 AVSS_n664 AVSS_n419 8.46995
R1824 AVSS_n663 AVSS_n662 8.46995
R1825 AVSS_n658 AVSS_n657 8.46995
R1826 AVSS_n424 AVSS_n421 8.46995
R1827 AVSS_n428 AVSS_n427 8.46995
R1828 AVSS_n623 AVSS_n622 8.46995
R1829 AVSS_n616 AVSS_n615 8.46995
R1830 AVSS_n611 AVSS_n610 8.46995
R1831 AVSS_n605 AVSS_n604 8.46995
R1832 AVSS_n603 AVSS_n602 8.46995
R1833 AVSS_n586 AVSS_n585 8.46995
R1834 AVSS_n581 AVSS_n580 8.46995
R1835 AVSS_n651 AVSS_n650 8.46995
R1836 AVSS_n646 AVSS_n486 8.46995
R1837 AVSS_n644 AVSS_n643 8.46995
R1838 AVSS_n638 AVSS_n637 8.46995
R1839 AVSS_n631 AVSS_n630 8.46995
R1840 AVSS_n633 AVSS_n632 8.46995
R1841 AVSS_n536 AVSS_n535 8.46995
R1842 AVSS_n526 AVSS_n525 8.46995
R1843 AVSS_n531 AVSS_n530 8.46995
R1844 AVSS_n228 AVSS_n227 8.46995
R1845 AVSS_n223 AVSS_n168 8.46995
R1846 AVSS_n177 AVSS_n167 8.46995
R1847 AVSS_n219 AVSS_n216 8.46995
R1848 AVSS_n740 AVSS_n275 8.46995
R1849 AVSS_n742 AVSS_n741 8.46995
R1850 AVSS_n739 AVSS_n738 8.46995
R1851 AVSS_n737 AVSS_n736 8.46995
R1852 AVSS_n735 AVSS_n734 8.46995
R1853 AVSS_n731 AVSS_n730 8.46995
R1854 AVSS_n729 AVSS_n728 8.46995
R1855 AVSS_n727 AVSS_n726 8.46995
R1856 AVSS_n725 AVSS_n724 8.46995
R1857 AVSS_n723 AVSS_n722 8.46995
R1858 AVSS_n721 AVSS_n720 8.46995
R1859 AVSS_n719 AVSS_n718 8.46995
R1860 AVSS_n717 AVSS_n716 8.46995
R1861 AVSS_n715 AVSS_n714 8.46995
R1862 AVSS_n330 AVSS_n329 8.46995
R1863 AVSS_n318 AVSS_n317 8.46995
R1864 AVSS_n319 AVSS_n316 8.46995
R1865 AVSS_n320 AVSS_n315 8.46995
R1866 AVSS_n325 AVSS_n324 8.46995
R1867 AVSS_n311 AVSS_n304 8.46995
R1868 AVSS_n310 AVSS_n309 8.46995
R1869 AVSS_n308 AVSS_n307 8.46995
R1870 AVSS_n306 AVSS_n305 8.46995
R1871 AVSS_n806 AVSS_n87 8.46995
R1872 AVSS_n781 AVSS_n780 8.46995
R1873 AVSS_n776 AVSS_n108 8.46995
R1874 AVSS_n775 AVSS_n774 8.46995
R1875 AVSS_n773 AVSS_n772 8.46995
R1876 AVSS_n769 AVSS_n768 8.46995
R1877 AVSS_n767 AVSS_n766 8.46995
R1878 AVSS_n765 AVSS_n764 8.46995
R1879 AVSS_n763 AVSS_n762 8.46995
R1880 AVSS_n757 AVSS_n756 8.46995
R1881 AVSS_n792 AVSS_n791 8.46995
R1882 AVSS_n793 AVSS_n790 8.46995
R1883 AVSS_n794 AVSS_n789 8.46995
R1884 AVSS_n795 AVSS_n788 8.46995
R1885 AVSS_n797 AVSS_n786 8.46995
R1886 AVSS_n799 AVSS_n784 8.46995
R1887 AVSS_n242 AVSS_n241 8.46995
R1888 AVSS_n166 AVSS_n165 8.46995
R1889 AVSS_n162 AVSS_n161 8.46995
R1890 AVSS_n160 AVSS_n159 8.46995
R1891 AVSS_n814 AVSS_n72 8.46995
R1892 AVSS_n815 AVSS_n71 8.46995
R1893 AVSS_n565 AVSS_n563 8.45541
R1894 AVSS_n247 AVSS_n151 8.45541
R1895 AVSS_n576 AVSS_n574 8.45541
R1896 AVSS_n225 AVSS_n222 8.45541
R1897 AVSS_n218 AVSS_n217 8.45541
R1898 AVSS_n703 AVSS_n702 8.44274
R1899 AVSS_n460 AVSS_n459 8.44274
R1900 AVSS_n473 AVSS_n472 8.44274
R1901 AVSS_n164 AVSS_n163 8.44274
R1902 AVSS_n816 AVSS_n70 8.44274
R1903 AVSS_n598 AVSS_n339 6.87449
R1904 AVSS_n212 AVSS_n64 6.87449
R1905 AVSS_t8 AVSS_t0 6.85921
R1906 AVSS_n708 AVSS_t53 6.70509
R1907 AVSS_n39 AVSS_n38 6.55454
R1908 AVSS_n708 AVSS_n372 6.09558
R1909 AVSS_n635 AVSS_n627 6.09558
R1910 AVSS_n744 AVSS_n261 6.09558
R1911 AVSS_n748 AVSS_n747 6.09558
R1912 AVSS_n146 AVSS_n145 6.09558
R1913 AVSS_n274 AVSS_n144 6.09558
R1914 AVSS_n273 AVSS_n143 6.09558
R1915 AVSS_n272 AVSS_n271 6.09558
R1916 AVSS_n544 AVSS_n339 6.02866
R1917 AVSS_n543 AVSS_n342 6.02866
R1918 AVSS_n522 AVSS_n340 6.02866
R1919 AVSS_n207 AVSS_n181 6.02866
R1920 AVSS_n204 AVSS_n182 6.02866
R1921 AVSS_n200 AVSS_n183 6.02866
R1922 AVSS_n198 AVSS_n197 6.02866
R1923 AVSS_n195 AVSS_n186 6.02866
R1924 AVSS_n543 AVSS_n341 6.02866
R1925 AVSS_n522 AVSS_n341 6.02866
R1926 AVSS_n544 AVSS_n340 6.02866
R1927 AVSS_n196 AVSS_n195 6.02866
R1928 AVSS_n197 AVSS_n184 6.02866
R1929 AVSS_n203 AVSS_n200 6.02866
R1930 AVSS_n206 AVSS_n204 6.02866
R1931 AVSS_n209 AVSS_n207 6.02866
R1932 AVSS_n683 AVSS_n682 5.66778
R1933 AVSS_n597 AVSS_n538 5.66778
R1934 AVSS_n261 AVSS_n150 5.66778
R1935 AVSS_n656 AVSS_n655 5.66778
R1936 AVSS_n669 AVSS_n415 5.66778
R1937 AVSS_n669 AVSS_n668 5.66778
R1938 AVSS_n609 AVSS_n608 5.66778
R1939 AVSS_n620 AVSS_n619 5.66778
R1940 AVSS_n620 AVSS_n507 5.66778
R1941 AVSS_n608 AVSS_n607 5.66778
R1942 AVSS_n636 AVSS_n635 5.66778
R1943 AVSS_n647 AVSS_n392 5.66778
R1944 AVSS_n635 AVSS_n629 5.66778
R1945 AVSS_n533 AVSS_n512 5.66778
R1946 AVSS_n744 AVSS_n278 5.66778
R1947 AVSS_n327 AVSS_n299 5.66778
R1948 AVSS_n327 AVSS_n297 5.66778
R1949 AVSS_n327 AVSS_n303 5.66778
R1950 AVSS_n327 AVSS_n296 5.66778
R1951 AVSS_n805 AVSS_n804 5.66778
R1952 AVSS_n778 AVSS_n111 5.66778
R1953 AVSS_n778 AVSS_n751 5.66778
R1954 AVSS_n778 AVSS_n116 5.66778
R1955 AVSS_n804 AVSS_n97 5.66778
R1956 AVSS_n804 AVSS_n100 5.66778
R1957 AVSS_n804 AVSS_n104 5.66778
R1958 AVSS_n804 AVSS_n105 5.66778
R1959 AVSS_n804 AVSS_n94 5.66778
R1960 AVSS_n709 AVSS_n708 5.66767
R1961 AVSS_n594 AVSS_n593 5.66767
R1962 AVSS_n681 AVSS_n680 5.66767
R1963 AVSS_n670 AVSS_n669 5.66767
R1964 AVSS_n620 AVSS_n504 5.66767
R1965 AVSS_n608 AVSS_n493 5.66767
R1966 AVSS_n584 AVSS_n583 5.66767
R1967 AVSS_n635 AVSS_n433 5.66767
R1968 AVSS_n221 AVSS_n153 5.66767
R1969 AVSS_n234 AVSS_n233 5.66767
R1970 AVSS_n745 AVSS_n744 5.66767
R1971 AVSS_n779 AVSS_n778 5.66767
R1972 AVSS_n244 AVSS_n243 5.66767
R1973 AVSS_n50 AVSS_n6 5.66717
R1974 AVSS_n40 AVSS_n5 5.66717
R1975 AVSS_n46 AVSS_n10 5.66717
R1976 AVSS_n36 AVSS_n11 5.66717
R1977 AVSS_n32 AVSS_n3 5.66717
R1978 AVSS_n823 AVSS_n822 5.66717
R1979 AVSS_n17 AVSS_n16 5.63673
R1980 AVSS_n685 AVSS_n684 5.62981
R1981 AVSS_n749 AVSS_n120 5.62486
R1982 AVSS_n653 AVSS_n431 5.62486
R1983 AVSS_n599 AVSS_n537 5.62486
R1984 AVSS_n54 AVSS_n25 5.61485
R1985 AVSS_n690 AVSS_n689 5.61281
R1986 AVSS_n475 AVSS_n474 5.61281
R1987 AVSS_n665 AVSS_n413 5.61281
R1988 AVSS_n426 AVSS_n425 5.61281
R1989 AVSS_n506 AVSS_n505 5.61281
R1990 AVSS_n618 AVSS_n617 5.61281
R1991 AVSS_n529 AVSS_n528 5.61281
R1992 AVSS_n333 AVSS_n149 5.61281
R1993 AVSS_n733 AVSS_n732 5.61281
R1994 AVSS_n298 AVSS_n290 5.61281
R1995 AVSS_n321 AVSS_n314 5.61281
R1996 AVSS_n323 AVSS_n312 5.61281
R1997 AVSS_n771 AVSS_n770 5.61281
R1998 AVSS_n761 AVSS_n760 5.61281
R1999 AVSS_n759 AVSS_n758 5.61281
R2000 AVSS_n755 AVSS_n754 5.61281
R2001 AVSS_n808 AVSS_n77 5.61281
R2002 AVSS_n99 AVSS_n76 5.61281
R2003 AVSS_n798 AVSS_n785 5.61281
R2004 AVSS_n800 AVSS_n783 5.61281
R2005 AVSS_n802 AVSS_n801 5.61281
R2006 AVSS_n818 AVSS_n817 5.61281
R2007 AVSS_n322 AVSS_n313 5.6088
R2008 AVSS_n796 AVSS_n787 5.6088
R2009 AVSS_n257 AVSS_n256 5.60001
R2010 AVSS_n688 AVSS_n687 5.58885
R2011 AVSS_n667 AVSS_n666 5.58885
R2012 AVSS_n606 AVSS_n509 5.58885
R2013 AVSS_n649 AVSS_n648 5.58885
R2014 AVSS_n628 AVSS_n489 5.58885
R2015 AVSS_n60 AVSS_n59 5.16006
R2016 AVSS_t39 AVSS_n483 4.87657
R2017 AVSS_n669 AVSS_n417 4.87657
R2018 AVSS_n414 AVSS_n412 4.87657
R2019 AVSS_n448 AVSS_n411 4.87657
R2020 AVSS_n447 AVSS_n410 4.87657
R2021 AVSS_n446 AVSS_n372 4.87657
R2022 AVSS_n409 AVSS_t55 4.87657
R2023 AVSS_n555 AVSS_t41 4.87657
R2024 AVSS_t41 AVSS_n344 4.87657
R2025 AVSS_n655 AVSS_n407 4.25119
R2026 AVSS_n804 AVSS_n803 4.25119
R2027 AVSS_n686 AVSS_n682 4.25113
R2028 AVSS_n778 AVSS_n85 4.25113
R2029 AVSS_n691 AVSS_n682 4.251
R2030 AVSS_n597 AVSS_n596 4.251
R2031 AVSS_n261 AVSS_n119 4.251
R2032 AVSS_n652 AVSS_n392 4.251
R2033 AVSS_n533 AVSS_n515 4.251
R2034 AVSS_n327 AVSS_n262 4.251
R2035 AVSS_n55 AVSS_n15 4.2505
R2036 AVSS_n482 AVSS_n481 4.17435
R2037 AVSS_n675 AVSS_n399 4.17416
R2038 AVSS_n613 AVSS_t58 4.02854
R2039 AVSS_n694 AVSS_n385 3.83153
R2040 AVSS_n148 AVSS_n118 3.83153
R2041 AVSS_n749 AVSS_n123 3.83153
R2042 AVSS_n749 AVSS_n130 3.83153
R2043 AVSS_n749 AVSS_n135 3.83153
R2044 AVSS_n749 AVSS_n142 3.83153
R2045 AVSS_n214 AVSS_n213 3.83153
R2046 AVSS_n214 AVSS_n199 3.83153
R2047 AVSS_n210 AVSS_n68 3.83153
R2048 AVSS_n208 AVSS_n68 3.83153
R2049 AVSS_n205 AVSS_n68 3.83153
R2050 AVSS_n202 AVSS_n68 3.83153
R2051 AVSS_n185 AVSS_n68 3.83153
R2052 AVSS_n533 AVSS_n494 3.65755
R2053 AVSS_n608 AVSS_n600 3.65755
R2054 AVSS_n578 AVSS_t42 3.49206
R2055 AVSS_n477 AVSS_n476 3.40094
R2056 AVSS_n820 AVSS_n819 3.40094
R2057 AVSS_n55 AVSS_n16 3.4005
R2058 AVSS_n55 AVSS_n54 3.4005
R2059 AVSS_n659 AVSS_n420 3.31185
R2060 AVSS_n482 AVSS_n463 3.30365
R2061 AVSS_n661 AVSS_n420 3.30365
R2062 AVSS_n711 AVSS_n710 3.3033
R2063 AVSS_n677 AVSS_n399 2.7239
R2064 AVSS_n614 AVSS_n491 2.71714
R2065 AVSS_n78 AVSS_t46 2.60458
R2066 AVSS_n334 AVSS_t50 2.60416
R2067 AVSS_n513 AVSS_t62 2.60106
R2068 AVSS_n593 AVSS_n521 2.43853
R2069 AVSS_n190 AVSS_n153 2.43853
R2070 AVSS_n191 AVSS_n172 2.43853
R2071 AVSS_n189 AVSS_n174 2.43853
R2072 AVSS_n192 AVSS_n171 2.43853
R2073 AVSS_n188 AVSS_n175 2.43853
R2074 AVSS_n713 AVSS_n712 2.38612
R2075 AVSS_n692 AVSS_n390 2.30325
R2076 AVSS_n612 AVSS_n491 2.29924
R2077 AVSS_n579 AVSS_n545 2.29333
R2078 AVSS_n599 AVSS_n514 1.97148
R2079 AVSS_n591 AVSS_n569 1.95776
R2080 AVSS_n672 AVSS_n671 1.95372
R2081 AVSS_n597 AVSS_n545 1.88939
R2082 AVSS_n640 AVSS_t56 1.8574
R2083 AVSS_t59 AVSS_n393 1.82903
R2084 AVSS_n232 AVSS_n220 1.70774
R2085 AVSS_n237 AVSS_n236 1.70393
R2086 AVSS_n377 AVSS_t48 1.62531
R2087 AVSS_n52 AVSS_n42 1.533
R2088 AVSS_n626 AVSS_n495 1.50681
R2089 AVSS_n695 AVSS_n694 1.50314
R2090 AVSS_n595 AVSS_n552 1.50251
R2091 AVSS_n335 AVSS_n149 1.4906
R2092 AVSS_n704 AVSS_n336 1.46583
R2093 AVSS_n524 AVSS_n511 1.39582
R2094 AVSS_n811 AVSS_n810 1.38941
R2095 AVSS_n812 AVSS_n74 1.37908
R2096 AVSS_n35 AVSS_n34 1.37204
R2097 AVSS_n254 AVSS_t52 1.36099
R2098 AVSS_n513 AVSS_n511 1.34601
R2099 AVSS_n240 AVSS_n68 1.34508
R2100 AVSS_n549 AVSS_n124 1.33808
R2101 AVSS_n807 AVSS_n806 1.3279
R2102 AVSS_n712 AVSS_n336 1.32108
R2103 AVSS_n597 AVSS_n338 1.30869
R2104 AVSS_n692 AVSS_n391 1.30819
R2105 AVSS_n244 AVSS_n75 1.30819
R2106 AVSS_n810 AVSS_n74 1.29917
R2107 AVSS_n812 AVSS_n811 1.29233
R2108 AVSS_n31 AVSS_n30 1.26704
R2109 AVSS_n567 AVSS_n566 1.25862
R2110 AVSS_n160 AVSS_n73 1.2575
R2111 AVSS_n545 AVSS_n544 1.23717
R2112 AVSS_n545 AVSS_n543 1.23717
R2113 AVSS_n599 AVSS_n522 1.23717
R2114 AVSS_n207 AVSS_n75 1.23717
R2115 AVSS_n204 AVSS_n75 1.23717
R2116 AVSS_n200 AVSS_n75 1.23717
R2117 AVSS_n197 AVSS_n75 1.23717
R2118 AVSS_n195 AVSS_n75 1.23717
R2119 AVSS_n48 AVSS_n47 1.22579
R2120 AVSS_n444 AVSS_n408 1.21952
R2121 AVSS_n443 AVSS_n406 1.21952
R2122 AVSS_n655 AVSS_n654 1.21952
R2123 AVSS_n620 AVSS_n440 1.21952
R2124 AVSS_n503 AVSS_n439 1.21952
R2125 AVSS_n502 AVSS_n438 1.21952
R2126 AVSS_n501 AVSS_n436 1.21952
R2127 AVSS_n500 AVSS_n435 1.21952
R2128 AVSS_n499 AVSS_n434 1.21952
R2129 AVSS_n229 AVSS_n124 1.20474
R2130 AVSS_n52 AVSS_n51 1.20204
R2131 AVSS_n711 AVSS_n337 1.20123
R2132 AVSS AVSS_n825 1.19862
R2133 AVSS_n641 AVSS_n430 1.19852
R2134 AVSS_n466 AVSS_n437 1.16524
R2135 AVSS_n523 AVSS_n437 1.15986
R2136 AVSS_n813 AVSS_n73 1.11302
R2137 AVSS_n639 AVSS_n430 1.07833
R2138 AVSS_n573 AVSS_n545 1.07523
R2139 AVSS_n817 AVSS_n69 1.06996
R2140 AVSS_n598 AVSS_n597 1.05846
R2141 AVSS_n820 AVSS_n64 1.05846
R2142 AVSS_n801 AVSS_n782 1.00138
R2143 AVSS_n740 AVSS_n263 0.987217
R2144 AVSS_n239 AVSS_n69 0.985941
R2145 AVSS_n306 AVSS_n263 0.983321
R2146 AVSS_n255 AVSS_n254 0.976171
R2147 AVSS_n488 AVSS_n379 0.965587
R2148 AVSS_n587 AVSS_n545 0.96552
R2149 AVSS_n377 AVSS_n337 0.962068
R2150 AVSS_n258 AVSS_n255 0.947416
R2151 AVSS_n782 AVSS_n781 0.946911
R2152 AVSS_n253 AVSS_n252 0.893699
R2153 AVSS_n253 AVSS_n148 0.880723
R2154 AVSS_n378 AVSS_n377 0.879004
R2155 AVSS_n696 AVSS_n379 0.878191
R2156 AVSS_n587 AVSS_n586 0.875293
R2157 AVSS_n782 AVSS_n107 0.861388
R2158 AVSS_n639 AVSS_n638 0.817386
R2159 AVSS_n697 AVSS_n378 0.815143
R2160 AVSS_n808 AVSS_n807 0.806452
R2161 AVSS_n378 AVSS_n376 0.794361
R2162 AVSS_n255 AVSS_n148 0.794361
R2163 AVSS_n640 AVSS_n639 0.787178
R2164 AVSS_n746 AVSS_n263 0.781617
R2165 AVSS_n588 AVSS_n573 0.761552
R2166 AVSS_n578 AVSS_n573 0.745448
R2167 AVSS_n641 AVSS_n640 0.734127
R2168 AVSS_n588 AVSS_n587 0.733365
R2169 AVSS_n241 AVSS_n240 0.723265
R2170 AVSS_n69 AVSS_n68 0.712752
R2171 AVSS_n564 AVSS_n552 0.693252
R2172 AVSS_n696 AVSS_n695 0.6911
R2173 AVSS_n254 AVSS_n253 0.690398
R2174 AVSS_n624 AVSS_n495 0.665037
R2175 AVSS_n566 AVSS_n495 0.663686
R2176 AVSS_n376 AVSS_n337 0.656278
R2177 AVSS_n807 AVSS_n78 0.655167
R2178 AVSS_n692 AVSS_n379 0.646639
R2179 AVSS_n220 AVSS_n219 0.642496
R2180 AVSS_n237 AVSS_n168 0.63611
R2181 AVSS_n240 AVSS_n239 0.635608
R2182 AVSS_n642 AVSS_n641 0.634703
R2183 AVSS_n49 AVSS_n48 0.63175
R2184 AVSS_n230 AVSS_n220 0.628252
R2185 AVSS_n529 AVSS_n514 0.617862
R2186 AVSS_n42 AVSS_n41 0.61425
R2187 AVSS_n496 AVSS_t47 0.610008
R2188 AVSS_n550 AVSS_n549 0.601833
R2189 AVSS_n642 AVSS_n488 0.598625
R2190 AVSS_n25 AVSS_n24 0.598325
R2191 AVSS_n810 AVSS_n809 0.59175
R2192 AVSS_n335 AVSS_n334 0.591351
R2193 AVSS_n589 AVSS_n569 0.582181
R2194 AVSS_n673 AVSS_n672 0.580907
R2195 AVSS_n569 AVSS_n568 0.577342
R2196 AVSS_n689 AVSS_n390 0.576867
R2197 AVSS_n713 AVSS_n335 0.568619
R2198 AVSS_n697 AVSS_n696 0.5615
R2199 AVSS_n552 AVSS_n551 0.558535
R2200 AVSS_n551 AVSS_n550 0.5505
R2201 AVSS_n239 AVSS_n238 0.529875
R2202 AVSS_n524 AVSS_n523 0.5285
R2203 AVSS_n514 AVSS_n513 0.512155
R2204 AVSS_n238 AVSS_n237 0.507096
R2205 AVSS_n612 AVSS_n611 0.506107
R2206 AVSS_n617 AVSS_n614 0.502286
R2207 AVSS_n580 AVSS_n579 0.498465
R2208 AVSS_n467 AVSS_n466 0.4955
R2209 AVSS_n38 AVSS_n37 0.4905
R2210 AVSS_n34 AVSS_n33 0.4905
R2211 AVSS_n30 AVSS_n2 0.4905
R2212 AVSS_n695 AVSS_n0 0.481324
R2213 AVSS_n488 AVSS_n390 0.47571
R2214 AVSS_n712 AVSS_n711 0.456304
R2215 AVSS_n672 AVSS_n404 0.455409
R2216 AVSS_n678 AVSS_n677 0.449724
R2217 AVSS_n332 AVSS_n331 0.447833
R2218 AVSS_n689 AVSS_n688 0.446722
R2219 AVSS_n653 AVSS_n437 0.445055
R2220 AVSS_n579 AVSS_n578 0.44461
R2221 AVSS_n20 AVSS_n19 0.443289
R2222 AVSS_n613 AVSS_n612 0.4318
R2223 AVSS_n616 AVSS_n505 0.422698
R2224 AVSS_n467 AVSS_n463 0.415367
R2225 AVSS_n666 AVSS_n665 0.410569
R2226 AVSS_n660 AVSS_n659 0.400134
R2227 AVSS_n659 AVSS_n658 0.391377
R2228 AVSS_n323 AVSS_n322 0.386729
R2229 AVSS_n649 AVSS_n486 0.384746
R2230 AVSS_n631 AVSS_n489 0.384746
R2231 AVSS_n604 AVSS_n509 0.384746
R2232 AVSS_n666 AVSS_n664 0.384746
R2233 AVSS_n688 AVSS_n684 0.383356
R2234 AVSS_n322 AVSS_n321 0.380681
R2235 AVSS_n463 AVSS_n462 0.380211
R2236 AVSS_n663 AVSS_n661 0.380211
R2237 AVSS_n614 AVSS_n613 0.379293
R2238 AVSS_n257 AVSS_n120 0.375457
R2239 AVSS_n801 AVSS_n800 0.374678
R2240 AVSS_n761 AVSS_n759 0.374678
R2241 AVSS_n624 AVSS_n404 0.367167
R2242 AVSS_n817 AVSS_n816 0.366781
R2243 AVSS_n474 AVSS_n473 0.366781
R2244 AVSS_n530 AVSS_n525 0.360378
R2245 AVSS_n427 AVSS_n421 0.360378
R2246 AVSS_n674 AVSS_n673 0.356167
R2247 AVSS_n258 AVSS_n257 0.3512
R2248 AVSS_n676 AVSS_n675 0.349895
R2249 AVSS_n650 AVSS_n649 0.348249
R2250 AVSS_n638 AVSS_n489 0.348249
R2251 AVSS_n611 AVSS_n509 0.348249
R2252 AVSS_n214 AVSS_n73 0.340951
R2253 AVSS_n677 AVSS_n676 0.336479
R2254 AVSS_n796 AVSS_n795 0.324408
R2255 AVSS_n230 AVSS_n229 0.3195
R2256 AVSS_n797 AVSS_n796 0.318701
R2257 AVSS_n481 AVSS_n480 0.318618
R2258 AVSS_n792 AVSS_n76 0.312698
R2259 AVSS_n799 AVSS_n798 0.312698
R2260 AVSS_n759 AVSS_n757 0.312698
R2261 AVSS_n771 AVSS_n769 0.312698
R2262 AVSS_n733 AVSS_n731 0.312698
R2263 AVSS_n318 AVSS_n290 0.312698
R2264 AVSS_n324 AVSS_n323 0.312698
R2265 AVSS_n474 AVSS_n402 0.312698
R2266 AVSS_n798 AVSS_n797 0.312358
R2267 AVSS_n800 AVSS_n799 0.312358
R2268 AVSS_n757 AVSS_n755 0.312358
R2269 AVSS_n763 AVSS_n761 0.312358
R2270 AVSS_n773 AVSS_n771 0.312358
R2271 AVSS_n735 AVSS_n733 0.312358
R2272 AVSS_n330 AVSS_n290 0.312358
R2273 AVSS_n321 AVSS_n320 0.312358
R2274 AVSS_n530 AVSS_n529 0.312358
R2275 AVSS_n617 AVSS_n616 0.312358
R2276 AVSS_n623 AVSS_n505 0.312358
R2277 AVSS_n427 AVSS_n426 0.312358
R2278 AVSS_n572 AVSS_n570 0.309045
R2279 AVSS_n705 AVSS_n703 0.304801
R2280 AVSS_n816 AVSS_n815 0.304801
R2281 AVSS_n166 AVSS_n164 0.304801
R2282 AVSS_n460 AVSS_n401 0.304801
R2283 AVSS_n473 AVSS_n468 0.304801
R2284 AVSS_n703 AVSS_n701 0.304801
R2285 AVSS_n164 AVSS_n162 0.304801
R2286 AVSS_n461 AVSS_n460 0.304801
R2287 AVSS_n537 AVSS_n536 0.294297
R2288 AVSS_n650 AVSS_n431 0.294297
R2289 AVSS_n755 AVSS_n86 0.285354
R2290 AVSS_n661 AVSS_n660 0.2852
R2291 AVSS_n665 AVSS_n403 0.285014
R2292 AVSS_n218 AVSS_n167 0.279447
R2293 AVSS_n219 AVSS_n218 0.279447
R2294 AVSS_n222 AVSS_n168 0.279447
R2295 AVSS_n228 AVSS_n222 0.279447
R2296 AVSS_n580 AVSS_n574 0.279447
R2297 AVSS_n586 AVSS_n574 0.279447
R2298 AVSS_n565 AVSS_n564 0.279447
R2299 AVSS_n252 AVSS_n151 0.279447
R2300 AVSS_n245 AVSS_n151 0.279447
R2301 AVSS_n767 AVSS_n765 0.268711
R2302 AVSS_n731 AVSS_n729 0.268711
R2303 AVSS_n813 AVSS_n812 0.2645
R2304 AVSS_n701 AVSS_n699 0.250378
R2305 AVSS_n705 AVSS_n704 0.250378
R2306 AVSS_n793 AVSS_n792 0.250378
R2307 AVSS_n794 AVSS_n793 0.250378
R2308 AVSS_n795 AVSS_n794 0.250378
R2309 AVSS_n815 AVSS_n814 0.250378
R2310 AVSS_n162 AVSS_n160 0.250378
R2311 AVSS_n241 AVSS_n166 0.250378
R2312 AVSS_n765 AVSS_n763 0.250378
R2313 AVSS_n769 AVSS_n767 0.250378
R2314 AVSS_n774 AVSS_n773 0.250378
R2315 AVSS_n774 AVSS_n108 0.250378
R2316 AVSS_n781 AVSS_n108 0.250378
R2317 AVSS_n717 AVSS_n715 0.250378
R2318 AVSS_n719 AVSS_n717 0.250378
R2319 AVSS_n721 AVSS_n719 0.250378
R2320 AVSS_n723 AVSS_n721 0.250378
R2321 AVSS_n725 AVSS_n723 0.250378
R2322 AVSS_n727 AVSS_n725 0.250378
R2323 AVSS_n729 AVSS_n727 0.250378
R2324 AVSS_n737 AVSS_n735 0.250378
R2325 AVSS_n739 AVSS_n737 0.250378
R2326 AVSS_n741 AVSS_n739 0.250378
R2327 AVSS_n741 AVSS_n740 0.250378
R2328 AVSS_n319 AVSS_n318 0.250378
R2329 AVSS_n320 AVSS_n319 0.250378
R2330 AVSS_n324 AVSS_n311 0.250378
R2331 AVSS_n311 AVSS_n310 0.250378
R2332 AVSS_n310 AVSS_n308 0.250378
R2333 AVSS_n308 AVSS_n306 0.250378
R2334 AVSS_n536 AVSS_n525 0.250378
R2335 AVSS_n643 AVSS_n486 0.250378
R2336 AVSS_n632 AVSS_n631 0.250378
R2337 AVSS_n570 AVSS_n548 0.250378
R2338 AVSS_n604 AVSS_n603 0.250378
R2339 AVSS_n664 AVSS_n663 0.250378
R2340 AVSS_n658 AVSS_n421 0.250378
R2341 AVSS_n462 AVSS_n461 0.250378
R2342 AVSS_n678 AVSS_n401 0.250378
R2343 AVSS_n480 AVSS_n468 0.250378
R2344 AVSS_n426 AVSS_n405 0.250092
R2345 AVSS_n334 AVSS_n333 0.242759
R2346 AVSS_n632 AVSS_n432 0.223034
R2347 AVSS_n603 AVSS_n492 0.223034
R2348 AVSS_n231 AVSS_n228 0.223034
R2349 AVSS_n590 AVSS_n572 0.223034
R2350 AVSS_n625 AVSS_n623 0.223034
R2351 AVSS_n749 AVSS_n124 0.220511
R2352 AVSS_n481 AVSS_n467 0.220115
R2353 AVSS_n599 AVSS_n598 0.217868
R2354 AVSS_n75 AVSS_n64 0.217868
R2355 AVSS_n809 AVSS_n76 0.205752
R2356 AVSS_n567 AVSS_n565 0.198508
R2357 AVSS_n18 AVSS_n17 0.194859
R2358 AVSS_n331 AVSS_n87 0.187772
R2359 AVSS_n245 AVSS_n121 0.187772
R2360 AVSS_n675 AVSS_n674 0.186728
R2361 AVSS_n87 AVSS_n78 0.180439
R2362 AVSS_n809 AVSS_n808 0.169425
R2363 AVSS_n26 AVSS_n25 0.169236
R2364 AVSS_n599 AVSS_n511 0.157398
R2365 AVSS_n589 AVSS_n588 0.1545
R2366 AVSS_n23 AVSS_n22 0.148289
R2367 AVSS_n699 AVSS_n697 0.132772
R2368 AVSS_n814 AVSS_n813 0.132772
R2369 AVSS_n238 AVSS_n167 0.132772
R2370 AVSS_n715 AVSS_n713 0.132772
R2371 AVSS_n332 AVSS_n330 0.132772
R2372 AVSS_n643 AVSS_n642 0.132772
R2373 AVSS_n551 AVSS_n548 0.132772
R2374 AVSS_n674 AVSS_n402 0.132772
R2375 AVSS_n53 AVSS_n26 0.132039
R2376 AVSS_n75 AVSS_n74 0.130662
R2377 AVSS_n811 AVSS_n75 0.129765
R2378 AVSS_n47 AVSS_n44 0.125789
R2379 AVSS_n51 AVSS_n43 0.125789
R2380 AVSS_n39 AVSS_n27 0.125789
R2381 AVSS_n35 AVSS_n28 0.125789
R2382 AVSS_n31 AVSS_n29 0.125789
R2383 AVSS_n824 AVSS_n1 0.125789
R2384 AVSS_n333 AVSS_n332 0.125086
R2385 AVSS_n22 AVSS_n21 0.108289
R2386 AVSS_n684 AVSS_n0 0.0980289
R2387 AVSS_n710 AVSS_n336 0.0897938
R2388 AVSS_n549 AVSS_n120 0.089169
R2389 AVSS_n466 AVSS_n431 0.089169
R2390 AVSS_n537 AVSS_n524 0.089169
R2391 AVSS_n19 AVSS_n18 0.084539
R2392 AVSS_n568 AVSS_n567 0.081439
R2393 AVSS_n21 AVSS_n20 0.073
R2394 AVSS_n405 AVSS_n404 0.0701667
R2395 AVSS_n229 AVSS_n121 0.0701667
R2396 AVSS_n45 AVSS_n44 0.0555
R2397 AVSS_n49 AVSS_n43 0.0555
R2398 AVSS_n41 AVSS_n27 0.0555
R2399 AVSS_n37 AVSS_n28 0.0555
R2400 AVSS_n33 AVSS_n29 0.0555
R2401 AVSS_n2 AVSS_n1 0.0555
R2402 AVSS_n566 AVSS_n492 0.0357621
R2403 AVSS_n523 AVSS_n432 0.0357621
R2404 AVSS_n331 AVSS_n86 0.0357621
R2405 AVSS_n231 AVSS_n230 0.0357621
R2406 AVSS_n590 AVSS_n589 0.0357621
R2407 AVSS_n625 AVSS_n624 0.0357621
R2408 AVSS_n673 AVSS_n403 0.0357621
R2409 AVSS_n24 AVSS_n23 0.033
R2410 AVSS_n476 AVSS_n475 0.00229998
R2411 AVSS_n819 AVSS_n818 0.00229998
R2412 AVSS_n687 AVSS_n686 0.002125
R2413 AVSS_n754 AVSS_n85 0.002125
R2414 AVSS_n686 AVSS_n685 0.00187493
R2415 AVSS_n806 AVSS_n85 0.00187493
R2416 AVSS_n691 AVSS_n690 0.00175
R2417 AVSS_n305 AVSS_n262 0.00175
R2418 AVSS_n535 AVSS_n515 0.00175
R2419 AVSS_n652 AVSS_n651 0.00175
R2420 AVSS_n256 AVSS_n119 0.00175
R2421 AVSS_n596 AVSS_n547 0.00175
R2422 AVSS_n819 AVSS_n68 0.00169991
R2423 AVSS_n476 AVSS_n399 0.00169991
R2424 AVSS_n687 AVSS_n683 0.00166667
R2425 AVSS_n657 AVSS_n656 0.00166667
R2426 AVSS_n805 AVSS_n77 0.00166667
R2427 AVSS_n756 AVSS_n116 0.00166667
R2428 AVSS_n758 AVSS_n751 0.00166667
R2429 AVSS_n768 AVSS_n111 0.00166667
R2430 AVSS_n99 AVSS_n97 0.00166667
R2431 AVSS_n791 AVSS_n100 0.00166667
R2432 AVSS_n786 AVSS_n104 0.00166667
R2433 AVSS_n784 AVSS_n105 0.00166667
R2434 AVSS_n802 AVSS_n94 0.00166667
R2435 AVSS_n730 AVSS_n278 0.00166667
R2436 AVSS_n317 AVSS_n299 0.00166667
R2437 AVSS_n313 AVSS_n297 0.00166667
R2438 AVSS_n312 AVSS_n303 0.00166667
R2439 AVSS_n325 AVSS_n296 0.00166667
R2440 AVSS_n599 AVSS_n512 0.00166667
R2441 AVSS_n647 AVSS_n646 0.00166667
R2442 AVSS_n637 AVSS_n636 0.00166667
R2443 AVSS_n630 AVSS_n629 0.00166667
R2444 AVSS_n619 AVSS_n491 0.00166667
R2445 AVSS_n615 AVSS_n507 0.00166667
R2446 AVSS_n610 AVSS_n609 0.00166667
R2447 AVSS_n607 AVSS_n605 0.00166667
R2448 AVSS_n668 AVSS_n419 0.00166667
R2449 AVSS_n667 AVSS_n415 0.00166667
R2450 AVSS_n259 AVSS_n150 0.00166667
R2451 AVSS_n571 AVSS_n538 0.00166667
R2452 AVSS_n803 AVSS_n107 0.00162501
R2453 AVSS_n671 AVSS_n407 0.00162501
R2454 AVSS_n425 AVSS_n407 0.00137498
R2455 AVSS_n803 AVSS_n802 0.00137498
R2456 AVSS_n690 AVSS_n683 0.00133332
R2457 AVSS_n591 AVSS_n538 0.00133332
R2458 AVSS_n256 AVSS_n150 0.00133332
R2459 AVSS_n415 AVSS_n413 0.00133332
R2460 AVSS_n668 AVSS_n667 0.00133332
R2461 AVSS_n507 AVSS_n506 0.00133332
R2462 AVSS_n619 AVSS_n618 0.00133332
R2463 AVSS_n609 AVSS_n491 0.00133332
R2464 AVSS_n607 AVSS_n606 0.00133332
R2465 AVSS_n648 AVSS_n647 0.00133332
R2466 AVSS_n636 AVSS_n430 0.00133332
R2467 AVSS_n629 AVSS_n628 0.00133332
R2468 AVSS_n528 AVSS_n512 0.00133332
R2469 AVSS_n732 AVSS_n278 0.00133332
R2470 AVSS_n299 AVSS_n298 0.00133332
R2471 AVSS_n314 AVSS_n297 0.00133332
R2472 AVSS_n313 AVSS_n303 0.00133332
R2473 AVSS_n312 AVSS_n296 0.00133332
R2474 AVSS_n770 AVSS_n111 0.00133332
R2475 AVSS_n760 AVSS_n751 0.00133332
R2476 AVSS_n758 AVSS_n116 0.00133332
R2477 AVSS_n97 AVSS_n77 0.00133332
R2478 AVSS_n100 AVSS_n99 0.00133332
R2479 AVSS_n787 AVSS_n104 0.00133332
R2480 AVSS_n785 AVSS_n105 0.00133332
R2481 AVSS_n783 AVSS_n94 0.00133332
R2482 AVSS_n806 AVSS_n805 0.00133332
R2483 AVSS_n656 AVSS_n420 0.00133332
R2484 AVSS_n692 AVSS_n691 0.00124998
R2485 AVSS_n596 AVSS_n595 0.00124998
R2486 AVSS_n749 AVSS_n119 0.00124998
R2487 AVSS_n653 AVSS_n652 0.00124998
R2488 AVSS_n599 AVSS_n515 0.00124998
R2489 AVSS_n746 AVSS_n262 0.00124998
R2490 AVSS_n685 AVSS_n380 0.001
R2491 AVSS_n692 AVSS_n381 0.001
R2492 AVSS_n694 AVSS_n380 0.001
R2493 AVSS_n694 AVSS_n381 0.001
R2494 AVSS_n376 AVSS_n338 0.001
R2495 AVSS_n707 AVSS_n370 0.001
R2496 AVSS_n706 AVSS_n375 0.001
R2497 AVSS_n702 AVSS_n374 0.001
R2498 AVSS_n698 AVSS_n371 0.001
R2499 AVSS_n698 AVSS_n373 0.001
R2500 AVSS_n710 AVSS_n709 0.001
R2501 AVSS_n376 AVSS_n373 0.001
R2502 AVSS_n700 AVSS_n371 0.001
R2503 AVSS_n700 AVSS_n374 0.001
R2504 AVSS_n702 AVSS_n375 0.001
R2505 AVSS_n707 AVSS_n706 0.001
R2506 AVSS_n709 AVSS_n370 0.001
R2507 AVSS_n592 AVSS_n591 0.001
R2508 AVSS_n594 AVSS_n559 0.001
R2509 AVSS_n563 AVSS_n560 0.001
R2510 AVSS_n562 AVSS_n561 0.001
R2511 AVSS_n571 AVSS_n546 0.001
R2512 AVSS_n250 AVSS_n148 0.001
R2513 AVSS_n260 AVSS_n148 0.001
R2514 AVSS_n247 AVSS_n152 0.001
R2515 AVSS_n248 AVSS_n247 0.001
R2516 AVSS_n246 AVSS_n122 0.001
R2517 AVSS_n482 AVSS_n396 0.001
R2518 AVSS_n680 AVSS_n679 0.001
R2519 AVSS_n400 AVSS_n394 0.001
R2520 AVSS_n459 AVSS_n395 0.001
R2521 AVSS_n459 AVSS_n398 0.001
R2522 AVSS_n458 AVSS_n397 0.001
R2523 AVSS_n479 AVSS_n465 0.001
R2524 AVSS_n478 AVSS_n469 0.001
R2525 AVSS_n472 AVSS_n470 0.001
R2526 AVSS_n475 AVSS_n471 0.001
R2527 AVSS_n670 AVSS_n413 0.001
R2528 AVSS_n662 AVSS_n416 0.001
R2529 AVSS_n662 AVSS_n418 0.001
R2530 AVSS_n424 AVSS_n422 0.001
R2531 AVSS_n429 AVSS_n428 0.001
R2532 AVSS_n425 AVSS_n423 0.001
R2533 AVSS_n622 AVSS_n621 0.001
R2534 AVSS_n615 AVSS_n508 0.001
R2535 AVSS_n606 AVSS_n510 0.001
R2536 AVSS_n605 AVSS_n601 0.001
R2537 AVSS_n626 AVSS_n493 0.001
R2538 AVSS_n626 AVSS_n504 0.001
R2539 AVSS_n582 AVSS_n545 0.001
R2540 AVSS_n585 AVSS_n575 0.001
R2541 AVSS_n581 AVSS_n577 0.001
R2542 AVSS_n584 AVSS_n545 0.001
R2543 AVSS_n651 AVSS_n485 0.001
R2544 AVSS_n646 AVSS_n645 0.001
R2545 AVSS_n644 AVSS_n487 0.001
R2546 AVSS_n628 AVSS_n490 0.001
R2547 AVSS_n634 AVSS_n633 0.001
R2548 AVSS_n633 AVSS_n433 0.001
R2549 AVSS_n534 AVSS_n526 0.001
R2550 AVSS_n527 AVSS_n526 0.001
R2551 AVSS_n532 AVSS_n531 0.001
R2552 AVSS_n236 AVSS_n235 0.001
R2553 AVSS_n236 AVSS_n173 0.001
R2554 AVSS_n227 AVSS_n226 0.001
R2555 AVSS_n224 AVSS_n223 0.001
R2556 AVSS_n180 AVSS_n177 0.001
R2557 AVSS_n217 AVSS_n179 0.001
R2558 AVSS_n233 AVSS_n232 0.001
R2559 AVSS_n232 AVSS_n221 0.001
R2560 AVSS_n745 AVSS_n275 0.001
R2561 AVSS_n743 AVSS_n275 0.001
R2562 AVSS_n738 AVSS_n276 0.001
R2563 AVSS_n738 AVSS_n289 0.001
R2564 AVSS_n736 AVSS_n288 0.001
R2565 AVSS_n732 AVSS_n277 0.001
R2566 AVSS_n730 AVSS_n279 0.001
R2567 AVSS_n726 AVSS_n287 0.001
R2568 AVSS_n726 AVSS_n280 0.001
R2569 AVSS_n724 AVSS_n281 0.001
R2570 AVSS_n722 AVSS_n282 0.001
R2571 AVSS_n720 AVSS_n283 0.001
R2572 AVSS_n718 AVSS_n284 0.001
R2573 AVSS_n716 AVSS_n285 0.001
R2574 AVSS_n714 AVSS_n286 0.001
R2575 AVSS_n329 AVSS_n328 0.001
R2576 AVSS_n298 AVSS_n291 0.001
R2577 AVSS_n316 AVSS_n300 0.001
R2578 AVSS_n315 AVSS_n301 0.001
R2579 AVSS_n314 AVSS_n302 0.001
R2580 AVSS_n326 AVSS_n325 0.001
R2581 AVSS_n309 AVSS_n295 0.001
R2582 AVSS_n307 AVSS_n294 0.001
R2583 AVSS_n305 AVSS_n293 0.001
R2584 AVSS_n780 AVSS_n109 0.001
R2585 AVSS_n777 AVSS_n776 0.001
R2586 AVSS_n775 AVSS_n753 0.001
R2587 AVSS_n772 AVSS_n752 0.001
R2588 AVSS_n768 AVSS_n112 0.001
R2589 AVSS_n766 AVSS_n113 0.001
R2590 AVSS_n764 AVSS_n114 0.001
R2591 AVSS_n762 AVSS_n115 0.001
R2592 AVSS_n756 AVSS_n117 0.001
R2593 AVSS_n791 AVSS_n96 0.001
R2594 AVSS_n789 AVSS_n101 0.001
R2595 AVSS_n788 AVSS_n102 0.001
R2596 AVSS_n787 AVSS_n103 0.001
R2597 AVSS_n785 AVSS_n95 0.001
R2598 AVSS_n783 AVSS_n106 0.001
R2599 AVSS_n779 AVSS_n107 0.001
R2600 AVSS_n243 AVSS_n242 0.001
R2601 AVSS_n242 AVSS_n158 0.001
R2602 AVSS_n165 AVSS_n157 0.001
R2603 AVSS_n161 AVSS_n154 0.001
R2604 AVSS_n161 AVSS_n156 0.001
R2605 AVSS_n159 AVSS_n155 0.001
R2606 AVSS_n72 AVSS_n65 0.001
R2607 AVSS_n72 AVSS_n63 0.001
R2608 AVSS_n70 AVSS_n66 0.001
R2609 AVSS_n818 AVSS_n67 0.001
R2610 AVSS_n214 AVSS_n155 0.001
R2611 AVSS_n159 AVSS_n156 0.001
R2612 AVSS_n163 AVSS_n154 0.001
R2613 AVSS_n163 AVSS_n157 0.001
R2614 AVSS_n165 AVSS_n158 0.001
R2615 AVSS_n243 AVSS_n68 0.001
R2616 AVSS_n214 AVSS_n65 0.001
R2617 AVSS_n71 AVSS_n63 0.001
R2618 AVSS_n71 AVSS_n66 0.001
R2619 AVSS_n70 AVSS_n67 0.001
R2620 AVSS_n754 AVSS_n117 0.001
R2621 AVSS_n760 AVSS_n115 0.001
R2622 AVSS_n762 AVSS_n114 0.001
R2623 AVSS_n764 AVSS_n113 0.001
R2624 AVSS_n766 AVSS_n112 0.001
R2625 AVSS_n770 AVSS_n752 0.001
R2626 AVSS_n772 AVSS_n753 0.001
R2627 AVSS_n777 AVSS_n775 0.001
R2628 AVSS_n776 AVSS_n109 0.001
R2629 AVSS_n780 AVSS_n779 0.001
R2630 AVSS_n790 AVSS_n96 0.001
R2631 AVSS_n790 AVSS_n101 0.001
R2632 AVSS_n789 AVSS_n102 0.001
R2633 AVSS_n788 AVSS_n103 0.001
R2634 AVSS_n786 AVSS_n95 0.001
R2635 AVSS_n784 AVSS_n106 0.001
R2636 AVSS_n286 AVSS_n149 0.001
R2637 AVSS_n714 AVSS_n285 0.001
R2638 AVSS_n716 AVSS_n284 0.001
R2639 AVSS_n718 AVSS_n283 0.001
R2640 AVSS_n720 AVSS_n282 0.001
R2641 AVSS_n722 AVSS_n281 0.001
R2642 AVSS_n724 AVSS_n280 0.001
R2643 AVSS_n728 AVSS_n287 0.001
R2644 AVSS_n728 AVSS_n279 0.001
R2645 AVSS_n734 AVSS_n277 0.001
R2646 AVSS_n734 AVSS_n288 0.001
R2647 AVSS_n736 AVSS_n289 0.001
R2648 AVSS_n742 AVSS_n276 0.001
R2649 AVSS_n743 AVSS_n742 0.001
R2650 AVSS_n746 AVSS_n745 0.001
R2651 AVSS_n328 AVSS_n149 0.001
R2652 AVSS_n329 AVSS_n291 0.001
R2653 AVSS_n317 AVSS_n300 0.001
R2654 AVSS_n316 AVSS_n301 0.001
R2655 AVSS_n315 AVSS_n302 0.001
R2656 AVSS_n326 AVSS_n304 0.001
R2657 AVSS_n304 AVSS_n295 0.001
R2658 AVSS_n309 AVSS_n294 0.001
R2659 AVSS_n307 AVSS_n293 0.001
R2660 AVSS_n223 AVSS_n173 0.001
R2661 AVSS_n225 AVSS_n224 0.001
R2662 AVSS_n226 AVSS_n225 0.001
R2663 AVSS_n227 AVSS_n221 0.001
R2664 AVSS_n235 AVSS_n177 0.001
R2665 AVSS_n217 AVSS_n180 0.001
R2666 AVSS_n216 AVSS_n179 0.001
R2667 AVSS_n233 AVSS_n216 0.001
R2668 AVSS_n710 AVSS_n338 0.001
R2669 AVSS_n532 AVSS_n528 0.001
R2670 AVSS_n531 AVSS_n527 0.001
R2671 AVSS_n535 AVSS_n534 0.001
R2672 AVSS_n487 AVSS_n430 0.001
R2673 AVSS_n645 AVSS_n644 0.001
R2674 AVSS_n648 AVSS_n485 0.001
R2675 AVSS_n637 AVSS_n490 0.001
R2676 AVSS_n634 AVSS_n630 0.001
R2677 AVSS_n653 AVSS_n433 0.001
R2678 AVSS_n582 AVSS_n581 0.001
R2679 AVSS_n577 AVSS_n576 0.001
R2680 AVSS_n576 AVSS_n575 0.001
R2681 AVSS_n585 AVSS_n584 0.001
R2682 AVSS_n618 AVSS_n508 0.001
R2683 AVSS_n621 AVSS_n506 0.001
R2684 AVSS_n622 AVSS_n504 0.001
R2685 AVSS_n610 AVSS_n510 0.001
R2686 AVSS_n602 AVSS_n601 0.001
R2687 AVSS_n602 AVSS_n493 0.001
R2688 AVSS_n420 AVSS_n418 0.001
R2689 AVSS_n419 AVSS_n416 0.001
R2690 AVSS_n671 AVSS_n670 0.001
R2691 AVSS_n657 AVSS_n422 0.001
R2692 AVSS_n429 AVSS_n424 0.001
R2693 AVSS_n428 AVSS_n423 0.001
R2694 AVSS_n457 AVSS_n396 0.001
R2695 AVSS_n457 AVSS_n397 0.001
R2696 AVSS_n458 AVSS_n398 0.001
R2697 AVSS_n400 AVSS_n395 0.001
R2698 AVSS_n679 AVSS_n394 0.001
R2699 AVSS_n680 AVSS_n399 0.001
R2700 AVSS_n482 AVSS_n465 0.001
R2701 AVSS_n479 AVSS_n478 0.001
R2702 AVSS_n470 AVSS_n469 0.001
R2703 AVSS_n472 AVSS_n471 0.001
R2704 AVSS_n260 AVSS_n259 0.001
R2705 AVSS_n251 AVSS_n250 0.001
R2706 AVSS_n251 AVSS_n152 0.001
R2707 AVSS_n248 AVSS_n246 0.001
R2708 AVSS_n749 AVSS_n122 0.001
R2709 AVSS_n592 AVSS_n562 0.001
R2710 AVSS_n563 AVSS_n561 0.001
R2711 AVSS_n560 AVSS_n559 0.001
R2712 AVSS_n595 AVSS_n594 0.001
R2713 AVSS_n547 AVSS_n546 0.001
C0 IBIAS pn13 0.01526f
C1 pn23 pn17 0.3878f
C2 s[3] pn17 0.26269f
C3 pn23 pn24 0.0797f
C4 pn4 pn5 2.27021f
C5 VOUT a_8814_818_ 0.01853f
C6 pn17 a_n6936_3817_ 0.08845f
C7 pn31 pn15 0.20624f
C8 pn4 pn3 0.45979f
C9 pn28 pn27 0.02561f
C10 pn21 a_n6936_3817_ 0.01195f
C11 pn26 a_n6936_3817_ 0.02425f
C12 VCM pn15 0.01993f
C13 pn23 pn5 0.04589f
C14 pn1 a_n2575_n8668_ 0.0275f
C15 pn25 a_n6936_3817_ 0.02758f
C16 AVDD pn32 6.27803f
C17 VCM pn31 1.68139f
C18 s[3] pn5 0.096f
C19 pn5 a_n6936_3817_ 0.08729f
C20 AVDD VOUT 2.30455f
C21 s[4] a_n1976_4554_ 0.13296f
C22 s[1] pn35 0.02074f
C23 s[3] pn27 0.01101f
C24 AVDD pn34 0.70879f
C25 s[0] pn35 0.05441f
C26 AVDD pn29 11.0694f
C27 pn12 pn32 0.16069f
C28 pn2 pn15 0.42393f
C29 pn11 pn31 1.07882f
C30 pn30 VCM 0.01565f
C31 AVDD pn35 46.8678f
C32 s[2] pn18 0.08378f
C33 pn24 pn17 0.07725f
C34 pn12 VOUT 0.97386f
C35 pn2 pn31 0.3585f
C36 pn14 pn15 0.01193f
C37 pn11 VCM 0.04431f
C38 AVDD pn10 2.04699f
C39 s[2] pn22 0.04661f
C40 pn17 pn21 0.05f
C41 pn26 pn17 0.32634f
C42 AVDD pn20 0.46548f
C43 pn2 VCM 0.02242f
C44 pn14 pn31 0.01692f
C45 a_n1976_4834_ pn5 0.07866f
C46 AVDD pn33 5.10986f
C47 AVDD pn19 0.46357f
C48 s[1] pn22 0.08461f
C49 pn25 pn17 0.35357f
C50 pn14 VCM 0.14897f
C51 a_n1976_4834_ pn27 0.03272f
C52 pn5 pn17 1.16105f
C53 AVDD pn18 0.46516f
C54 pn12 pn10 0.10851f
C55 pn14 pn30 0.17186f
C56 pn2 pn11 0.13716f
C57 a_n1976_4834_ pn3 0.05954f
C58 AVDD pn22 0.41824f
C59 pn25 pn21 0.01136f
C60 pn27 pn17 0.32072f
C61 pn5 pn24 0.02022f
C62 pn1 pn10 0.67514f
C63 pn14 pn11 0.18634f
C64 s[1] a_n8617_3817_ 0.01977f
C65 pn7 pn36 0.02469f
C66 pn6 pn8 0.20241f
C67 pn3 pn17 0.28573f
C68 pn5 pn26 0.03213f
C69 pn14 pn2 0.30114f
C70 pn11 IBIAS 0.3157f
C71 pn7 pn8 0.11576f
C72 pn5 pn25 0.04412f
C73 pn13 pn33 0.1093f
C74 AVDD a_n8617_3817_ 0.01852f
C75 pn2 IBIAS 0.14684f
C76 pn7 pn6 0.32428f
C77 pn17 pn16 0.1856f
C78 pn14 IBIAS 0.10035f
C79 s[4] pn6 0.18512f
C80 s[4] a_n1976_5114_ 0.22971f
C81 pn27 pn5 0.46679f
C82 s[4] pn7 0.0529f
C83 pn4 AVDD 0.05776f
C84 pn23 s[2] 0.11904f
C85 pn3 pn5 0.76119f
C86 pn22 a_n3910_3817_ 0.01262f
C87 s[3] s[2] 5.13483f
C88 pn23 s[1] 0.11937f
C89 pn15 pn32 0.73924f
C90 a_2199_n6987_ pn12 0.06289f
C91 pn11 a_n2575_n8668_ 0.13861f
C92 s[3] s[1] 0.05292f
C93 pn23 s[0] 0.6109f
C94 s[1] a_n6936_3817_ 0.05536f
C95 pn31 pn32 0.52945f
C96 pn15 VOUT 0.22442f
C97 s[3] s[0] 0.05725f
C98 pn2 a_n2575_n8668_ 0.0609f
C99 pn23 AVDD 0.42657f
C100 pn15 pn34 0.11326f
C101 VCM pn32 0.29697f
C102 pn31 VOUT 1.44764f
C103 pn15 pn29 0.02725f
C104 s[3] AVDD 0.97155f
C105 AVDD a_n6936_3817_ 0.02943f
C106 VCM VOUT 0.123f
C107 pn31 pn34 0.31876f
C108 pn31 pn29 0.52777f
C109 IBIAS a_n2575_n8668_ 0.01527f
C110 pn15 pn10 0.39181f
C111 VCM pn34 0.45405f
C112 VCM pn29 1.39878f
C113 pn15 pn33 0.10314f
C114 pn31 pn10 0.34986f
C115 pn11 VOUT 0.02504f
C116 VCM VIN 0.04063f
C117 s[2] pn17 1.00914f
C118 pn2 pn32 1.4573f
C119 VCM pn35 0.10604f
C120 pn31 pn33 1.1511f
C121 VCM pn10 0.13481f
C122 pn14 pn32 0.57012f
C123 pn11 pn34 1.06048f
C124 pn2 VOUT 0.89516f
C125 s[1] pn17 0.48256f
C126 pn30 pn35 0.02269f
C127 VCM pn33 0.3573f
C128 s[2] pn26 0.01759f
C129 pn2 pn34 0.20503f
C130 pn14 VOUT 0.12863f
C131 s[0] pn17 0.29142f
C132 pn30 pn10 0.0148f
C133 pn11 pn35 0.03972f
C134 pn5 a_8814_818_ 0.01807f
C135 AVDD pn17 9.60599f
C136 s[0] pn24 0.10066f
C137 pn4 a_n1976_4554_ 0.01316f
C138 pn14 pn34 0.27056f
C139 pn11 pn10 0.19451f
C140 s[1] pn21 0.0161f
C141 s[1] pn26 0.029f
C142 pn14 pn29 0.1344f
C143 s[3] a_n3910_3817_ 0.0202f
C144 s[1] pn25 0.01763f
C145 pn11 pn33 0.04234f
C146 s[2] pn5 0.20396f
C147 s[0] pn21 0.07862f
C148 AVDD pn24 0.44304f
C149 pn14 pn35 0.03181f
C150 s[0] pn25 0.01635f
C151 pn2 pn33 0.59982f
C152 s[1] pn5 0.71669f
C153 AVDD pn21 0.51423f
C154 AVDD pn26 0.04028f
C155 pn14 pn10 0.01743f
C156 s[2] pn27 0.03694f
C157 IBIAS pn35 0.63956f
C158 pn14 pn33 0.46747f
C159 s[0] pn5 0.01079f
C160 AVDD pn25 0.04166f
C161 IBIAS pn10 0.18368f
C162 s[4] pn20 0.07887f
C163 AVDD pn5 0.14243f
C164 s[4] pn19 0.06011f
C165 AVDD pn27 0.03448f
C166 pn17 a_n3910_3817_ 0.17196f
C167 AVDD pn3 0.04637f
C168 pn34 a_n2575_n8668_ 0.036f
C169 pn26 a_n3910_3817_ 0.02602f
C170 AVDD pn16 19.1691f
C171 a_n1976_4834_ a_n1976_4554_ 1.17654f
C172 VOUT pn32 1.35215f
C173 pn5 a_n3910_3817_ 0.1755f
C174 pn4 a_n1976_5114_ 0.02044f
C175 pn34 pn32 0.20728f
C176 pn29 pn32 0.11688f
C177 pn27 a_n3910_3817_ 0.08325f
C178 pn28 a_n1976_5114_ 0.02317f
C179 pn29 VOUT 0.29706f
C180 pn35 pn32 0.04374f
C181 pn8 pn23 0.08063f
C182 s[4] pn4 0.13948f
C183 pn10 pn32 0.81654f
C184 pn29 pn34 0.82491f
C185 s[4] pn28 0.04204f
C186 pn6 pn23 0.02724f
C187 pn10 VOUT 0.02167f
C188 pn33 pn32 0.16354f
C189 pn35 pn29 2.92399f
C190 a_n1976_4554_ pn5 0.20416f
C191 s[3] pn6 0.07235f
C192 pn6 pn38 0.01299f
C193 pn7 pn23 0.01905f
C194 pn10 pn34 0.54154f
C195 pn33 VOUT 0.07765f
C196 s[1] s[2] 3.8126f
C197 a_n1976_4554_ pn27 0.26159f
C198 s[3] pn7 0.03022f
C199 s[4] pn23 1.01554f
C200 pn33 pn34 1.06987f
C201 pn29 pn33 0.19957f
C202 pn35 pn10 0.44685f
C203 s[0] s[2] 0.05726f
C204 a_n1976_4554_ pn3 0.25617f
C205 s[3] s[4] 4.21954f
C206 pn7 pn37 0.02805f
C207 pn35 pn33 0.0288f
C208 s[0] s[1] 0.66286f
C209 AVDD s[2] 0.36359f
C210 pn33 pn10 0.06846f
C211 AVDD s[1] 0.39769f
C212 VIN a_n9265_n1723_ 0.04968f
C213 a_n1976_5114_ a_n1976_4834_ 1.17654f
C214 AVDD s[0] 0.6494f
C215 a_2199_n6987_ pn32 0.0438f
C216 s[4] a_n1976_4834_ 0.14571f
C217 s[4] pn17 0.53533f
C218 s[2] a_n3910_3817_ 0.04148f
C219 pn6 pn5 0.01211f
C220 VCM pn16 0.56665f
C221 a_n1976_5114_ pn5 0.04536f
C222 a_2199_n6987_ pn10 0.01072f
C223 pn30 pn16 0.02718f
C224 pn4 pn20 0.0183f
C225 a_n1976_5114_ pn27 0.01325f
C226 AVDD a_n3910_3817_ 0.01197f
C227 s[4] pn5 1.76737f
C228 pn11 pn16 1.59468f
C229 a_n1976_5114_ pn3 0.01602f
C230 s[4] pn27 0.29311f
C231 s[3] pn29 0.01021f
C232 s[3] pn35 0.14562f
C233 s[4] pn3 0.14375f
C234 pn14 pn16 0.3042f
C235 IBIAS pn16 0.3852f
C236 s[3] pn19 0.07915f
C237 pn17 pn32 0.03986f
C238 s[3] pn18 0.14144f
C239 pn17 VOUT 0.01327f
C240 s[3] pn22 0.0142f
C241 pn17 pn34 1.99073f
C242 pn17 pn29 1.7346f
C243 pn17 VIN 0.02443f
C244 pn17 pn35 0.42047f
C245 pn15 AVDD 6.00111f
C246 pn17 pn10 0.01973f
C247 pn17 pn20 0.01621f
C248 pn31 AVDD 0.83763f
C249 a_n1976_4554_ a_n3910_3817_ 0.1345f
C250 pn17 pn33 0.28864f
C251 pn17 pn19 0.07109f
C252 VCM AVDD 7.25207f
C253 pn17 pn18 0.06486f
C254 pn30 AVDD 1.80953f
C255 pn17 a_n9265_n1723_ 0.04968f
C256 pn36 AVDD 0.0137f
C257 pn7 s[2] 0.12004f
C258 pn17 pn22 0.04558f
C259 pn11 AVDD 0.81214f
C260 pn16 pn32 0.52315f
C261 pn7 s[1] 0.15914f
C262 pn8 AVDD 0.28378f
C263 s[4] s[2] 0.07995f
C264 pn2 AVDD 1.18142f
C265 pn6 AVDD 0.25632f
C266 s[4] s[1] 0.06837f
C267 pn7 s[0] 0.04253f
C268 pn26 pn22 0.01044f
C269 pn14 AVDD 5.28473f
C270 pn17 a_n8617_3817_ 0.04583f
C271 s[3] pn23 0.17179f
C272 pn7 AVDD 0.44972f
C273 s[4] s[0] 0.07802f
C274 pn3 pn20 0.0127f
C275 AVDD IBIAS 0.02179f
C276 pn24 a_n8617_3817_ 0.01344f
C277 pn11 pn1 0.01807f
C278 pn35 pn16 2.40691f
C279 s[4] AVDD 0.38566f
C280 pn27 pn18 0.01065f
C281 pn3 pn19 0.02484f
C282 pn11 pn13 0.01521f
C283 pn28 a_n1976_4834_ 0.02317f
C284 pn16 pn10 1.33154f
C285 pn4 pn17 0.18577f
C286 pn25 a_n8617_3817_ 0.024f
C287 pn2 pn13 0.09267f
C288 pn16 pn33 0.57521f
C289 pn5 a_n8617_3817_ 0.07357f
C290 pn14 pn13 0.01014f
C291 pn12 AVSS 6.70652f
C292 pn1 AVSS 8.74284f
C293 IBIAS AVSS 9.83004f
C294 pn31 AVSS 9.75035f
C295 VCM AVSS 2.46411f
C296 pn30 AVSS 0.11377f
C297 pn2 AVSS 3.95104f
C298 pn32 AVSS 9.24403f
C299 VOUT AVSS 16.33774f
C300 pn34 AVSS 8.10937f
C301 VIN AVSS 0.81002f
C302 pn33 AVSS 5.90261f
C303 pn29 AVSS 1.07173f
C304 pn35 AVSS 7.03115f
C305 pn17 AVSS 9.18876f
C306 pn26 AVSS 1.49801f
C307 pn25 AVSS 1.05917f
C308 pn5 AVSS 7.28338f
C309 pn27 AVSS 5.7334f
C310 pn3 AVSS 3.08503f
C311 pn4 AVSS 1.92869f
C312 pn28 AVSS 3.07404f
C313 pn9 AVSS 0.40226f
C314 pn38 AVSS 0.02411f
C315 pn37 AVSS 0.22316f
C316 pn36 AVSS 0.22617f
C317 pn8 AVSS 0.4477f
C318 pn6 AVSS 0.70878f
C319 pn7 AVSS 1.11881f
C320 s[4] AVSS 6.00477f
C321 s[3] AVSS 5.01198f
C322 s[2] AVSS 3.17531f
C323 s[1] AVSS 2.75012f
C324 s[0] AVSS 3.29455f
C325 AVDD AVSS 3.37495f
C326 AVSS_t15 AVSS 0.07553f
C327 AVSS_t16 AVSS 0.09248f
C328 AVSS_t9 AVSS 0.14526f
C329 AVSS_t1 AVSS 0.16878f
C330 AVSS_t32 AVSS 0.19011f
C331 AVSS_t29 AVSS 0.12921f
C332 AVSS_t4 AVSS 0.12169f
C333 AVSS_t24 AVSS 0.1159f
C334 AVSS_t7 AVSS 0.09996f
C335 AVSS_t35 AVSS 0.05587f
C336 AVSS_t38 AVSS 0.03792f
C337 AVSS_t12 AVSS 0.10074f
C338 AVSS_t46 AVSS 0.53044f
C339 AVSS_t52 AVSS 0.28779f
C340 AVSS_t50 AVSS 0.52099f
C341 AVSS_t48 AVSS 6.04481f
C342 AVSS_t60 AVSS 0.07982f
C343 AVSS_t54 AVSS 0.10697f
C344 AVSS_t56 AVSS 0.25129f
C345 AVSS_t58 AVSS 0.09196f
C346 AVSS_t62 AVSS 0.13247f
C347 AVSS_t27 AVSS 1.08502f
C348 AVSS_t42 AVSS 0.49258f
C349 AVDD_n1 AVSS 0.01104f
C350 AVDD_n2 AVSS 0.01104f
C351 AVDD_n3 AVSS 0.01104f
C352 AVDD_n4 AVSS 0.01656f
C353 AVDD_n5 AVSS 0.01104f
C354 AVDD_n6 AVSS 0.01275f
C355 AVDD_n7 AVSS 0.01827f
C356 AVDD_n8 AVSS 0.01104f
C357 AVDD_n9 AVSS 0.01104f
C358 AVDD_n10 AVSS 0.01656f
C359 AVDD_n11 AVSS 0.01104f
C360 AVDD_n12 AVSS 0.14354f
C361 AVDD_n13 AVSS 0.42414f
C362 AVDD_n14 AVSS 0.02027f
C363 AVDD_n15 AVSS 0.04781f
C364 AVDD_n16 AVSS 0.25786f
C365 AVDD_n17 AVSS 0.01201f
C366 AVDD_n18 AVSS 0.09443f
C367 AVDD_n19 AVSS 0.50176f
C368 AVDD_n20 AVSS 0.03576f
C369 AVDD_n21 AVSS 0.38712f
C370 AVDD_t18 AVSS 1.45755f
C371 AVDD_n22 AVSS 0.093f
C372 AVDD_n23 AVSS 0.04512f
C373 AVDD_t33 AVSS 8.23899f
C374 AVDD_n37 AVSS 1.22326f
C375 AVDD_n43 AVSS 0.61163f
C376 AVDD_n44 AVSS 0.61163f
C377 AVDD_n46 AVSS 0.61163f
C378 AVDD_n47 AVSS 0.61163f
C379 AVDD_n48 AVSS 0.61163f
C380 AVDD_n50 AVSS 0.61163f
C381 AVDD_t58 AVSS 0.61163f
C382 AVDD_t39 AVSS 1.22326f
C383 AVDD_n56 AVSS 0.61163f
C384 AVDD_n58 AVSS 0.61163f
C385 AVDD_n61 AVSS 0.61163f
C386 AVDD_n62 AVSS 0.61163f
C387 AVDD_n64 AVSS 0.61163f
C388 AVDD_n65 AVSS 0.61163f
C389 AVDD_t17 AVSS 2.31159f
C390 AVDD_n67 AVSS 0.36925f
C391 AVDD_n68 AVSS 0.65634f
C392 AVDD_n69 AVSS 1.83488f
C393 AVDD_n70 AVSS 0.06309f
C394 AVDD_n81 AVSS 0.12397f
C395 AVDD_n82 AVSS 0.47578f
C396 AVDD_t68 AVSS 1.88654f
C397 AVDD_n83 AVSS 0.04332f
C398 AVDD_t67 AVSS 1.22479f
C399 AVDD_n84 AVSS 0.11187f
C400 AVDD_n85 AVSS 4.58721f
C401 AVDD_t66 AVSS 0.61163f
C402 AVDD_n93 AVSS 0.61163f
C403 AVDD_n95 AVSS 0.01579f
C404 AVDD_n98 AVSS 0.78252f
C405 AVDD_n102 AVSS 1.22326f
C406 AVDD_n103 AVSS 0.61163f
C407 AVDD_t49 AVSS 0.44073f
C408 AVDD_n105 AVSS 0.93543f
C409 AVDD_n106 AVSS 0.61163f
C410 AVDD_n107 AVSS 0.10737f
C411 AVDD_n108 AVSS 1.83488f
C412 AVDD_n110 AVSS 1.22326f
C413 AVDD_n111 AVSS 1.22326f
C414 AVDD_n112 AVSS 1.22326f
C415 AVDD_t30 AVSS 2.3026f
C416 AVDD_n114 AVSS 1.22326f
C417 AVDD_n115 AVSS 0.01104f
C418 AVDD_n116 AVSS 0.01471f
C419 AVDD_n117 AVSS 1.83488f
C420 AVDD_n119 AVSS 0.01473f
C421 AVDD_n120 AVSS 0.01656f
C422 AVDD_n121 AVSS 1.22326f
C423 AVDD_n123 AVSS 0.01104f
C424 AVDD_n126 AVSS 0.01656f
C425 AVDD_n127 AVSS 0.01289f
C426 AVDD_n128 AVSS 0.01362f
C427 AVDD_n129 AVSS 0.01335f
C428 AVDD_n131 AVSS 0.01104f
C429 AVDD_n133 AVSS 0.01104f
C430 AVDD_n135 AVSS 0.01104f
C431 AVDD_n136 AVSS 0.05953f
C432 AVDD_n137 AVSS 0.01104f
C433 AVDD_n138 AVSS 0.01288f
C434 AVDD_n139 AVSS 0.01362f
C435 AVDD_n140 AVSS 0.01656f
C436 AVDD_n142 AVSS 0.01299f
C437 AVDD_n144 AVSS 0.97141f
C438 AVDD_n145 AVSS 0.3095f
C439 AVDD_n146 AVSS 0.05174f
C440 AVDD_n147 AVSS 0.15835f
C441 AVDD_n148 AVSS 0.1391f
C442 AVDD_t47 AVSS 0.61163f
C443 AVDD_n150 AVSS 0.61163f
C444 AVDD_n151 AVSS 0.61163f
C445 AVDD_n152 AVSS 0.61163f
C446 AVDD_t60 AVSS 0.61163f
C447 AVDD_n153 AVSS 0.61163f
C448 AVDD_n154 AVSS 0.61163f
C449 AVDD_n155 AVSS 0.61163f
C450 AVDD_n156 AVSS 0.61163f
C451 AVDD_n157 AVSS 0.61163f
C452 AVDD_t31 AVSS 1.22326f
C453 AVDD_t63 AVSS 0.61163f
C454 AVDD_t64 AVSS 0.61163f
C455 AVDD_n158 AVSS 0.61163f
C456 AVDD_n160 AVSS 0.72856f
C457 AVDD_n162 AVSS 0.61163f
C458 AVDD_n163 AVSS 0.61163f
C459 AVDD_t57 AVSS 0.70157f
C460 AVDD_n164 AVSS 0.32437f
C461 AVDD_t56 AVSS 1.43761f
C462 AVDD_t55 AVSS 1.4202f
C463 AVDD_t54 AVSS 1.42021f
C464 AVDD_t53 AVSS 1.4202f
C465 AVDD_t52 AVSS 1.42021f
C466 AVDD_t50 AVSS 1.42021f
C467 AVDD_t48 AVSS 1.42021f
C468 AVDD_t32 AVSS 1.43856f
C469 AVDD_n165 AVSS 0.06974f
C470 AVDD_n166 AVSS 0.04994f
C471 AVDD_n167 AVSS 0.04995f
C472 AVDD_n168 AVSS 0.04995f
C473 AVDD_n169 AVSS 0.04995f
C474 AVDD_n170 AVSS 0.04995f
C475 AVDD_n171 AVSS 0.04246f
C476 AVDD_n172 AVSS 0.08025f
C477 AVDD_n173 AVSS 0.08982f
C478 AVDD_n174 AVSS 0.24149f
C479 AVDD_n183 AVSS 0.45499f
C480 AVDD_t62 AVSS 0.14023f
C481 AVDD_t65 AVSS 1.09619f
C482 AVDD_t61 AVSS 0.1395f
C483 AVDD_n184 AVSS 0.08544f
C484 AVDD_n185 AVSS 0.08152f
C485 AVDD_n186 AVSS 0.01726f
C486 AVDD_n187 AVSS 0.12212f
C487 AVDD_n188 AVSS 0.03343f
C488 AVDD_n190 AVSS 0.08844f
C489 AVDD_n191 AVSS 0.08432f
C490 AVDD_n192 AVSS 0.0611f
C491 AVDD_n193 AVSS 0.0866f
C492 AVDD_n194 AVSS 0.02161f
C493 AVDD_n197 AVSS 0.26046f
C494 AVDD_t51 AVSS 9.1866f
C495 AVDD_n200 AVSS 0.73294f
C496 AVDD_n201 AVSS 1.52907f
C497 AVDD_n202 AVSS 0.47578f
C498 AVDD_n203 AVSS 0.1932f
C499 AVDD_n204 AVSS 0.10579f
C500 AVDD_n205 AVSS 0.09136f
C501 AVDD_n206 AVSS 0.02875f
C502 AVDD_n207 AVSS 0.10333f
C503 AVDD_n208 AVSS 0.06918f
C504 AVDD_n209 AVSS 0.11653f
C505 AVDD_n210 AVSS 0.12421f
C506 AVDD_n211 AVSS 0.29461f
C507 AVDD_t29 AVSS 0.1117f
C508 AVDD_n212 AVSS 0.04985f
C509 AVDD_n213 AVSS 0.18545f
C510 AVDD_t59 AVSS 0.40752f
C511 AVDD_n214 AVSS 0.01249f
C512 AVDD_n216 AVSS 0.26046f
C513 AVDD_t27 AVSS 0.52307f
C514 AVDD_n218 AVSS 0.09109f
C515 AVDD_t24 AVSS 0.61163f
C516 AVDD_t26 AVSS 1.39415f
C517 AVDD_n224 AVSS 0.61163f
C518 AVDD_n226 AVSS 0.61163f
C519 AVDD_n227 AVSS 0.61163f
C520 AVDD_n229 AVSS 0.61163f
C521 AVDD_n230 AVSS 1.22326f
C522 AVDD_t35 AVSS 1.52907f
C523 AVDD_n231 AVSS 0.31242f
C524 AVDD_n232 AVSS 0.16941f
C525 AVDD_n233 AVSS 0.07185f
C526 AVDD_n234 AVSS 0.07363f
C527 AVDD_n235 AVSS 0.10778f
C528 AVDD_n236 AVSS 0.07496f
C529 AVDD_n237 AVSS 0.07984f
C530 AVDD_n238 AVSS 0.0122f
C531 AVDD_n239 AVSS 0.04436f
C532 AVDD_n241 AVSS 0.08086f
C533 AVDD_t22 AVSS 0.16003f
C534 AVDD_t23 AVSS 4.49172f
C535 AVDD_n242 AVSS 0.09607f
C536 AVDD_n243 AVSS 0.09755f
C537 AVDD_n244 AVSS 0.03701f
C538 AVDD_n245 AVSS 0.06347f
C539 AVDD_n246 AVSS 0.02304f
C540 AVDD_n247 AVSS 0.0591f
C541 AVDD_n248 AVSS 0.02469f
C542 AVDD_n249 AVSS 0.10005f
C543 AVDD_n250 AVSS 0.12096f
C544 AVDD_n251 AVSS 0.4033f
C545 AVDD_n252 AVSS 0.68525f
C546 AVDD_t46 AVSS 1.42023f
C547 AVDD_t44 AVSS 1.42021f
C548 AVDD_t42 AVSS 1.4202f
C549 AVDD_t40 AVSS 1.42021f
C550 AVDD_t38 AVSS 1.4202f
C551 AVDD_t37 AVSS 1.42021f
C552 AVDD_t36 AVSS 1.42021f
C553 AVDD_t34 AVSS 1.43853f
C554 AVDD_n254 AVSS 0.06975f
C555 AVDD_n255 AVSS 0.04995f
C556 AVDD_n256 AVSS 0.04996f
C557 AVDD_n257 AVSS 0.04994f
C558 AVDD_n258 AVSS 0.04996f
C559 AVDD_n259 AVSS 0.04995f
C560 AVDD_n260 AVSS 0.04245f
C561 AVDD_n261 AVSS 0.03529f
C562 AVDD_n263 AVSS 4.4433f
C563 AVDD_n265 AVSS 0.61163f
C564 AVDD_n267 AVSS 1.22326f
C565 AVDD_n269 AVSS 0.61163f
C566 AVDD_n271 AVSS 0.61163f
C567 AVDD_n273 AVSS 0.61163f
C568 AVDD_t45 AVSS 0.71956f
C569 AVDD_n276 AVSS 0.50369f
C570 AVDD_n278 AVSS 1.22326f
C571 AVDD_t19 AVSS 0.87697f
C572 AVDD_n281 AVSS 0.57115f
C573 AVDD_n283 AVSS 0.61163f
C574 AVDD_t43 AVSS 1.83488f
C575 AVDD_n286 AVSS 0.61163f
C576 AVDD_n288 AVSS 0.61163f
C577 AVDD_n290 AVSS 1.22326f
C578 AVDD_n292 AVSS 1.22326f
C579 AVDD_t41 AVSS 3.9486f
C580 AVDD_n294 AVSS 0.53683f
C581 AVDD_t25 AVSS 2.83355f
C582 AVDD_n295 AVSS 0.1042f
C583 AVDD_n296 AVSS 0.38796f
C584 AVDD_n297 AVSS 0.07744f
C585 AVDD_n298 AVSS 0.08828f
C586 AVDD_n299 AVSS 0.07983f
C587 AVDD_n300 AVSS 0.08462f
C588 AVDD_t20 AVSS 0.13024f
C589 AVDD_t21 AVSS 2.25198f
C590 AVDD_n301 AVSS 0.07049f
C591 AVDD_n302 AVSS 0.06681f
C592 AVDD_n303 AVSS 0.01516f
C593 AVDD_n304 AVSS 0.07646f
C594 AVDD_n305 AVSS 0.14935f
C595 AVDD_n306 AVSS 0.11661f
C596 AVDD_n307 AVSS 0.06397f
C597 AVDD_n308 AVSS 0.08903f
C598 AVDD_n309 AVSS 0.07988f
C599 AVDD_n310 AVSS 0.09835f
C600 AVDD_n311 AVSS 0.27378f
C601 AVDD_n312 AVSS 0.12407f
C602 AVDD_n313 AVSS 0.05103f
C603 AVDD_n314 AVSS 0.01289f
C604 AVDD_n315 AVSS 0.01288f
C605 AVDD_n316 AVSS 0.01288f
C606 AVDD_n317 AVSS 0.01469f
C607 AVDD_n318 AVSS 0.01449f
C608 AVDD_n319 AVSS 0.01288f
C609 AVDD_n320 AVSS 0.01289f
C610 AVDD_n321 AVSS 0.01288f
C611 AVDD_n322 AVSS 0.01055f
C612 AVDD_n323 AVSS 0.01308f
C613 AVDD_n324 AVSS 0.06791f
C614 AVDD_n325 AVSS 0.0687f
C615 AVDD_t16 AVSS 0.02151f
C616 AVDD_n326 AVSS 0.03844f
C617 AVDD_t15 AVSS 0.91015f
C618 AVDD_n327 AVSS 0.02341f
C619 AVDD_n328 AVSS 0.05078f
C620 AVDD_n329 AVSS 0.05593f
C621 AVDD_t14 AVSS 0.02134f
C622 AVDD_n330 AVSS 0.03194f
C623 AVDD_t13 AVSS 0.73364f
C624 AVDD_n332 AVSS 0.02341f
C625 AVDD_n333 AVSS 0.05438f
C626 AVDD_t11 AVSS 0.10262f
C627 AVDD_n334 AVSS 0.02811f
C628 AVDD_n335 AVSS 0.03083f
C629 AVDD_t70 AVSS 0.01576f
C630 AVDD_n336 AVSS 0.02353f
C631 AVDD_t0 AVSS 0.69123f
C632 AVDD_t12 AVSS 0.02273f
C633 AVDD_n338 AVSS 0.09377f
C634 AVDD_n339 AVSS 0.03422f
C635 AVDD_t3 AVSS 0.02257f
C636 AVDD_n340 AVSS 0.03227f
C637 AVDD_n341 AVSS 0.03294f
C638 AVDD_n342 AVSS 0.03118f
C639 AVDD_t10 AVSS 0.59598f
C640 AVDD_n344 AVSS 0.03899f
C641 AVDD_n345 AVSS 0.30868f
C642 AVDD_t2 AVSS 0.0218f
C643 AVDD_t1 AVSS 0.71051f
C644 AVDD_n346 AVSS 0.14345f
C645 AVDD_t8 AVSS 0.66809f
C646 AVDD_t9 AVSS 0.02237f
C647 AVDD_n347 AVSS 0.14928f
C648 AVDD_t4 AVSS 0.65662f
C649 AVDD_t5 AVSS 0.02237f
C650 AVDD_n348 AVSS 0.14928f
C651 AVDD_t6 AVSS 0.66235f
C652 AVDD_t7 AVSS 0.02237f
C653 AVDD_n349 AVSS 0.18262f
C654 AVDD_n350 AVSS 1.96447f
C655 AVDD_n351 AVSS 1.1738f
C656 AVDD_n352 AVSS 1.28712f
C657 AVDD_n353 AVSS 1.00349f
C658 AVDD_n354 AVSS 0.42798f
C659 AVDD_n355 AVSS 0.43045f
C660 AVDD_n356 AVSS 0.31087f
C661 s[0]_n0 AVSS 0.40935f
C662 s[0]_n1 AVSS 1.7125f
C663 s[1]_n0 AVSS 1.04594f
C664 s[1]_n1 AVSS 4.81101f
C665 s[2]_n0 AVSS 2.95175f
C666 s[2]_n1 AVSS 7.3096f
C667 s[3]_n0 AVSS 4.22755f
C668 s[3]_n1 AVSS 6.38703f
C669 s[4]_n0 AVSS 0.45717f
C670 s[4]_n1 AVSS 3.30057f
C671 s[4]_n2 AVSS 5.13142f
C672 pn7_t0 AVSS 0.23607f
C673 pn7_t1 AVSS 0.09321f
C674 pn7_n0 AVSS 0.4914f
C675 pn7_n1 AVSS 0.15222f
C676 pn6_t0 AVSS 0.12546f
C677 pn6_n0 AVSS 0.62154f
C678 pn8_t0 AVSS 0.12446f
C679 pn8_n0 AVSS 0.31722f
C680 pn23_t1 AVSS 0.13873f
C681 pn23_t0 AVSS 0.03393f
C682 pn23_n0 AVSS 1.23431f
C683 pn23_n1 AVSS 1.5878f
C684 pn28_t0 AVSS 3.20988f
C685 pn4_t1 AVSS 0.40634f
C686 pn4_t0 AVSS 4.18277f
C687 pn4_n0 AVSS 2.08769f
C688 pn3_t1 AVSS 2.74039f
C689 pn3_t0 AVSS 3.1174f
C690 pn3_n0 AVSS 1.03382f
C691 pn3_t2 AVSS 0.36352f
C692 pn3_n1 AVSS 0.97037f
C693 pn27_t1 AVSS 0.03823f
C694 pn27_t2 AVSS 0.37615f
C695 pn27_n0 AVSS 0.09991f
C696 pn27_t0 AVSS 1.75712f
C697 pn27_n1 AVSS 1.28899f
C698 pn5_t1 AVSS 0.40446f
C699 pn5_t2 AVSS 3.17243f
C700 pn5_t0 AVSS 0.45508f
C701 pn5_n0 AVSS 5.22747f
C702 pn5_n1 AVSS 0.15829f
C703 pn25_t2 AVSS 0.39505f
C704 pn25_t0 AVSS 0.03161f
C705 pn25_n0 AVSS 0.16189f
C706 pn25_t1 AVSS 0.91956f
C707 pn25_n1 AVSS 0.26118f
C708 pn26_t2 AVSS 0.42509f
C709 pn26_t1 AVSS 0.04531f
C710 pn26_n0 AVSS 0.15778f
C711 pn26_t0 AVSS 1.76748f
C712 pn26_n1 AVSS 0.24578f
C713 pn24_t1 AVSS 0.06219f
C714 pn24_t0 AVSS 0.0781f
C715 pn24_n0 AVSS 0.55668f
C716 pn17_n0 AVSS 0.0896f
C717 pn17_n1 AVSS 0.0357f
C718 pn17_n2 AVSS 0.03595f
C719 pn17_n3 AVSS 0.03572f
C720 pn17_n4 AVSS 0.02606f
C721 pn17_n5 AVSS 0.01954f
C722 pn17_n6 AVSS 0.02596f
C723 pn17_n7 AVSS 0.03623f
C724 pn17_n8 AVSS 0.03622f
C725 pn17_n9 AVSS 0.03595f
C726 pn17_n10 AVSS 1.80307f
C727 pn17_t1 AVSS 0.03245f
C728 pn17_t11 AVSS 0.39743f
C729 pn17_n11 AVSS 0.50215f
C730 pn17_t2 AVSS 0.0438f
C731 pn17_t10 AVSS 0.367f
C732 pn17_n12 AVSS 0.48898f
C733 pn17_n13 AVSS 1.34419f
C734 pn17_t3 AVSS 0.04098f
C735 pn17_t9 AVSS 0.37988f
C736 pn17_n14 AVSS 0.48898f
C737 pn17_n15 AVSS 1.5397f
C738 pn17_t4 AVSS 0.04321f
C739 pn17_t7 AVSS 0.41783f
C740 pn17_n16 AVSS 0.50407f
C741 pn17_n17 AVSS 1.75235f
C742 pn17_t0 AVSS 0.02949f
C743 pn17_t8 AVSS 0.38236f
C744 pn17_n18 AVSS 0.52421f
C745 pn17_n19 AVSS 1.3961f
C746 pn17_t5 AVSS 1.36987f
C747 pn17_t6 AVSS 0.39011f
C748 pn17_n20 AVSS 0.34399f
C749 pn17_n21 AVSS 0.99102f
C750 pn17_n22 AVSS 1.45289f
C751 pn21_t1 AVSS 0.05884f
C752 pn21_t0 AVSS 0.09406f
C753 pn21_n0 AVSS 0.51533f
C754 pn22_t1 AVSS 0.05178f
C755 pn22_t0 AVSS 0.15533f
C756 pn22_n0 AVSS 0.4851f
C757 pn18_t1 AVSS 0.06331f
C758 pn18_t0 AVSS 0.15669f
C759 pn18_n0 AVSS 0.59284f
C760 pn19_t0 AVSS 0.05753f
C761 pn19_t1 AVSS 0.13702f
C762 pn19_n0 AVSS 0.53867f
C763 pn20_t0 AVSS 0.04866f
C764 pn20_t1 AVSS 0.10688f
C765 pn20_n0 AVSS 0.4556f
C766 pn35_t7 AVSS 1.71801f
C767 pn35_t13 AVSS 1.71801f
C768 pn35_t11 AVSS 1.718f
C769 pn35_t5 AVSS 1.718f
C770 pn35_t3 AVSS 1.71799f
C771 pn35_t1 AVSS 1.71799f
C772 pn35_t9 AVSS 1.767f
C773 pn35_n0 AVSS 0.18578f
C774 pn35_n1 AVSS 0.13315f
C775 pn35_n2 AVSS 0.13313f
C776 pn35_n3 AVSS 0.13314f
C777 pn35_n4 AVSS 0.13313f
C778 pn35_n5 AVSS 0.17308f
C779 pn35_t15 AVSS 3.54152f
C780 pn35_n6 AVSS 2.3427f
C781 pn35_n7 AVSS 0.27321f
C782 pn35_n8 AVSS 0.1669f
C783 pn35_n9 AVSS 0.1669f
C784 pn35_n10 AVSS 0.1669f
C785 pn35_n11 AVSS 0.1669f
C786 pn35_n12 AVSS 0.16511f
C787 pn35_n13 AVSS 0.89415f
C788 pn35_n14 AVSS 0.89406f
C789 pn35_n15 AVSS 0.16498f
C790 pn35_n16 AVSS 0.1669f
C791 pn35_n17 AVSS 0.1669f
C792 pn35_n18 AVSS 0.1669f
C793 pn35_n19 AVSS 0.1669f
C794 pn35_n20 AVSS 0.1494f
C795 pn35_n21 AVSS 0.07484f
C796 pn35_n22 AVSS 0.09408f
C797 pn35_n23 AVSS 0.14149f
C798 pn29_t11 AVSS 0.8711f
C799 pn29_t9 AVSS 4.23143f
C800 pn29_t8 AVSS 0.86823f
C801 pn29_t10 AVSS 0.86822f
C802 pn29_n0 AVSS 0.44615f
C803 pn29_n1 AVSS 0.4819f
C804 pn29_t2 AVSS 2.08586f
C805 pn29_t1 AVSS 2.08587f
C806 pn29_t0 AVSS 2.08586f
C807 pn29_t3 AVSS 2.08587f
C808 pn29_t4 AVSS 2.08585f
C809 pn29_t7 AVSS 2.08584f
C810 pn29_t5 AVSS 2.19008f
C811 pn29_n2 AVSS 0.32925f
C812 pn29_n3 AVSS 0.23598f
C813 pn29_n4 AVSS 0.23595f
C814 pn29_n5 AVSS 0.23597f
C815 pn29_n6 AVSS 0.23595f
C816 pn29_n7 AVSS 0.22112f
C817 pn29_t6 AVSS 2.09454f
C818 pn29_n8 AVSS 0.87439f
C819 pn29_n9 AVSS 3.0861f
C820 pn29_t12 AVSS 5.23965f
C821 pn29_n10 AVSS 0.93656f
C822 pn16_n0 AVSS 0.04842f
C823 pn16_n1 AVSS 0.11673f
C824 pn16_n2 AVSS 1.88358f
C825 pn16_t2 AVSS 0.83055f
C826 pn16_t1 AVSS 0.61183f
C827 pn16_n3 AVSS 0.69271f
C828 pn16_n4 AVSS 2.39188f
C829 pn16_n5 AVSS 1.10748f
C830 pn16_n6 AVSS 0.3016f
C831 pn16_n7 AVSS 0.02598f
C832 pn16_n8 AVSS 0.04903f
C833 pn33_t1 AVSS 0.1291f
C834 pn33_n0 AVSS 0.80127f
C835 pn33_n1 AVSS 6.26948f
C836 pn10_t1 AVSS 5.38872f
C837 pn10_n0 AVSS 1.46662f
C838 pn10_t0 AVSS 3.15424f
C839 pn10_n1 AVSS 2.41717f
C840 pn10_n2 AVSS 0.10105f
C841 VIN_t0 AVSS 0.45281f
C842 pn34_t1 AVSS 0.65334f
C843 pn34_t0 AVSS 2.04975f
C844 pn34_t2 AVSS 1.0952f
C845 pn34_n0 AVSS 2.00171f
C846 pn34_n1 AVSS 2.61783f
C847 VOUT_t2 AVSS 1.13762f
C848 VOUT_t1 AVSS 0.1633f
C849 VOUT_n0 AVSS 0.62959f
C850 VOUT_t0 AVSS 0.54428f
C851 VOUT_n1 AVSS 1.53377f
C852 VOUT_t3 AVSS 0.85547f
C853 VOUT_n2 AVSS 4.44015f
C854 pn32_t0 AVSS 1.50914f
C855 pn32_t1 AVSS 0.36791f
C856 pn32_n0 AVSS 1.29264f
C857 pn32_t2 AVSS 0.72727f
C858 pn32_n1 AVSS 0.71769f
C859 pn32_t4 AVSS 2.73022f
C860 pn32_n2 AVSS 1.60199f
C861 pn32_t3 AVSS 1.01976f
C862 pn32_n3 AVSS 0.98568f
C863 pn32_n4 AVSS 2.15674f
C864 pn14_t1 AVSS 0.57139f
C865 pn14_n0 AVSS 5.22615f
C866 pn14_t0 AVSS 1.26009f
C867 pn14_n1 AVSS 0.32342f
C868 pn2_t1 AVSS 1.88444f
C869 pn2_t0 AVSS 0.45923f
C870 pn2_n0 AVSS 0.39724f
C871 pn2_n1 AVSS 3.14406f
C872 pn11_t2 AVSS 6.20316f
C873 pn11_n0 AVSS 0.56196f
C874 pn11_t0 AVSS 0.17033f
C875 pn11_t1 AVSS 4.55127f
C876 pn11_n1 AVSS 0.76491f
C877 pn11_n2 AVSS 0.61049f
C878 pn11_n3 AVSS 0.10959f
C879 pn30_t0 AVSS 1.2112f
C880 pn30_t2 AVSS 0.59659f
C881 pn30_n0 AVSS 0.75992f
C882 pn30_n1 AVSS 0.31706f
C883 VCM_n0 AVSS 0.11243f
C884 VCM_n1 AVSS 0.04648f
C885 VCM_n2 AVSS 0.16456f
C886 VCM_n3 AVSS 0.04717f
C887 VCM_n4 AVSS 0.04619f
C888 VCM_n5 AVSS 2.13592f
C889 pn31_t0 AVSS 0.59431f
C890 pn31_t1 AVSS 0.92493f
C891 pn31_t2 AVSS 1.0969f
C892 pn31_n0 AVSS 1.61416f
C893 pn31_n1 AVSS 4.81253f
C894 pn15_t0 AVSS 2.08483f
C895 pn15_t2 AVSS 1.56124f
C896 pn15_n0 AVSS 1.22801f
C897 pn15_n1 AVSS 0.69608f
C898 IBIAS_n0 AVSS 0.08451f
C899 IBIAS_t1 AVSS 0.08795f
C900 IBIAS_n2 AVSS 0.01986f
C901 IBIAS_n3 AVSS 0.01318f
C902 IBIAS_n4 AVSS 0.12424f
C903 pn13_t0 AVSS 0.11779f
C904 pn13_t1 AVSS 0.52381f
C905 pn13_n0 AVSS 0.11377f
C906 pn1_t0 AVSS 1.3088f
XCM_1 pn12 VOUT cap_cmomi w=10.200u l=8.650u mmin=1 mmax=4 feed=double subblock=0 m=1
XCM_2 pn12 VOUT cap_cmomi w=10.200u l=8.650u mmin=1 mmax=4 feed=double subblock=0 m=1
XCM_3 pn12 VOUT cap_cmomi w=10.200u l=8.650u mmin=1 mmax=4 feed=double subblock=0 m=1
XCM_4 pn12 VOUT cap_cmomi w=10.200u l=8.650u mmin=1 mmax=4 feed=double subblock=0 m=1
XCM_5 pn31 VOUT cap_cmomi w=26.160u l=25.560u mmin=1 mmax=4 feed=double subblock=0 m=1
.ends gain_stage
