** post-layout RC netlist of central_bias: Magic extresist -> ngspice by scripts/pex_netlist.py --magic (source: /foss/designs/sg13cmos5l_spma_ip__instramp/runs/pex/central_bias/magic/raw.spice)
.subckt central_bias IB_IN IB_IA IB_BUF IB_G1 IB_G2 AVDD AVSS
X0 IB_G2_t4 pn1_t9 AVDD_t19 AVDD_t2 sg13_lv_pmos ad=0.68p pd=4.68u as=0.68p ps=4.68u w=2u l=2u
X1 pn1_t14 pn1_t9 AVDD_t29 AVDD_t15 sg13_lv_pmos ad=0.68p pd=4.68u as=0.68p ps=4.68u w=2u l=2u
X2 IB_G2_t1 pn1_t7 AVDD_t6 AVDD_t2 sg13_lv_pmos ad=0.68p pd=4.68u as=0.68p ps=4.68u w=2u l=2u
X3 pn1_t2 IB_IN_t2 AVSS_t89 AVSS_t88 sg13_lv_nmos ad=0.34p pd=2.68u as=0.34p ps=2.68u w=1u l=2u
X4 IB_IN_t5 IB_IN_t2 AVSS_t121 AVSS_t120 sg13_lv_nmos ad=0.34p pd=2.68u as=0.34p ps=2.68u w=1u l=2u
X5 pn1_t15 pn1_t7 AVDD_t14 AVDD_t11 sg13_lv_pmos ad=0.68p pd=4.68u as=0.68p ps=4.68u w=2u l=2u
X6 pn1_t5 IB_IN_t0 AVSS_t13 AVSS_t12 sg13_lv_nmos ad=0.34p pd=2.68u as=0.34p ps=2.68u w=1u l=2u
X7 IB_BUF_t6 IB_IN_t0 AVSS_t41 AVSS_t40 sg13_lv_nmos ad=0.34p pd=2.68u as=0.34p ps=2.68u w=1u l=2u
X8 IB_BUF_t2 IB_IN_t2 AVSS_t87 AVSS_t86 sg13_lv_nmos ad=0.34p pd=2.68u as=0.34p ps=2.68u w=1u l=2u
X9 IB_IA_t25 IB_IN_t0 AVSS_t29 AVSS_t28 sg13_lv_nmos ad=0.34p pd=2.68u as=0.34p ps=2.68u w=1u l=2u
X10 IB_IA_t19 IB_IN_t0 AVSS_t59 AVSS_t58 sg13_lv_nmos ad=0.34p pd=2.68u as=0.34p ps=2.68u w=1u l=2u
X11 pn1_t12 pn1_t9 AVDD_t3 AVDD_t2 sg13_lv_pmos ad=0.68p pd=4.68u as=0.68p ps=4.68u w=2u l=2u
X12 IB_IN_t7 IB_IN_t2 AVSS_t85 AVSS_t84 sg13_lv_nmos ad=0.34p pd=2.68u as=0.34p ps=2.68u w=1u l=2u
X13 IB_G1_t5 pn1_t9 AVDD_t26 AVDD_t11 sg13_lv_pmos ad=0.68p pd=4.68u as=0.68p ps=4.68u w=2u l=2u
X14 IB_IA_t4 IB_IN_t2 AVSS_t93 AVSS_t92 sg13_lv_nmos ad=0.34p pd=2.68u as=0.34p ps=2.68u w=1u l=2u
X15 IB_IN_t9 IB_IN_t0 AVSS_t11 AVSS_t10 sg13_lv_nmos ad=0.34p pd=2.68u as=0.34p ps=2.68u w=1u l=2u
X16 IB_IN_t11 IB_IN_t0 AVSS_t45 AVSS_t44 sg13_lv_nmos ad=0.34p pd=2.68u as=0.34p ps=2.68u w=1u l=2u
X17 IB_G1_t2 pn1_t7 AVDD_t10 AVDD_t0 sg13_lv_pmos ad=0.68p pd=4.68u as=0.68p ps=4.68u w=2u l=2u
X18 IB_IN_t8 IB_IN_t0 AVSS_t5 AVSS_t4 sg13_lv_nmos ad=0.34p pd=2.68u as=0.34p ps=2.68u w=1u l=2u
X19 IB_IA_t23 IB_IN_t0 AVSS_t27 AVSS_t26 sg13_lv_nmos ad=0.34p pd=2.68u as=0.34p ps=2.68u w=1u l=2u
X20 IB_IN_t1 IB_IN_t0 AVSS_t43 AVSS_t42 sg13_lv_nmos ad=0.34p pd=2.68u as=0.34p ps=2.68u w=1u l=2u
X21 IB_IA_t30 IB_IN_t0 AVSS_t57 AVSS_t56 sg13_lv_nmos ad=0.34p pd=2.68u as=0.34p ps=2.68u w=1u l=2u
X22 IB_IN_t6 IB_IN_t2 AVSS_t91 AVSS_t90 sg13_lv_nmos ad=0.34p pd=2.68u as=0.34p ps=2.68u w=1u l=2u
X23 IB_G2_t5 pn1_t9 AVDD_t20 AVDD_t0 sg13_lv_pmos ad=0.68p pd=4.68u as=0.68p ps=4.68u w=2u l=2u
X24 IB_IA_t0 IB_IN_t2 AVSS_t99 AVSS_t98 sg13_lv_nmos ad=0.34p pd=2.68u as=0.34p ps=2.68u w=1u l=2u
X25 IB_G2_t2 pn1_t7 AVDD_t9 AVDD_t0 sg13_lv_pmos ad=0.68p pd=4.68u as=0.68p ps=4.68u w=2u l=2u
X26 IB_IA_t1 IB_IN_t2 AVSS_t97 AVSS_t96 sg13_lv_nmos ad=0.34p pd=2.68u as=0.34p ps=2.68u w=1u l=2u
X27 pn1_t13 pn1_t7 AVDD_t16 AVDD_t15 sg13_lv_pmos ad=0.68p pd=4.68u as=0.68p ps=4.68u w=2u l=2u
X28 IB_BUF_t10 IB_IN_t0 AVSS_t3 AVSS_t2 sg13_lv_nmos ad=0.34p pd=2.68u as=0.34p ps=2.68u w=1u l=2u
X29 IB_BUF_t9 IB_IN_t0 AVSS_t33 AVSS_t32 sg13_lv_nmos ad=0.34p pd=2.68u as=0.34p ps=2.68u w=1u l=2u
X30 IB_IA_t28 IB_IN_t0 AVSS_t19 AVSS_t18 sg13_lv_nmos ad=0.34p pd=2.68u as=0.34p ps=2.68u w=1u l=2u
X31 IB_IA_t26 IB_IN_t0 AVSS_t37 AVSS_t36 sg13_lv_nmos ad=0.34p pd=2.68u as=0.34p ps=2.68u w=1u l=2u
X32 IB_IA_t10 IB_IN_t2 AVSS_t1 AVSS_t0 sg13_lv_nmos ad=0.34p pd=2.68u as=0.34p ps=2.68u w=1u l=2u
X33 IB_IA_t6 IB_IN_t2 AVSS_t95 AVSS_t94 sg13_lv_nmos ad=0.34p pd=2.68u as=0.34p ps=2.68u w=1u l=2u
X34 pn1_t17 pn1_t9 AVDD_t22 AVDD_t2 sg13_lv_pmos ad=0.68p pd=4.68u as=0.68p ps=4.68u w=2u l=2u
X35 IB_IA_t8 IB_IN_t2 AVSS_t103 AVSS_t102 sg13_lv_nmos ad=0.34p pd=2.68u as=0.34p ps=2.68u w=1u l=2u
X36 pn1_t8 pn1_t7 AVDD_t5 AVDD_t2 sg13_lv_pmos ad=0.68p pd=4.68u as=0.68p ps=4.68u w=2u l=2u
X37 IB_G1_t0 pn1_t7 AVDD_t18 AVDD_t15 sg13_lv_pmos ad=0.68p pd=4.68u as=0.68p ps=4.68u w=2u l=2u
X38 IB_G1_t6 pn1_t9 AVDD_t30 AVDD_t11 sg13_lv_pmos ad=0.68p pd=4.68u as=0.68p ps=4.68u w=2u l=2u
X39 IB_IA_t24 IB_IN_t0 AVSS_t35 AVSS_t34 sg13_lv_nmos ad=0.34p pd=2.68u as=0.34p ps=2.68u w=1u l=2u
X40 IB_IA_t16 IB_IN_t2 AVSS_t69 AVSS_t68 sg13_lv_nmos ad=0.34p pd=2.68u as=0.34p ps=2.68u w=1u l=2u
X41 IB_IA_t3 IB_IN_t2 AVSS_t101 AVSS_t100 sg13_lv_nmos ad=0.34p pd=2.68u as=0.34p ps=2.68u w=1u l=2u
X42 IB_G1_t3 pn1_t7 AVDD_t13 AVDD_t11 sg13_lv_pmos ad=0.68p pd=4.68u as=0.68p ps=4.68u w=2u l=2u
X43 IB_IN_t10 IB_IN_t0 AVSS_t17 AVSS_t16 sg13_lv_nmos ad=0.34p pd=2.68u as=0.34p ps=2.68u w=1u l=2u
X44 IB_IA_t18 IB_IN_t0 AVSS_t63 AVSS_t62 sg13_lv_nmos ad=0.34p pd=2.68u as=0.34p ps=2.68u w=1u l=2u
X45 IB_IA_t11 IB_IN_t2 AVSS_t67 AVSS_t66 sg13_lv_nmos ad=0.34p pd=2.68u as=0.34p ps=2.68u w=1u l=2u
X46 IB_IN_t3 IB_IN_t2 AVSS_t113 AVSS_t112 sg13_lv_nmos ad=0.34p pd=2.68u as=0.34p ps=2.68u w=1u l=2u
X47 IB_G1_t8 pn1_t9 AVDD_t21 AVDD_t2 sg13_lv_pmos ad=0.68p pd=4.68u as=0.68p ps=4.68u w=2u l=2u
X48 IB_IA_t15 IB_IN_t2 AVSS_t65 AVSS_t64 sg13_lv_nmos ad=0.34p pd=2.68u as=0.34p ps=2.68u w=1u l=2u
X49 IB_G1_t1 pn1_t7 AVDD_t4 AVDD_t2 sg13_lv_pmos ad=0.68p pd=4.68u as=0.68p ps=4.68u w=2u l=2u
X50 IB_G2_t8 pn1_t9 AVDD_t28 AVDD_t11 sg13_lv_pmos ad=0.68p pd=4.68u as=0.68p ps=4.68u w=2u l=2u
X51 IB_IA_t9 IB_IN_t2 AVSS_t107 AVSS_t106 sg13_lv_nmos ad=0.34p pd=2.68u as=0.34p ps=2.68u w=1u l=2u
X52 IB_G2_t0 pn1_t7 AVDD_t12 AVDD_t11 sg13_lv_pmos ad=0.68p pd=4.68u as=0.68p ps=4.68u w=2u l=2u
X53 IB_IA_t22 IB_IN_t0 AVSS_t31 AVSS_t30 sg13_lv_nmos ad=0.34p pd=2.68u as=0.34p ps=2.68u w=1u l=2u
X54 IB_BUF_t5 IB_IN_t0 AVSS_t39 AVSS_t38 sg13_lv_nmos ad=0.34p pd=2.68u as=0.34p ps=2.68u w=1u l=2u
X55 IB_IA_t31 IB_IN_t0 AVSS_t61 AVSS_t60 sg13_lv_nmos ad=0.34p pd=2.68u as=0.34p ps=2.68u w=1u l=2u
X56 IB_IA_t7 IB_IN_t2 AVSS_t105 AVSS_t104 sg13_lv_nmos ad=0.34p pd=2.68u as=0.34p ps=2.68u w=1u l=2u
X57 IB_BUF_t8 IB_IN_t0 AVSS_t9 AVSS_t8 sg13_lv_nmos ad=0.34p pd=2.68u as=0.34p ps=2.68u w=1u l=2u
X58 IB_IA_t20 IB_IN_t0 AVSS_t55 AVSS_t54 sg13_lv_nmos ad=0.34p pd=2.68u as=0.34p ps=2.68u w=1u l=2u
X59 IB_IA_t2 IB_IN_t2 AVSS_t73 AVSS_t72 sg13_lv_nmos ad=0.34p pd=2.68u as=0.34p ps=2.68u w=1u l=2u
X60 IB_IA_t21 IB_IN_t0 AVSS_t25 AVSS_t24 sg13_lv_nmos ad=0.34p pd=2.68u as=0.34p ps=2.68u w=1u l=2u
X61 IB_IA_t5 IB_IN_t2 AVSS_t71 AVSS_t70 sg13_lv_nmos ad=0.34p pd=2.68u as=0.34p ps=2.68u w=1u l=2u
X62 pn1_t3 IB_IN_t2 AVSS_t117 AVSS_t116 sg13_lv_nmos ad=0.34p pd=2.68u as=0.34p ps=2.68u w=1u l=2u
X63 pn1_t18 pn1_t9 AVDD_t27 AVDD_t11 sg13_lv_pmos ad=0.68p pd=4.68u as=0.68p ps=4.68u w=2u l=2u
X64 pn1_t11 pn1_t7 AVDD_t1 AVDD_t0 sg13_lv_pmos ad=0.68p pd=4.68u as=0.68p ps=4.68u w=2u l=2u
X65 pn1_t10 pn1_t9 AVDD_t23 AVDD_t0 sg13_lv_pmos ad=0.68p pd=4.68u as=0.68p ps=4.68u w=2u l=2u
X66 pn1 IB_IN_t0 AVSS_t7 AVSS_t6 sg13_lv_nmos ad=0.34p pd=2.68u as=0.34p ps=2.68u w=1u l=2u
X67 pn1_t0 IB_IN_t0 AVSS_t47 AVSS_t46 sg13_lv_nmos ad=0.34p pd=2.68u as=0.34p ps=2.68u w=1u l=2u
X68 IB_IA_t12 IB_IN_t2 AVSS_t79 AVSS_t78 sg13_lv_nmos ad=0.34p pd=2.68u as=0.34p ps=2.68u w=1u l=2u
X69 IB_BUF_t4 IB_IN_t2 AVSS_t109 AVSS_t108 sg13_lv_nmos ad=0.34p pd=2.68u as=0.34p ps=2.68u w=1u l=2u
X70 pn1_t16 pn1_t7 AVDD_t8 AVDD_t0 sg13_lv_pmos ad=0.68p pd=4.68u as=0.68p ps=4.68u w=2u l=2u
X71 IB_IA_t27 IB_IN_t0 AVSS_t23 AVSS_t22 sg13_lv_nmos ad=0.34p pd=2.68u as=0.34p ps=2.68u w=1u l=2u
X72 IB_IA_t17 IB_IN_t0 AVSS_t53 AVSS_t52 sg13_lv_nmos ad=0.34p pd=2.68u as=0.34p ps=2.68u w=1u l=2u
X73 IB_IA_t13 IB_IN_t2 AVSS_t77 AVSS_t76 sg13_lv_nmos ad=0.34p pd=2.68u as=0.34p ps=2.68u w=1u l=2u
X74 pn1_t6 IB_IN_t2 AVSS_t123 AVSS_t122 sg13_lv_nmos ad=0.34p pd=2.68u as=0.34p ps=2.68u w=1u l=2u
X75 IB_IA_t14 IB_IN_t2 AVSS_t75 AVSS_t74 sg13_lv_nmos ad=0.34p pd=2.68u as=0.34p ps=2.68u w=1u l=2u
X76 IB_BUF_t1 IB_IN_t2 AVSS_t111 AVSS_t110 sg13_lv_nmos ad=0.34p pd=2.68u as=0.34p ps=2.68u w=1u l=2u
X77 IB_G1_t7 pn1_t9 AVDD_t25 AVDD_t0 sg13_lv_pmos ad=0.68p pd=4.68u as=0.68p ps=4.68u w=2u l=2u
X78 IB_G1_t4 pn1_t7 AVDD_t7 AVDD_t2 sg13_lv_pmos ad=0.68p pd=4.68u as=0.68p ps=4.68u w=2u l=2u
X79 IB_G2_t7 pn1_t9 AVDD_t31 AVDD_t15 sg13_lv_pmos ad=0.68p pd=4.68u as=0.68p ps=4.68u w=2u l=2u
X80 IB_IA_t29 IB_IN_t0 AVSS_t21 AVSS_t20 sg13_lv_nmos ad=0.34p pd=2.68u as=0.34p ps=2.68u w=1u l=2u
X81 IB_IA_t32 IB_IN_t0 AVSS_t51 AVSS_t50 sg13_lv_nmos ad=0.34p pd=2.68u as=0.34p ps=2.68u w=1u l=2u
X82 IB_BUF_t3 IB_IN_t2 AVSS_t83 AVSS_t82 sg13_lv_nmos ad=0.34p pd=2.68u as=0.34p ps=2.68u w=1u l=2u
X83 IB_IN_t4 IB_IN_t2 AVSS_t115 AVSS_t114 sg13_lv_nmos ad=0.34p pd=2.68u as=0.34p ps=2.68u w=1u l=2u
X84 IB_G2_t3 pn1_t7 AVDD_t17 AVDD_t11 sg13_lv_pmos ad=0.68p pd=4.68u as=0.68p ps=4.68u w=2u l=2u
X85 IB_BUF_t7 IB_IN_t0 AVSS_t15 AVSS_t14 sg13_lv_nmos ad=0.34p pd=2.68u as=0.34p ps=2.68u w=1u l=2u
X86 pn1_t1 IB_IN_t0 AVSS_t49 AVSS_t48 sg13_lv_nmos ad=0.34p pd=2.68u as=0.34p ps=2.68u w=1u l=2u
X87 IB_G2_t6 pn1_t9 AVDD_t24 AVDD_t0 sg13_lv_pmos ad=0.68p pd=4.68u as=0.68p ps=4.68u w=2u l=2u
X88 pn1_t4 IB_IN_t2 AVSS_t81 AVSS_t80 sg13_lv_nmos ad=0.34p pd=2.68u as=0.34p ps=2.68u w=1u l=2u
X89 IB_BUF_t0 IB_IN_t2 AVSS_t119 AVSS_t118 sg13_lv_nmos ad=0.34p pd=2.68u as=0.34p ps=2.68u w=1u l=2u
R0 IB_IA_n0 IB_IA_t10 16.698
R1 IB_IA_n8 IB_IA_t28 16.2305
R2 IB_IA_n31 IB_IA_t18 16.2301
R3 IB_IA_n30 IB_IA_t31 16.2301
R4 IB_IA_n29 IB_IA_t19 16.2301
R5 IB_IA_n28 IB_IA_t30 16.2301
R6 IB_IA_n27 IB_IA_t20 16.2301
R7 IB_IA_n26 IB_IA_t17 16.2301
R8 IB_IA_n25 IB_IA_t32 16.2301
R9 IB_IA_n24 IB_IA_t26 16.2301
R10 IB_IA_n23 IB_IA_t24 16.2301
R11 IB_IA_n14 IB_IA_t22 16.2301
R12 IB_IA_n13 IB_IA_t25 16.2301
R13 IB_IA_n12 IB_IA_t23 16.2301
R14 IB_IA_n11 IB_IA_t21 16.2301
R15 IB_IA_n10 IB_IA_t27 16.2301
R16 IB_IA_n9 IB_IA_t29 16.2301
R17 IB_IA_n22 IB_IA_t9 15.818
R18 IB_IA_n21 IB_IA_t7 15.818
R19 IB_IA_n20 IB_IA_t8 15.818
R20 IB_IA_n19 IB_IA_t3 15.818
R21 IB_IA_n18 IB_IA_t0 15.818
R22 IB_IA_n17 IB_IA_t1 15.818
R23 IB_IA_n16 IB_IA_t6 15.818
R24 IB_IA_n15 IB_IA_t4 15.818
R25 IB_IA_n7 IB_IA_t12 15.818
R26 IB_IA_n6 IB_IA_t13 15.818
R27 IB_IA_n5 IB_IA_t14 15.818
R28 IB_IA_n4 IB_IA_t2 15.818
R29 IB_IA_n3 IB_IA_t5 15.818
R30 IB_IA_n2 IB_IA_t16 15.818
R31 IB_IA_n1 IB_IA_t11 15.818
R32 IB_IA_n0 IB_IA_t15 15.818
R33 IB_IA IB_IA_n31 9.73383
R34 IB_IA_n1 IB_IA_n0 0.8805
R35 IB_IA_n2 IB_IA_n1 0.8805
R36 IB_IA_n3 IB_IA_n2 0.8805
R37 IB_IA_n4 IB_IA_n3 0.8805
R38 IB_IA_n5 IB_IA_n4 0.8805
R39 IB_IA_n6 IB_IA_n5 0.8805
R40 IB_IA_n7 IB_IA_n6 0.8805
R41 IB_IA_n9 IB_IA_n8 0.8805
R42 IB_IA_n10 IB_IA_n9 0.8805
R43 IB_IA_n11 IB_IA_n10 0.8805
R44 IB_IA_n12 IB_IA_n11 0.8805
R45 IB_IA_n13 IB_IA_n12 0.8805
R46 IB_IA_n14 IB_IA_n13 0.8805
R47 IB_IA_n16 IB_IA_n15 0.8805
R48 IB_IA_n17 IB_IA_n16 0.8805
R49 IB_IA_n18 IB_IA_n17 0.8805
R50 IB_IA_n19 IB_IA_n18 0.8805
R51 IB_IA_n20 IB_IA_n19 0.8805
R52 IB_IA_n21 IB_IA_n20 0.8805
R53 IB_IA_n22 IB_IA_n21 0.8805
R54 IB_IA_n24 IB_IA_n23 0.8805
R55 IB_IA_n25 IB_IA_n24 0.8805
R56 IB_IA_n26 IB_IA_n25 0.8805
R57 IB_IA_n27 IB_IA_n26 0.8805
R58 IB_IA_n28 IB_IA_n27 0.8805
R59 IB_IA_n29 IB_IA_n28 0.8805
R60 IB_IA_n30 IB_IA_n29 0.8805
R61 IB_IA_n31 IB_IA_n30 0.8805
R62 IB_IA_n8 IB_IA_n7 0.4405
R63 IB_IA_n15 IB_IA_n14 0.4405
R64 IB_IA_n23 IB_IA_n22 0.4405
R65 IB_BUF_n0 IB_BUF_t10 18.458
R66 IB_BUF_n9 IB_BUF_t0 16.2305
R67 IB_BUF_n8 IB_BUF_t1 16.2305
R68 IB_BUF_n7 IB_BUF_t4 16.2305
R69 IB_BUF_n3 IB_BUF_t2 16.2305
R70 IB_BUF_n2 IB_BUF_t3 16.2305
R71 IB_BUF_n6 IB_BUF_t6 15.8176
R72 IB_BUF_n5 IB_BUF_t5 15.8176
R73 IB_BUF_n4 IB_BUF_t9 15.8176
R74 IB_BUF_n1 IB_BUF_t7 15.8176
R75 IB_BUF_n0 IB_BUF_t8 15.8176
R76 IB_BUF IB_BUF_n9 10.1738
R77 IB_BUF_n2 IB_BUF_n1 3.0805
R78 IB_BUF_n4 IB_BUF_n3 3.0805
R79 IB_BUF_n7 IB_BUF_n6 3.0805
R80 IB_BUF_n1 IB_BUF_n0 2.6405
R81 IB_BUF_n5 IB_BUF_n4 2.6405
R82 IB_BUF_n8 IB_BUF_n7 2.6405
R83 IB_BUF_n9 IB_BUF_n8 2.6405
R84 IB_BUF_n3 IB_BUF_n2 1.7605
R85 IB_BUF_n6 IB_BUF_n5 1.7605
R86 IB_IN_n0 IB_IN_t5 18.0455
R87 IB_IN_n9 IB_IN_t0 17.704
R88 IB_IN_n2 IB_IN_t11 16.6426
R89 IB_IN_n3 IB_IN_t1 16.6426
R90 IB_IN_n6 IB_IN_t10 16.6426
R91 IB_IN_n7 IB_IN_t9 16.6426
R92 IB_IN_n8 IB_IN_t8 16.6426
R93 IB_IN_n9 IB_IN_t2 16.4665
R94 IB_IN_n0 IB_IN_t4 15.4055
R95 IB_IN_n1 IB_IN_t3 15.4055
R96 IB_IN_n4 IB_IN_t6 15.4055
R97 IB_IN_n5 IB_IN_t7 15.4055
R98 IB_IN IB_IN_n10 9.65463
R99 IB_IN_n10 IB_IN_n9 9.0005
R100 IB_IN_n6 IB_IN_n5 3.0805
R101 IB_IN_n2 IB_IN_n1 3.0805
R102 IB_IN_n8 IB_IN_n7 2.6405
R103 IB_IN_n7 IB_IN_n6 2.6405
R104 IB_IN_n5 IB_IN_n4 2.6405
R105 IB_IN_n3 IB_IN_n2 2.6405
R106 IB_IN_n1 IB_IN_n0 2.6405
R107 IB_IN_n10 IB_IN_n8 2.27383
R108 IB_IN_n4 IB_IN_n3 2.2005
R109 IB_G2 IB_G2_n7 26.448
R110 IB_G2_n0 IB_G2_t7 14.929
R111 IB_G2_n1 IB_G2_t8 13.609
R112 IB_G2_n3 IB_G2_t5 13.609
R113 IB_G2_n5 IB_G2_t6 13.609
R114 IB_G2_n7 IB_G2_t4 13.609
R115 IB_G2_n6 IB_G2_t1 12.7843
R116 IB_G2_n0 IB_G2_t3 12.7831
R117 IB_G2_n2 IB_G2_t0 12.7831
R118 IB_G2_n4 IB_G2_t2 12.7831
R119 IB_G2_n7 IB_G2_n6 1.3205
R120 IB_G2_n6 IB_G2_n5 1.3205
R121 IB_G2_n5 IB_G2_n4 1.3205
R122 IB_G2_n4 IB_G2_n3 1.3205
R123 IB_G2_n3 IB_G2_n2 1.3205
R124 IB_G2_n2 IB_G2_n1 1.3205
R125 IB_G2_n1 IB_G2_n0 1.3205
R126 IB_G1_n0 IB_G1_t1 14.5168
R127 IB_G1_n6 IB_G1_t6 13.1965
R128 IB_G1_n4 IB_G1_t5 13.1965
R129 IB_G1_n2 IB_G1_t7 13.1965
R130 IB_G1_n0 IB_G1_t8 13.1965
R131 IB_G1_n7 IB_G1_t0 13.1956
R132 IB_G1_n5 IB_G1_t3 13.1956
R133 IB_G1_n3 IB_G1_t2 13.1956
R134 IB_G1_n1 IB_G1_t4 13.1956
R135 IB_G1 IB_G1_n7 10.6138
R136 IB_G1_n1 IB_G1_n0 1.3205
R137 IB_G1_n2 IB_G1_n1 1.3205
R138 IB_G1_n3 IB_G1_n2 1.3205
R139 IB_G1_n4 IB_G1_n3 1.3205
R140 IB_G1_n5 IB_G1_n4 1.3205
R141 IB_G1_n6 IB_G1_n5 1.3205
R142 IB_G1_n7 IB_G1_n6 1.3205
R143 pn1_n17 pn1_n16 23.0594
R144 pn1_n0 pn1_t6 19.283
R145 pn1_n15 pn1_t7 17.979
R146 pn1_n15 pn1_t9 17.154
R147 pn1_n0 pn1_t3 16.643
R148 pn1_n3 pn1_t2 16.643
R149 pn1_n4 pn1_t4 16.643
R150 pn1_n1 pn1_t1 15.4051
R151 pn1_n2 pn1_t0 15.4051
R152 pn1_n5 pn1_t5 15.4051
R153 pn1 pn1_n17 15.4041
R154 pn1_n6 pn1_t13 14.9281
R155 pn1_n7 pn1_t15 13.6081
R156 pn1_n9 pn1_t11 13.6081
R157 pn1_n11 pn1_t16 13.6081
R158 pn1_n13 pn1_t8 13.6081
R159 pn1_n6 pn1_t14 12.784
R160 pn1_n8 pn1_t18 12.784
R161 pn1_n10 pn1_t10 12.784
R162 pn1_n12 pn1_t17 12.784
R163 pn1_n14 pn1_t12 12.784
R164 pn1_n16 pn1_n15 9.0005
R165 pn1_n3 pn1_n2 3.9605
R166 pn1_n4 pn1_n3 3.5205
R167 pn1_n2 pn1_n1 3.5205
R168 pn1_n5 pn1_n4 3.0805
R169 pn1_n1 pn1_n0 3.0805
R170 pn1_n17 pn1_n5 2.6405
R171 pn1_n14 pn1_n13 1.3205
R172 pn1_n13 pn1_n12 1.3205
R173 pn1_n12 pn1_n11 1.3205
R174 pn1_n11 pn1_n10 1.3205
R175 pn1_n10 pn1_n9 1.3205
R176 pn1_n9 pn1_n8 1.3205
R177 pn1_n8 pn1_n7 1.3205
R178 pn1_n7 pn1_n6 1.3205
R179 pn1_n16 pn1_n14 0.953833
R180 AVDD AVDD_n37 27.0445
R181 AVDD_n19 AVDD_n18 8.48209
R182 AVDD_n9 AVDD_n8 8.48209
R183 AVDD_n3 AVDD_n2 8.48209
R184 AVDD_n35 AVDD_t15 8.48159
R185 AVDD_n30 AVDD_t11 8.48159
R186 AVDD_n25 AVDD_t0 8.48159
R187 AVDD_n20 AVDD_t2 8.48159
R188 AVDD_t2 AVDD_n1 8.48159
R189 AVDD_n37 AVDD_n36 7.83279
R190 AVDD_n36 AVDD_t16 4.34779
R191 AVDD_n33 AVDD_t17 4.34779
R192 AVDD_n32 AVDD_t14 4.34779
R193 AVDD_n31 AVDD_t13 4.34779
R194 AVDD_n28 AVDD_t1 4.34779
R195 AVDD_n27 AVDD_t10 4.34779
R196 AVDD_n26 AVDD_t9 4.34779
R197 AVDD_n23 AVDD_t7 4.34779
R198 AVDD_n22 AVDD_t6 4.34779
R199 AVDD_n21 AVDD_t5 4.34779
R200 AVDD_n0 AVDD_t31 4.34688
R201 AVDD_n7 AVDD_t27 4.34688
R202 AVDD_n6 AVDD_t28 4.34688
R203 AVDD_n5 AVDD_t30 4.34688
R204 AVDD_n13 AVDD_t25 4.34688
R205 AVDD_n12 AVDD_t23 4.34688
R206 AVDD_n11 AVDD_t20 4.34688
R207 AVDD_n14 AVDD_t19 4.34688
R208 AVDD_n15 AVDD_t21 4.34688
R209 AVDD_n16 AVDD_t22 4.34688
R210 AVDD_n20 AVDD_t4 4.33433
R211 AVDD_n1 AVDD_t3 4.33368
R212 AVDD_n34 AVDD_t18 4.26185
R213 AVDD_n29 AVDD_t12 4.26185
R214 AVDD_n24 AVDD_t8 4.26185
R215 AVDD_n4 AVDD_t29 4.26094
R216 AVDD_n10 AVDD_t26 4.26094
R217 AVDD_n17 AVDD_t24 4.26094
R218 AVDD_n37 AVDD_n0 1.41793
R219 AVDD_n32 AVDD_n31 0.943357
R220 AVDD_n33 AVDD_n32 0.943357
R221 AVDD_n27 AVDD_n26 0.943357
R222 AVDD_n28 AVDD_n27 0.943357
R223 AVDD_n22 AVDD_n21 0.943357
R224 AVDD_n23 AVDD_n22 0.943357
R225 AVDD_n7 AVDD_n6 0.943357
R226 AVDD_n6 AVDD_n5 0.943357
R227 AVDD_n13 AVDD_n12 0.943357
R228 AVDD_n12 AVDD_n11 0.943357
R229 AVDD_n15 AVDD_n14 0.943357
R230 AVDD_n16 AVDD_n15 0.943357
R231 AVDD_n34 AVDD_n33 0.936741
R232 AVDD_n29 AVDD_n28 0.936741
R233 AVDD_n24 AVDD_n23 0.936741
R234 AVDD_n5 AVDD_n4 0.936741
R235 AVDD_n11 AVDD_n10 0.936741
R236 AVDD_n17 AVDD_n16 0.936741
R237 AVDD_n21 AVDD_n20 0.826195
R238 AVDD_n3 AVDD_n0 0.826195
R239 AVDD_n36 AVDD_n35 0.825943
R240 AVDD_n31 AVDD_n30 0.825943
R241 AVDD_n26 AVDD_n25 0.825943
R242 AVDD_n9 AVDD_n7 0.825943
R243 AVDD_n18 AVDD_n13 0.825943
R244 AVDD_n14 AVDD_n1 0.825943
R245 AVDD_n35 AVDD_n34 0.073233
R246 AVDD_n30 AVDD_n29 0.073233
R247 AVDD_n25 AVDD_n24 0.073233
R248 AVDD_n18 AVDD_n17 0.073233
R249 AVDD_n10 AVDD_n9 0.073233
R250 AVDD_n4 AVDD_n3 0.0729806
R251 AVDD_n19 AVDD_t0 0.001
R252 AVDD_n8 AVDD_t11 0.001
R253 AVDD_n2 AVDD_t15 0.001
R254 AVDD_t2 AVDD_n19 0.001
R255 AVDD_n8 AVDD_t0 0.001
R256 AVDD_n2 AVDD_t11 0.001
R257 AVSS_t42 AVSS_t96 307.272
R258 AVSS_t96 AVSS_t46 307.272
R259 AVSS_t46 AVSS_t98 307.272
R260 AVSS_t98 AVSS_t38 307.272
R261 AVSS_t38 AVSS_t100 307.272
R262 AVSS_t100 AVSS_t44 307.272
R263 AVSS_t40 AVSS_t104 307.272
R264 AVSS_t104 AVSS_t48 307.272
R265 AVSS_t48 AVSS_t106 307.272
R266 AVSS_t106 AVSS_t34 307.272
R267 AVSS_t34 AVSS_t112 307.272
R268 AVSS_t112 AVSS_t36 307.272
R269 AVSS_t50 AVSS_t116 307.272
R270 AVSS_t116 AVSS_t52 307.272
R271 AVSS_t52 AVSS_t114 307.272
R272 AVSS_t114 AVSS_t54 307.272
R273 AVSS_t54 AVSS_t110 307.272
R274 AVSS_t110 AVSS_t56 307.272
R275 AVSS_t58 AVSS_t120 307.272
R276 AVSS_t120 AVSS_t60 307.272
R277 AVSS_t60 AVSS_t118 307.272
R278 AVSS_t118 AVSS_t62 307.272
R279 AVSS_t2 AVSS_t64 170.166
R280 AVSS_t64 AVSS_t4 170.166
R281 AVSS_t4 AVSS_t66 170.166
R282 AVSS_t66 AVSS_t6 170.166
R283 AVSS_t6 AVSS_t68 170.166
R284 AVSS_t68 AVSS_t8 170.166
R285 AVSS_t10 AVSS_t72 170.166
R286 AVSS_t72 AVSS_t12 170.166
R287 AVSS_t12 AVSS_t74 170.166
R288 AVSS_t74 AVSS_t14 170.166
R289 AVSS_t14 AVSS_t76 170.166
R290 AVSS_t76 AVSS_t16 170.166
R291 AVSS_t18 AVSS_t80 170.166
R292 AVSS_t80 AVSS_t20 170.166
R293 AVSS_t20 AVSS_t82 170.166
R294 AVSS_t82 AVSS_t22 170.166
R295 AVSS_t22 AVSS_t84 170.166
R296 AVSS_t84 AVSS_t24 170.166
R297 AVSS_t26 AVSS_t88 170.166
R298 AVSS_t88 AVSS_t28 170.166
R299 AVSS_t28 AVSS_t90 170.166
R300 AVSS_t90 AVSS_t30 170.166
R301 AVSS_t30 AVSS_t92 170.166
R302 AVSS_t92 AVSS_t32 170.166
R303 AVSS_t102 AVSS_n2 152.275
R304 AVSS_n26 AVSS_t40 152.275
R305 AVSS_t108 AVSS_n1 152.275
R306 AVSS_n20 AVSS_t50 152.275
R307 AVSS_n19 AVSS_t122 152.275
R308 AVSS_n8 AVSS_t58 152.275
R309 AVSS_n32 AVSS_t42 152.257
R310 AVSS_t56 AVSS_n19 99.0157
R311 AVSS_n8 AVSS_t122 99.0157
R312 AVSS_n20 AVSS_t108 99.0157
R313 AVSS_n26 AVSS_t102 99.0157
R314 AVSS_t44 AVSS_n2 99.0157
R315 AVSS_t36 AVSS_n1 99.0157
R316 AVSS_n58 AVSS_t0 91.976
R317 AVSS_n57 AVSS_t2 86.4453
R318 AVSS_t70 AVSS_n6 86.4453
R319 AVSS_n50 AVSS_t10 86.4453
R320 AVSS_t78 AVSS_n5 86.4453
R321 AVSS_n44 AVSS_t18 86.4453
R322 AVSS_t86 AVSS_n4 86.4453
R323 AVSS_n38 AVSS_t26 86.4453
R324 AVSS_t94 AVSS_n3 86.4453
R325 AVSS_n32 AVSS_t94 57.8656
R326 AVSS_n38 AVSS_t86 56.9507
R327 AVSS_n44 AVSS_t78 56.9507
R328 AVSS_n50 AVSS_t70 56.9507
R329 AVSS_t0 AVSS_n57 56.9507
R330 AVSS_t8 AVSS_n6 56.9507
R331 AVSS_t16 AVSS_n5 56.9507
R332 AVSS_t24 AVSS_n4 56.9507
R333 AVSS_t32 AVSS_n3 56.9507
R334 AVSS AVSS_n91 27.0445
R335 AVSS_n15 AVSS_n14 8.33339
R336 AVSS_n14 AVSS_t63 6.96929
R337 AVSS_n13 AVSS_t61 6.96929
R338 AVSS_n10 AVSS_t57 6.96929
R339 AVSS_n9 AVSS_t55 6.96929
R340 AVSS_n7 AVSS_t53 6.96929
R341 AVSS_n23 AVSS_t37 6.96929
R342 AVSS_n24 AVSS_t35 6.96929
R343 AVSS_n25 AVSS_t49 6.96929
R344 AVSS_n29 AVSS_t45 6.96929
R345 AVSS_n30 AVSS_t39 6.96929
R346 AVSS_n31 AVSS_t47 6.96929
R347 AVSS_n35 AVSS_t33 6.96929
R348 AVSS_n36 AVSS_t31 6.96929
R349 AVSS_n37 AVSS_t29 6.96929
R350 AVSS_n41 AVSS_t25 6.96929
R351 AVSS_n42 AVSS_t23 6.96929
R352 AVSS_n43 AVSS_t21 6.96929
R353 AVSS_n47 AVSS_t17 6.96929
R354 AVSS_n48 AVSS_t15 6.96929
R355 AVSS_n49 AVSS_t13 6.96929
R356 AVSS_n53 AVSS_t9 6.96929
R357 AVSS_n54 AVSS_t7 6.96929
R358 AVSS_n55 AVSS_t5 6.96929
R359 AVSS_n0 AVSS_t111 6.96886
R360 AVSS_n16 AVSS_t121 6.96886
R361 AVSS_n15 AVSS_t119 6.96886
R362 AVSS_n89 AVSS_t117 6.96886
R363 AVSS_n90 AVSS_t115 6.96886
R364 AVSS_n84 AVSS_t105 6.96886
R365 AVSS_n85 AVSS_t107 6.96886
R366 AVSS_n86 AVSS_t113 6.96886
R367 AVSS_n79 AVSS_t97 6.96886
R368 AVSS_n80 AVSS_t99 6.96886
R369 AVSS_n81 AVSS_t101 6.96886
R370 AVSS_n74 AVSS_t89 6.96886
R371 AVSS_n75 AVSS_t91 6.96886
R372 AVSS_n76 AVSS_t93 6.96886
R373 AVSS_n69 AVSS_t81 6.96886
R374 AVSS_n70 AVSS_t83 6.96886
R375 AVSS_n71 AVSS_t85 6.96886
R376 AVSS_n64 AVSS_t73 6.96886
R377 AVSS_n65 AVSS_t75 6.96886
R378 AVSS_n66 AVSS_t77 6.96886
R379 AVSS_n59 AVSS_t65 6.96886
R380 AVSS_n60 AVSS_t67 6.96886
R381 AVSS_n61 AVSS_t69 6.96886
R382 AVSS_n56 AVSS_t3 6.95583
R383 AVSS_n58 AVSS_t1 6.95565
R384 AVSS_n11 AVSS_t59 6.88335
R385 AVSS_n22 AVSS_t51 6.88335
R386 AVSS_n28 AVSS_t41 6.88335
R387 AVSS_n34 AVSS_t43 6.88335
R388 AVSS_n40 AVSS_t27 6.88335
R389 AVSS_n46 AVSS_t19 6.88335
R390 AVSS_n52 AVSS_t11 6.88335
R391 AVSS_n17 AVSS_t123 6.88292
R392 AVSS_n87 AVSS_t109 6.88292
R393 AVSS_n82 AVSS_t103 6.88292
R394 AVSS_n77 AVSS_t95 6.88292
R395 AVSS_n72 AVSS_t87 6.88292
R396 AVSS_n67 AVSS_t79 6.88292
R397 AVSS_n62 AVSS_t71 6.88292
R398 AVSS_n39 AVSS_n38 5.53249
R399 AVSS_n45 AVSS_n44 5.53249
R400 AVSS_n51 AVSS_n50 5.53249
R401 AVSS_n57 AVSS_n56 5.53249
R402 AVSS_n63 AVSS_n6 5.53249
R403 AVSS_n68 AVSS_n5 5.53249
R404 AVSS_n73 AVSS_n4 5.53249
R405 AVSS_n78 AVSS_n3 5.53249
R406 AVSS_n33 AVSS_n32 5.07506
R407 AVSS_n19 AVSS_n18 5.06617
R408 AVSS_n12 AVSS_n8 5.06617
R409 AVSS_n21 AVSS_n20 5.06617
R410 AVSS_n27 AVSS_n26 5.06617
R411 AVSS_n83 AVSS_n2 5.06617
R412 AVSS_n88 AVSS_n1 5.06617
R413 AVSS_n16 AVSS_n15 0.943357
R414 AVSS_n14 AVSS_n13 0.943357
R415 AVSS_n9 AVSS_n7 0.943357
R416 AVSS_n10 AVSS_n9 0.943357
R417 AVSS_n25 AVSS_n24 0.943357
R418 AVSS_n24 AVSS_n23 0.943357
R419 AVSS_n31 AVSS_n30 0.943357
R420 AVSS_n30 AVSS_n29 0.943357
R421 AVSS_n37 AVSS_n36 0.943357
R422 AVSS_n36 AVSS_n35 0.943357
R423 AVSS_n43 AVSS_n42 0.943357
R424 AVSS_n42 AVSS_n41 0.943357
R425 AVSS_n49 AVSS_n48 0.943357
R426 AVSS_n48 AVSS_n47 0.943357
R427 AVSS_n55 AVSS_n54 0.943357
R428 AVSS_n54 AVSS_n53 0.943357
R429 AVSS_n90 AVSS_n89 0.943357
R430 AVSS_n85 AVSS_n84 0.943357
R431 AVSS_n86 AVSS_n85 0.943357
R432 AVSS_n80 AVSS_n79 0.943357
R433 AVSS_n81 AVSS_n80 0.943357
R434 AVSS_n75 AVSS_n74 0.943357
R435 AVSS_n76 AVSS_n75 0.943357
R436 AVSS_n70 AVSS_n69 0.943357
R437 AVSS_n71 AVSS_n70 0.943357
R438 AVSS_n65 AVSS_n64 0.943357
R439 AVSS_n66 AVSS_n65 0.943357
R440 AVSS_n60 AVSS_n59 0.943357
R441 AVSS_n61 AVSS_n60 0.943357
R442 AVSS_n17 AVSS_n0 0.936741
R443 AVSS_n11 AVSS_n10 0.936741
R444 AVSS_n23 AVSS_n22 0.936741
R445 AVSS_n29 AVSS_n28 0.936741
R446 AVSS_n35 AVSS_n34 0.936741
R447 AVSS_n41 AVSS_n40 0.936741
R448 AVSS_n47 AVSS_n46 0.936741
R449 AVSS_n53 AVSS_n52 0.936741
R450 AVSS_n87 AVSS_n86 0.936741
R451 AVSS_n82 AVSS_n81 0.936741
R452 AVSS_n77 AVSS_n76 0.936741
R453 AVSS_n72 AVSS_n71 0.936741
R454 AVSS_n67 AVSS_n66 0.936741
R455 AVSS_n62 AVSS_n61 0.936741
R456 AVSS_n56 AVSS_n55 0.826195
R457 AVSS_n89 AVSS_n88 0.826195
R458 AVSS_n18 AVSS_n16 0.825943
R459 AVSS_n13 AVSS_n12 0.825943
R460 AVSS_n21 AVSS_n7 0.825943
R461 AVSS_n27 AVSS_n25 0.825943
R462 AVSS_n33 AVSS_n31 0.825943
R463 AVSS_n39 AVSS_n37 0.825943
R464 AVSS_n45 AVSS_n43 0.825943
R465 AVSS_n51 AVSS_n49 0.825943
R466 AVSS_n84 AVSS_n83 0.825943
R467 AVSS_n79 AVSS_n78 0.825943
R468 AVSS_n74 AVSS_n73 0.825943
R469 AVSS_n69 AVSS_n68 0.825943
R470 AVSS_n64 AVSS_n63 0.825943
R471 AVSS_n59 AVSS_n58 0.825943
R472 AVSS_n91 AVSS_n0 0.751643
R473 AVSS_n91 AVSS_n90 0.1545
R474 AVSS_n18 AVSS_n17 0.073233
R475 AVSS_n12 AVSS_n11 0.073233
R476 AVSS_n22 AVSS_n21 0.073233
R477 AVSS_n28 AVSS_n27 0.073233
R478 AVSS_n34 AVSS_n33 0.073233
R479 AVSS_n40 AVSS_n39 0.073233
R480 AVSS_n46 AVSS_n45 0.073233
R481 AVSS_n52 AVSS_n51 0.073233
R482 AVSS_n63 AVSS_n62 0.073233
R483 AVSS_n68 AVSS_n67 0.073233
R484 AVSS_n73 AVSS_n72 0.073233
R485 AVSS_n78 AVSS_n77 0.073233
R486 AVSS_n83 AVSS_n82 0.073233
R487 AVSS_n88 AVSS_n87 0.0729806
C0 IB_IN AVDD 0.03037f
C1 AVDD pn1 30.7092f
C2 IB_G1 pn1 4.9224f
C3 IB_G2 pn1 3.65526f
C4 IB_IN IB_BUF 1.05843f
C5 IB_BUF pn1 8.43567f
C6 IB_IA IB_BUF 8.78755f
C7 IB_G1 AVDD 2.81647f
C8 IB_G2 AVDD 3.18239f
C9 IB_IN pn1 1.98583f
C10 IB_IN IB_IA 10.5209f
C11 IB_IA pn1 0.75041f
C12 IB_G2 IB_G1 3.89989f
C13 IB_IA AVSS 7.20938f
C14 IB_BUF AVSS 3.16465f
C15 IB_IN AVSS 53.15659f
C16 IB_G2 AVSS 4.69057f
C17 IB_G1 AVSS 0.24438f
C18 pn1 AVSS 10.15041f
C19 AVDD AVSS 0.21043f
C20 AVSS_t89 AVSS 2.93658f
C21 AVSS_t13 AVSS 2.9529f
C22 AVDD_t31 AVSS 0.04904f
C23 AVDD_n0 AVSS 0.10034f
C24 AVDD_t16 AVSS 0.04904f
C25 AVDD_t15 AVSS 5.66735f
C26 AVDD_t18 AVSS 0.04854f
C27 AVDD_t17 AVSS 0.04904f
C28 AVDD_t14 AVSS 0.04904f
C29 AVDD_t13 AVSS 0.04904f
C30 AVDD_t11 AVSS 8.47083f
C31 AVDD_t12 AVSS 0.04854f
C32 AVDD_t1 AVSS 0.04904f
C33 AVDD_t10 AVSS 0.04904f
C34 AVDD_t9 AVSS 0.04904f
C35 AVDD_t0 AVSS 8.47083f
C36 AVDD_t8 AVSS 0.04854f
C37 AVDD_t7 AVSS 0.04904f
C38 AVDD_t6 AVSS 8.51404f
C39 AVDD_t5 AVSS 0.04904f
C40 AVDD_t4 AVSS 0.04911f
C41 AVDD_t3 AVSS 0.04911f
C42 AVDD_n1 AVSS 0.08749f
C43 AVDD_t25 AVSS 0.04904f
C44 AVDD_t23 AVSS 0.04904f
C45 AVDD_t20 AVSS 0.04904f
C46 AVDD_t26 AVSS 0.04854f
C47 AVDD_t27 AVSS 0.04904f
C48 AVDD_t28 AVSS 0.04904f
C49 AVDD_t30 AVSS 0.04904f
C50 AVDD_t29 AVSS 0.04854f
C51 AVDD_n2 AVSS 0.01812f
C52 AVDD_n3 AVSS 0.05424f
C53 AVDD_n4 AVSS 0.06369f
C54 AVDD_n5 AVSS 0.08793f
C55 AVDD_n6 AVSS 0.08813f
C56 AVDD_n7 AVSS 0.08455f
C57 AVDD_n8 AVSS 0.01812f
C58 AVDD_n9 AVSS 0.05424f
C59 AVDD_n10 AVSS 0.0637f
C60 AVDD_n11 AVSS 0.08793f
C61 AVDD_n12 AVSS 0.08813f
C62 AVDD_n13 AVSS 0.08455f
C63 AVDD_t24 AVSS 0.04854f
C64 AVDD_t22 AVSS 0.04904f
C65 AVDD_t21 AVSS 0.04904f
C66 AVDD_t19 AVSS 8.44584f
C67 AVDD_n14 AVSS 0.08455f
C68 AVDD_n15 AVSS 0.08813f
C69 AVDD_n16 AVSS 0.08793f
C70 AVDD_n17 AVSS 0.0637f
C71 AVDD_n18 AVSS 0.05424f
C72 AVDD_n19 AVSS 0.01812f
C73 AVDD_t2 AVSS 9.65824f
C74 AVDD_n20 AVSS 0.08748f
C75 AVDD_n21 AVSS 0.08456f
C76 AVDD_n22 AVSS 0.08813f
C77 AVDD_n23 AVSS 0.08792f
C78 AVDD_n24 AVSS 0.0637f
C79 AVDD_n25 AVSS 0.05424f
C80 AVDD_n26 AVSS 0.08455f
C81 AVDD_n27 AVSS 0.08813f
C82 AVDD_n28 AVSS 0.08792f
C83 AVDD_n29 AVSS 0.0637f
C84 AVDD_n30 AVSS 0.05424f
C85 AVDD_n31 AVSS 0.08455f
C86 AVDD_n32 AVSS 0.08813f
C87 AVDD_n33 AVSS 0.08792f
C88 AVDD_n34 AVSS 0.0637f
C89 AVDD_n35 AVSS 0.05424f
C90 AVDD_n36 AVSS 0.15873f
C91 AVDD_n37 AVSS 0.13109f
C92 pn1_t6 AVSS 0.27f
C93 pn1_t3 AVSS 0.1442f
C94 pn1_n0 AVSS 1.42349f
C95 pn1_t1 AVSS 0.11031f
C96 pn1_n1 AVSS 0.69642f
C97 pn1_t0 AVSS 0.11031f
C98 pn1_n2 AVSS 0.78564f
C99 pn1_t2 AVSS 3.08078f
C100 pn1_n3 AVSS 0.80885f
C101 pn1_t4 AVSS 0.1442f
C102 pn1_n4 AVSS 0.71963f
C103 pn1_t5 AVSS 3.06321f
C104 pn1_n5 AVSS 0.6072f
C105 pn1_t13 AVSS 0.26736f
C106 pn1_t14 AVSS 0.21173f
C107 pn1_n6 AVSS 0.58855f
C108 pn1_t15 AVSS 0.23865f
C109 pn1_n7 AVSS 0.30379f
C110 pn1_t18 AVSS 0.21173f
C111 pn1_n8 AVSS 0.29265f
C112 pn1_t11 AVSS 0.23865f
C113 pn1_n9 AVSS 0.30379f
C114 pn1_t10 AVSS 0.21173f
C115 pn1_n10 AVSS 0.29265f
C116 pn1_t16 AVSS 0.23865f
C117 pn1_n11 AVSS 0.30379f
C118 pn1_t17 AVSS 0.21173f
C119 pn1_n12 AVSS 0.29265f
C120 pn1_t8 AVSS 0.23865f
C121 pn1_n13 AVSS 0.30379f
C122 pn1_t12 AVSS 0.21173f
C123 pn1_n14 AVSS 0.25547f
C124 pn1_n15 AVSS 0.24734f
C125 pn1_n16 AVSS 2.43881f
C126 pn1_n17 AVSS 2.64623f
C127 IB_G1_t1 AVSS 0.59138f
C128 IB_G1_t8 AVSS 0.53499f
C129 IB_G1_n0 AVSS 1.27168f
C130 IB_G1_t4 AVSS 0.53499f
C131 IB_G1_n1 AVSS 0.70781f
C132 IB_G1_t7 AVSS 0.53499f
C133 IB_G1_n2 AVSS 0.70782f
C134 IB_G1_t2 AVSS 0.53499f
C135 IB_G1_n3 AVSS 0.70781f
C136 IB_G1_t5 AVSS 0.53499f
C137 IB_G1_n4 AVSS 0.70782f
C138 IB_G1_t3 AVSS 0.53499f
C139 IB_G1_n5 AVSS 0.70781f
C140 IB_G1_t6 AVSS 0.53499f
C141 IB_G1_n6 AVSS 0.70782f
C142 IB_G1_t0 AVSS 0.53499f
C143 IB_G1_n7 AVSS 1.12005f
C144 IB_G2_t7 AVSS 0.34683f
C145 IB_G2_t3 AVSS 0.27935f
C146 IB_G2_n0 AVSS 0.71571f
C147 IB_G2_t8 AVSS 0.31486f
C148 IB_G2_n1 AVSS 0.40082f
C149 IB_G2_t0 AVSS 0.27935f
C150 IB_G2_n2 AVSS 0.3861f
C151 IB_G2_t5 AVSS 0.31486f
C152 IB_G2_n3 AVSS 0.40082f
C153 IB_G2_t2 AVSS 0.27935f
C154 IB_G2_n4 AVSS 0.3861f
C155 IB_G2_t6 AVSS 0.31486f
C156 IB_G2_n5 AVSS 0.40082f
C157 IB_G2_t1 AVSS 8.74434f
C158 IB_G2_n6 AVSS 0.38611f
C159 IB_G2_t4 AVSS 8.71166f
C160 IB_G2_n7 AVSS 3.35495f
C161 IB_IN_t5 AVSS 0.04603f
C162 IB_IN_t4 AVSS 0.02606f
C163 IB_IN_n0 AVSS 0.24943f
C164 IB_IN_t3 AVSS 0.02606f
C165 IB_IN_n1 AVSS 0.14348f
C166 IB_IN_t11 AVSS 0.03407f
C167 IB_IN_n2 AVSS 0.14896f
C168 IB_IN_t1 AVSS 0.03407f
C169 IB_IN_n3 AVSS 0.12788f
C170 IB_IN_t6 AVSS 0.02606f
C171 IB_IN_n4 AVSS 0.1224f
C172 IB_IN_t7 AVSS 0.02606f
C173 IB_IN_n5 AVSS 0.14348f
C174 IB_IN_t10 AVSS 0.03407f
C175 IB_IN_n6 AVSS 0.14896f
C176 IB_IN_t9 AVSS 0.03407f
C177 IB_IN_n7 AVSS 0.13842f
C178 IB_IN_t8 AVSS 0.03407f
C179 IB_IN_n8 AVSS 0.12964f
C180 IB_IN_n9 AVSS 0.04928f
C181 IB_IN_n10 AVSS 0.08609f
C182 IB_BUF_t10 AVSS 0.43878f
C183 IB_BUF_t8 AVSS 0.29858f
C184 IB_BUF_n0 AVSS 2.2391f
C185 IB_BUF_t7 AVSS 0.29858f
C186 IB_BUF_n1 AVSS 1.5085f
C187 IB_BUF_t3 AVSS 0.32629f
C188 IB_BUF_n2 AVSS 1.3086f
C189 IB_BUF_t2 AVSS 0.32629f
C190 IB_BUF_n3 AVSS 1.3086f
C191 IB_BUF_t9 AVSS 0.29858f
C192 IB_BUF_n4 AVSS 1.5085f
C193 IB_BUF_t5 AVSS 0.29858f
C194 IB_BUF_n5 AVSS 1.18016f
C195 IB_BUF_t6 AVSS 0.29858f
C196 IB_BUF_n6 AVSS 1.28961f
C197 IB_BUF_t4 AVSS 0.32629f
C198 IB_BUF_n7 AVSS 1.52749f
C199 IB_BUF_t1 AVSS 0.32629f
C200 IB_BUF_n8 AVSS 1.41805f
C201 IB_BUF_t0 AVSS 0.32629f
C202 IB_BUF_n9 AVSS 1.32467f
C203 IB_IA_t10 AVSS 0.23234f
C204 IB_IA_t15 AVSS 0.21979f
C205 IB_IA_n0 AVSS 0.61099f
C206 IB_IA_t11 AVSS 0.21979f
C207 IB_IA_n1 AVSS 0.38536f
C208 IB_IA_t16 AVSS 0.21979f
C209 IB_IA_n2 AVSS 0.38536f
C210 IB_IA_t5 AVSS 0.21979f
C211 IB_IA_n3 AVSS 0.38536f
C212 IB_IA_t2 AVSS 0.21979f
C213 IB_IA_n4 AVSS 0.38536f
C214 IB_IA_t14 AVSS 0.21979f
C215 IB_IA_n5 AVSS 0.38536f
C216 IB_IA_t13 AVSS 0.21979f
C217 IB_IA_n6 AVSS 0.38536f
C218 IB_IA_t12 AVSS 0.21979f
C219 IB_IA_n7 AVSS 0.30479f
C220 IB_IA_t28 AVSS 0.24019f
C221 IB_IA_n8 AVSS 0.31877f
C222 IB_IA_t29 AVSS 0.24019f
C223 IB_IA_n9 AVSS 0.39933f
C224 IB_IA_t27 AVSS 0.24019f
C225 IB_IA_n10 AVSS 0.39933f
C226 IB_IA_t21 AVSS 0.24019f
C227 IB_IA_n11 AVSS 0.39933f
C228 IB_IA_t23 AVSS 0.24019f
C229 IB_IA_n12 AVSS 0.39933f
C230 IB_IA_t25 AVSS 0.24019f
C231 IB_IA_n13 AVSS 0.39933f
C232 IB_IA_t22 AVSS 0.24019f
C233 IB_IA_n14 AVSS 0.31876f
C234 IB_IA_t4 AVSS 0.21979f
C235 IB_IA_n15 AVSS 0.30479f
C236 IB_IA_t6 AVSS 0.21979f
C237 IB_IA_n16 AVSS 0.38536f
C238 IB_IA_t1 AVSS 0.21979f
C239 IB_IA_n17 AVSS 0.38536f
C240 IB_IA_t0 AVSS 0.21979f
C241 IB_IA_n18 AVSS 0.38536f
C242 IB_IA_t3 AVSS 0.21979f
C243 IB_IA_n19 AVSS 0.38536f
C244 IB_IA_t8 AVSS 0.21979f
C245 IB_IA_n20 AVSS 0.38536f
C246 IB_IA_t7 AVSS 0.21979f
C247 IB_IA_n21 AVSS 0.38536f
C248 IB_IA_t9 AVSS 0.21979f
C249 IB_IA_n22 AVSS 0.30479f
C250 IB_IA_t24 AVSS 0.24019f
C251 IB_IA_n23 AVSS 0.31876f
C252 IB_IA_t26 AVSS 0.24019f
C253 IB_IA_n24 AVSS 0.39933f
C254 IB_IA_t32 AVSS 0.24019f
C255 IB_IA_n25 AVSS 0.39933f
C256 IB_IA_t17 AVSS 0.24019f
C257 IB_IA_n26 AVSS 0.39933f
C258 IB_IA_t20 AVSS 0.24019f
C259 IB_IA_n27 AVSS 0.39933f
C260 IB_IA_t30 AVSS 0.24019f
C261 IB_IA_n28 AVSS 0.39933f
C262 IB_IA_t19 AVSS 0.24019f
C263 IB_IA_n29 AVSS 0.39933f
C264 IB_IA_t31 AVSS 0.24019f
C265 IB_IA_n30 AVSS 0.39933f
C266 IB_IA_t18 AVSS 0.24019f
C267 IB_IA_n31 AVSS 0.50683f
.ends central_bias
