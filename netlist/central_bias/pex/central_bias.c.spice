** post-layout netlist of central_bias: kpex -> ngspice by scripts/pex_netlist.py (source: /foss/designs/sg13cmos5l_spma_ip__instramp/runs/pex/central_bias/kpex/central_bias__central_bias/central_bias_k25d_pex_netlist.spice)
.subckt central_bias IB_IN IB_IA IB_BUF IB_G1 IB_G2 AVDD AVSS
XM_1 IB_IA IB_IN AVSS AVSS sg13_lv_nmos L=2U W=1U AS=0.34P AD=0.34P PS=2.68U PD=2.68U rfmode=0
XM_2 IB_IA IB_IN AVSS AVSS sg13_lv_nmos L=2U W=1U AS=0.34P AD=0.34P PS=2.68U PD=2.68U rfmode=0
XM_3 IB_IA IB_IN AVSS AVSS sg13_lv_nmos L=2U W=1U AS=0.34P AD=0.34P PS=2.68U PD=2.68U rfmode=0
XM_4 IB_IA IB_IN AVSS AVSS sg13_lv_nmos L=2U W=1U AS=0.34P AD=0.34P PS=2.68U PD=2.68U rfmode=0
XM_5 IB_IA IB_IN AVSS AVSS sg13_lv_nmos L=2U W=1U AS=0.34P AD=0.34P PS=2.68U PD=2.68U rfmode=0
XM_6 IB_IA IB_IN AVSS AVSS sg13_lv_nmos L=2U W=1U AS=0.34P AD=0.34P PS=2.68U PD=2.68U rfmode=0
XM_7 IB_IA IB_IN AVSS AVSS sg13_lv_nmos L=2U W=1U AS=0.34P AD=0.34P PS=2.68U PD=2.68U rfmode=0
XM_8 IB_IA IB_IN AVSS AVSS sg13_lv_nmos L=2U W=1U AS=0.34P AD=0.34P PS=2.68U PD=2.68U rfmode=0
XM_9 IB_IA IB_IN AVSS AVSS sg13_lv_nmos L=2U W=1U AS=0.34P AD=0.34P PS=2.68U PD=2.68U rfmode=0
XM_10 n6 IB_IN AVSS AVSS sg13_lv_nmos L=2U W=1U AS=0.34P AD=0.34P PS=2.68U PD=2.68U rfmode=0
XM_11 IB_BUF IB_IN AVSS AVSS sg13_lv_nmos L=2U W=1U AS=0.34P AD=0.34P PS=2.68U PD=2.68U rfmode=0
XM_12 IB_IN IB_IN AVSS AVSS sg13_lv_nmos L=2U W=1U AS=0.34P AD=0.34P PS=2.68U PD=2.68U rfmode=0
XM_13 IB_BUF IB_IN AVSS AVSS sg13_lv_nmos L=2U W=1U AS=0.34P AD=0.34P PS=2.68U PD=2.68U rfmode=0
XM_14 n6 IB_IN AVSS AVSS sg13_lv_nmos L=2U W=1U AS=0.34P AD=0.34P PS=2.68U PD=2.68U rfmode=0
XM_15 IB_IN IB_IN AVSS AVSS sg13_lv_nmos L=2U W=1U AS=0.34P AD=0.34P PS=2.68U PD=2.68U rfmode=0
XM_16 IB_IA IB_IN AVSS AVSS sg13_lv_nmos L=2U W=1U AS=0.34P AD=0.34P PS=2.68U PD=2.68U rfmode=0
XM_17 IB_IA IB_IN AVSS AVSS sg13_lv_nmos L=2U W=1U AS=0.34P AD=0.34P PS=2.68U PD=2.68U rfmode=0
XM_18 IB_IA IB_IN AVSS AVSS sg13_lv_nmos L=2U W=1U AS=0.34P AD=0.34P PS=2.68U PD=2.68U rfmode=0
XM_19 IB_IA IB_IN AVSS AVSS sg13_lv_nmos L=2U W=1U AS=0.34P AD=0.34P PS=2.68U PD=2.68U rfmode=0
XM_20 IB_IA IB_IN AVSS AVSS sg13_lv_nmos L=2U W=1U AS=0.34P AD=0.34P PS=2.68U PD=2.68U rfmode=0
XM_21 IB_IA IB_IN AVSS AVSS sg13_lv_nmos L=2U W=1U AS=0.34P AD=0.34P PS=2.68U PD=2.68U rfmode=0
XM_22 IB_IA IB_IN AVSS AVSS sg13_lv_nmos L=2U W=1U AS=0.34P AD=0.34P PS=2.68U PD=2.68U rfmode=0
XM_23 IB_IA IB_IN AVSS AVSS sg13_lv_nmos L=2U W=1U AS=0.34P AD=0.34P PS=2.68U PD=2.68U rfmode=0
XM_24 IB_IN IB_IN AVSS AVSS sg13_lv_nmos L=2U W=1U AS=0.34P AD=0.34P PS=2.68U PD=2.68U rfmode=0
XM_25 IB_BUF IB_IN AVSS AVSS sg13_lv_nmos L=2U W=1U AS=0.34P AD=0.34P PS=2.68U PD=2.68U rfmode=0
XM_26 n6 IB_IN AVSS AVSS sg13_lv_nmos L=2U W=1U AS=0.34P AD=0.34P PS=2.68U PD=2.68U rfmode=0
XM_27 IB_IN IB_IN AVSS AVSS sg13_lv_nmos L=2U W=1U AS=0.34P AD=0.34P PS=2.68U PD=2.68U rfmode=0
XM_28 IB_BUF IB_IN AVSS AVSS sg13_lv_nmos L=2U W=1U AS=0.34P AD=0.34P PS=2.68U PD=2.68U rfmode=0
XM_29 n6 IB_IN AVSS AVSS sg13_lv_nmos L=2U W=1U AS=0.34P AD=0.34P PS=2.68U PD=2.68U rfmode=0
XM_30 IB_IN IB_IN AVSS AVSS sg13_lv_nmos L=2U W=1U AS=0.34P AD=0.34P PS=2.68U PD=2.68U rfmode=0
XM_31 IB_BUF IB_IN AVSS AVSS sg13_lv_nmos L=2U W=1U AS=0.34P AD=0.34P PS=2.68U PD=2.68U rfmode=0
XM_32 IB_BUF IB_IN AVSS AVSS sg13_lv_nmos L=2U W=1U AS=0.34P AD=0.34P PS=2.68U PD=2.68U rfmode=0
XM_33 IB_IN IB_IN AVSS AVSS sg13_lv_nmos L=2U W=1U AS=0.34P AD=0.34P PS=2.68U PD=2.68U rfmode=0
XM_34 n6 IB_IN AVSS AVSS sg13_lv_nmos L=2U W=1U AS=0.34P AD=0.34P PS=2.68U PD=2.68U rfmode=0
XM_35 IB_BUF IB_IN AVSS AVSS sg13_lv_nmos L=2U W=1U AS=0.34P AD=0.34P PS=2.68U PD=2.68U rfmode=0
XM_36 IB_IN IB_IN AVSS AVSS sg13_lv_nmos L=2U W=1U AS=0.34P AD=0.34P PS=2.68U PD=2.68U rfmode=0
XM_37 n6 IB_IN AVSS AVSS sg13_lv_nmos L=2U W=1U AS=0.34P AD=0.34P PS=2.68U PD=2.68U rfmode=0
XM_38 IB_BUF IB_IN AVSS AVSS sg13_lv_nmos L=2U W=1U AS=0.34P AD=0.34P PS=2.68U PD=2.68U rfmode=0
XM_39 IB_IN IB_IN AVSS AVSS sg13_lv_nmos L=2U W=1U AS=0.34P AD=0.34P PS=2.68U PD=2.68U rfmode=0
XM_40 IB_IA IB_IN AVSS AVSS sg13_lv_nmos L=2U W=1U AS=0.34P AD=0.34P PS=2.68U PD=2.68U rfmode=0
XM_41 IB_IA IB_IN AVSS AVSS sg13_lv_nmos L=2U W=1U AS=0.34P AD=0.34P PS=2.68U PD=2.68U rfmode=0
XM_42 IB_IA IB_IN AVSS AVSS sg13_lv_nmos L=2U W=1U AS=0.34P AD=0.34P PS=2.68U PD=2.68U rfmode=0
XM_43 IB_IA IB_IN AVSS AVSS sg13_lv_nmos L=2U W=1U AS=0.34P AD=0.34P PS=2.68U PD=2.68U rfmode=0
XM_44 IB_IA IB_IN AVSS AVSS sg13_lv_nmos L=2U W=1U AS=0.34P AD=0.34P PS=2.68U PD=2.68U rfmode=0
XM_45 IB_IA IB_IN AVSS AVSS sg13_lv_nmos L=2U W=1U AS=0.34P AD=0.34P PS=2.68U PD=2.68U rfmode=0
XM_46 IB_IA IB_IN AVSS AVSS sg13_lv_nmos L=2U W=1U AS=0.34P AD=0.34P PS=2.68U PD=2.68U rfmode=0
XM_47 IB_BUF IB_IN AVSS AVSS sg13_lv_nmos L=2U W=1U AS=0.34P AD=0.34P PS=2.68U PD=2.68U rfmode=0
XM_48 IB_IN IB_IN AVSS AVSS sg13_lv_nmos L=2U W=1U AS=0.34P AD=0.34P PS=2.68U PD=2.68U rfmode=0
XM_49 n6 IB_IN AVSS AVSS sg13_lv_nmos L=2U W=1U AS=0.34P AD=0.34P PS=2.68U PD=2.68U rfmode=0
XM_50 IB_BUF IB_IN AVSS AVSS sg13_lv_nmos L=2U W=1U AS=0.34P AD=0.34P PS=2.68U PD=2.68U rfmode=0
XM_51 IB_IN IB_IN AVSS AVSS sg13_lv_nmos L=2U W=1U AS=0.34P AD=0.34P PS=2.68U PD=2.68U rfmode=0
XM_52 IB_BUF IB_IN AVSS AVSS sg13_lv_nmos L=2U W=1U AS=0.34P AD=0.34P PS=2.68U PD=2.68U rfmode=0
XM_53 n6 IB_IN AVSS AVSS sg13_lv_nmos L=2U W=1U AS=0.34P AD=0.34P PS=2.68U PD=2.68U rfmode=0
XM_54 IB_IA IB_IN AVSS AVSS sg13_lv_nmos L=2U W=1U AS=0.34P AD=0.34P PS=2.68U PD=2.68U rfmode=0
XM_55 IB_IA IB_IN AVSS AVSS sg13_lv_nmos L=2U W=1U AS=0.34P AD=0.34P PS=2.68U PD=2.68U rfmode=0
XM_56 IB_IA IB_IN AVSS AVSS sg13_lv_nmos L=2U W=1U AS=0.34P AD=0.34P PS=2.68U PD=2.68U rfmode=0
XM_57 IB_IA IB_IN AVSS AVSS sg13_lv_nmos L=2U W=1U AS=0.34P AD=0.34P PS=2.68U PD=2.68U rfmode=0
XM_58 IB_IA IB_IN AVSS AVSS sg13_lv_nmos L=2U W=1U AS=0.34P AD=0.34P PS=2.68U PD=2.68U rfmode=0
XM_59 IB_IA IB_IN AVSS AVSS sg13_lv_nmos L=2U W=1U AS=0.34P AD=0.34P PS=2.68U PD=2.68U rfmode=0
XM_60 IB_IA IB_IN AVSS AVSS sg13_lv_nmos L=2U W=1U AS=0.34P AD=0.34P PS=2.68U PD=2.68U rfmode=0
XM_61 IB_IA IB_IN AVSS AVSS sg13_lv_nmos L=2U W=1U AS=0.34P AD=0.34P PS=2.68U PD=2.68U rfmode=0
XM_62 IB_IA IB_IN AVSS AVSS sg13_lv_nmos L=2U W=1U AS=0.34P AD=0.34P PS=2.68U PD=2.68U rfmode=0
XM_63 n6 n6 AVDD AVDD sg13_lv_pmos L=2U W=2U AS=0.68P AD=0.68P PS=4.68U PD=4.68U rfmode=0
XM_64 IB_G2 n6 AVDD AVDD sg13_lv_pmos L=2U W=2U AS=0.68P AD=0.68P PS=4.68U PD=4.68U rfmode=0
XM_65 n6 n6 AVDD AVDD sg13_lv_pmos L=2U W=2U AS=0.68P AD=0.68P PS=4.68U PD=4.68U rfmode=0
XM_66 IB_G1 n6 AVDD AVDD sg13_lv_pmos L=2U W=2U AS=0.68P AD=0.68P PS=4.68U PD=4.68U rfmode=0
XM_67 n6 n6 AVDD AVDD sg13_lv_pmos L=2U W=2U AS=0.68P AD=0.68P PS=4.68U PD=4.68U rfmode=0
XM_68 IB_G1 n6 AVDD AVDD sg13_lv_pmos L=2U W=2U AS=0.68P AD=0.68P PS=4.68U PD=4.68U rfmode=0
XM_69 IB_G2 n6 AVDD AVDD sg13_lv_pmos L=2U W=2U AS=0.68P AD=0.68P PS=4.68U PD=4.68U rfmode=0
XM_70 IB_G2 n6 AVDD AVDD sg13_lv_pmos L=2U W=2U AS=0.68P AD=0.68P PS=4.68U PD=4.68U rfmode=0
XM_71 n6 n6 AVDD AVDD sg13_lv_pmos L=2U W=2U AS=0.68P AD=0.68P PS=4.68U PD=4.68U rfmode=0
XM_72 IB_G1 n6 AVDD AVDD sg13_lv_pmos L=2U W=2U AS=0.68P AD=0.68P PS=4.68U PD=4.68U rfmode=0
XM_73 n6 n6 AVDD AVDD sg13_lv_pmos L=2U W=2U AS=0.68P AD=0.68P PS=4.68U PD=4.68U rfmode=0
XM_74 IB_G2 n6 AVDD AVDD sg13_lv_pmos L=2U W=2U AS=0.68P AD=0.68P PS=4.68U PD=4.68U rfmode=0
XM_75 IB_G2 n6 AVDD AVDD sg13_lv_pmos L=2U W=2U AS=0.68P AD=0.68P PS=4.68U PD=4.68U rfmode=0
XM_76 n6 n6 AVDD AVDD sg13_lv_pmos L=2U W=2U AS=0.68P AD=0.68P PS=4.68U PD=4.68U rfmode=0
XM_77 IB_G2 n6 AVDD AVDD sg13_lv_pmos L=2U W=2U AS=0.68P AD=0.68P PS=4.68U PD=4.68U rfmode=0
XM_78 IB_G1 n6 AVDD AVDD sg13_lv_pmos L=2U W=2U AS=0.68P AD=0.68P PS=4.68U PD=4.68U rfmode=0
XM_79 n6 n6 AVDD AVDD sg13_lv_pmos L=2U W=2U AS=0.68P AD=0.68P PS=4.68U PD=4.68U rfmode=0
XM_80 IB_G1 n6 AVDD AVDD sg13_lv_pmos L=2U W=2U AS=0.68P AD=0.68P PS=4.68U PD=4.68U rfmode=0
XM_81 IB_G1 n6 AVDD AVDD sg13_lv_pmos L=2U W=2U AS=0.68P AD=0.68P PS=4.68U PD=4.68U rfmode=0
XM_82 IB_G2 n6 AVDD AVDD sg13_lv_pmos L=2U W=2U AS=0.68P AD=0.68P PS=4.68U PD=4.68U rfmode=0
XM_83 n6 n6 AVDD AVDD sg13_lv_pmos L=2U W=2U AS=0.68P AD=0.68P PS=4.68U PD=4.68U rfmode=0
XM_84 IB_G1 n6 AVDD AVDD sg13_lv_pmos L=2U W=2U AS=0.68P AD=0.68P PS=4.68U PD=4.68U rfmode=0
XM_85 IB_G2 n6 AVDD AVDD sg13_lv_pmos L=2U W=2U AS=0.68P AD=0.68P PS=4.68U PD=4.68U rfmode=0
XM_86 IB_G1 n6 AVDD AVDD sg13_lv_pmos L=2U W=2U AS=0.68P AD=0.68P PS=4.68U PD=4.68U rfmode=0
XM_87 IB_G2 n6 AVDD AVDD sg13_lv_pmos L=2U W=2U AS=0.68P AD=0.68P PS=4.68U PD=4.68U rfmode=0
XM_88 IB_G1 n6 AVDD AVDD sg13_lv_pmos L=2U W=2U AS=0.68P AD=0.68P PS=4.68U PD=4.68U rfmode=0
XM_89 n6 n6 AVDD AVDD sg13_lv_pmos L=2U W=2U AS=0.68P AD=0.68P PS=4.68U PD=4.68U rfmode=0
XM_90 n6 n6 AVDD AVDD sg13_lv_pmos L=2U W=2U AS=0.68P AD=0.68P PS=4.68U PD=4.68U rfmode=0
Cext_1 n6 AVDD 6.33789f
Cext_2 n6 AVSS 606.42a
Cext_3 n6 IB_BUF 7.56016f
Cext_4 n6 IB_G1 4.62397f
Cext_5 n6 IB_G2 3.40035f
Cext_6 n6 IB_IA 688.199a
Cext_7 n6 IB_IN 2.18429f
Cext_8 n6 AVSS 37.5196f
Cext_9 AVDD AVSS 117.868a
Cext_10 AVDD IB_G1 824.181a
Cext_11 AVDD IB_G2 822.223a
Cext_12 AVDD IB_IA 0.232484a
Cext_13 AVDD IB_IN 7.13239a
Cext_14 AVDD AVSS 10.6134f
Cext_15 AVSS IB_BUF 534.676a
Cext_16 AVSS IB_IA 1.59875f
Cext_17 AVSS IB_IN 9.40247f
Cext_18 AVSS AVSS 20.8122f
Cext_19 IB_BUF IB_IA 7.90156f
Cext_20 IB_BUF IB_IN 1.10013f
Cext_21 IB_BUF AVSS 2.66826f
Cext_22 IB_G1 IB_G2 3.48839f
Cext_23 IB_G1 AVSS 1.86239f
Cext_24 IB_G2 AVSS 5.15251f
Cext_25 IB_IA IB_IN 9.87854f
Cext_26 IB_IA AVSS 5.74008f
Cext_27 IB_IN AVSS 48.6459f
.ends central_bias
