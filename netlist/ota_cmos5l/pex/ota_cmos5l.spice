** post-layout RC netlist of ota_cmos5l: Magic extresist -> ngspice by scripts/pex_netlist.py --magic (source: /foss/designs/sg13cmos5l_spma_ip__instramp/runs/pex/ota_cmos5l/magic/raw.spice)
.subckt ota_cmos5l VSS IBIAS VDD VINN VINP VOUT
X0 pn2 pn4_t2 VSS_t15 rhigh l=1.95u w=0.5u ps=0 b=0 m=1
X1 VDD_t9 IBIAS_t0 VOUT_t2 VDD_t0 sg13_lv_pmos ad=0.3345p pd=2.9u as=0.1005p ps=1.34u w=0.15u l=0.15u
X2 VOUT_t9 pn4_t3 VSS_t1 VSS_t0 sg13_lv_nmos ad=0.95p pd=5.38u as=3.6p ps=11.44u w=5u l=3u
X3 VDD_t11 IBIAS_t0 VOUT_t5 VDD_t0 sg13_lv_pmos ad=0.3345p pd=2.9u as=0.1005p ps=1.34u w=0.15u l=0.15u
X4 VDD_t5 IBIAS_t0 pn3_t2 VDD_t3 sg13_lv_pmos ad=0.3345p pd=2.9u as=0.1005p ps=1.34u w=0.15u l=0.15u
X5 VDD_t8 IBIAS_t0 pn3_t0 VDD_t3 sg13_lv_pmos ad=0.3345p pd=2.9u as=0.1005p ps=1.34u w=0.15u l=0.15u
X6 VDD_t12 IBIAS_t0 VOUT_t3 VDD_t0 sg13_lv_pmos ad=0.3345p pd=2.9u as=0.1005p ps=1.34u w=0.15u l=0.15u
X7 pn3_t7 VINN_t0 pn1_t0 VDD_t3 sg13_lv_pmos ad=0.95p pd=5.38u as=0.95p ps=5.38u w=5u l=3u
X8 pn4_t1 VINP_t0 pn3_t5 VDD_t0 sg13_lv_pmos ad=0.95p pd=5.38u as=0.95p ps=5.38u w=5u l=3u
X9 pn3_t6 VINP_t0 pn4_t1 VDD_t0 sg13_lv_pmos ad=1.7p pd=10.68u as=0.95p ps=5.38u w=5u l=3u
X10 pn4_t0 pn1_t4 VSS_t12 VSS_t11 sg13_lv_nmos ad=0.95p pd=5.38u as=3.6p ps=11.44u w=5u l=5u
X11 VSS_t14 pn1_t4 pn4_t0 VSS_t13 sg13_lv_nmos ad=1.7p pd=10.68u as=0.95p ps=5.38u w=5u l=5u
X12 VSS_t3 pn4_t3 VOUT_t9 VSS_t2 sg13_lv_nmos ad=0.95p pd=5.38u as=0.95p ps=5.38u w=5u l=3u
X13 VSS_t10 pn1 pn1_t2 VSS_t9 sg13_lv_nmos ad=3.6p pd=11.44u as=0.95p ps=5.38u w=5u l=5u
X14 pn3_t5 VINP_t0 pn4 VDD_t0 sg13_lv_pmos ad=0.95p pd=5.38u as=0.95p ps=5.38u w=5u l=3u
X15 pn1_t1 VINN_t0 pn3_t7 VDD_t3 sg13_lv_pmos ad=0.95p pd=5.38u as=0.95p ps=5.38u w=5u l=3u
X16 pn3_t8 VINN_t0 pn1_t1 VDD_t3 sg13_lv_pmos ad=1.7p pd=10.68u as=0.95p ps=5.38u w=5u l=3u
X17 VDD_t1 IBIAS_t0 VOUT_t4 VDD_t0 sg13_lv_pmos ad=0.3345p pd=2.9u as=0.1005p ps=1.34u w=0.15u l=0.15u
X18 VSS_t6 pn4_t3 VOUT_t8 VSS_t5 sg13_lv_nmos ad=1.7p pd=10.68u as=0.95p ps=5.38u w=5u l=3u
X19 VDD_t13 IBIAS_t0 VOUT_t0 VDD_t0 sg13_lv_pmos ad=0.3345p pd=2.9u as=0.1005p ps=1.34u w=0.15u l=0.15u
X20 VOUT_t8 pn4_t3 VSS_t3 VSS_t4 sg13_lv_nmos ad=0.95p pd=5.38u as=0.95p ps=5.38u w=5u l=3u
X21 VDD_t6 IBIAS_t0 pn3_t1 VDD_t3 sg13_lv_pmos ad=0.3345p pd=2.9u as=0.1005p ps=1.34u w=0.15u l=0.15u
X22 pn1_t0 VINN_t0 pn3 VDD_t3 sg13_lv_pmos ad=0.95p pd=5.38u as=1.7p ps=10.68u w=5u l=3u
X23 pn1_t2 pn1 VSS_t8 VSS_t7 sg13_lv_nmos ad=0.95p pd=5.38u as=1.7p ps=10.68u w=5u l=5u
X24 VDD_t4 IBIAS_t0 IBIAS_t1 VDD_t3 sg13_lv_pmos ad=0.3345p pd=2.9u as=0.1005p ps=1.34u w=0.15u l=0.15u
X25 VDD_t2 IBIAS_t0 VOUT_t1 VDD_t0 sg13_lv_pmos ad=0.3345p pd=2.9u as=0.1005p ps=1.34u w=0.15u l=0.15u
X26 VDD_t14 IBIAS_t0 VOUT_t6 VDD_t0 sg13_lv_pmos ad=0.3345p pd=2.9u as=0.1005p ps=1.34u w=0.15u l=0.15u
X27 VDD_t10 IBIAS_t0 VOUT_t7 VDD_t0 sg13_lv_pmos ad=0.3345p pd=2.9u as=0.1005p ps=1.34u w=0.15u l=0.15u
X28 VDD_t7 IBIAS_t0 pn3_t3 VDD_t3 sg13_lv_pmos ad=0.3345p pd=2.9u as=0.1005p ps=1.34u w=0.15u l=0.15u
X29 pn4 VINP_t0 pn3_t4 VDD_t0 sg13_lv_pmos ad=0.95p pd=5.38u as=1.7p ps=10.68u w=5u l=3u
R0 pn4_n0 pn4_t2 20.2699
R1 pn4_n0 pn4_t3 14.7473
R2 pn4_n1 pn4_t0 12.3775
R3 pn4_n2 pn4_n1 10.4592
R4 pn4 pn4_n2 5.69745
R5 pn4_n2 pn4_t1 3.80008
R6 pn4_n1 pn4_n0 2.6427
R7 pn1_n1 pn1_n0 20.4994
R8 pn1_n2 pn1 15.0005
R9 pn1_n3 pn1 7.46905
R10 pn1_n2 pn1_t4 7.05784
R11 pn1_n0 pn1_t1 5.69783
R12 pn1_n6 pn1 4.9422
R13 pn1_n7 pn1_n6 4.13405
R14 pn1_n0 pn1_t0 3.80064
R15 pn1_n4 pn1 3.66876
R16 pn1_n1 pn1_t2 2.38026
R17 pn1_n5 pn1_n1 1.21595
R18 pn1_n4 pn1_n3 0.388852
R19 pn1_n5 pn1_n4 0.274959
R20 pn1_n3 pn1_n2 0.196893
R21 pn1_n6 pn1_n5 0.192983
R22 pn1_n7 pn1 0.00162886
R23 pn1_n7 pn1 0.00137113
R24 VINP VINP_t0 14.3885
R25 VINN VINN_t0 7.9696
R26 VOUT_n0 VOUT_t4 17.3511
R27 VOUT_n0 VOUT_t1 17.0005
R28 VOUT_n1 VOUT_t2 17.0005
R29 VOUT_n2 VOUT_t7 17.0005
R30 VOUT_n3 VOUT_t5 17.0005
R31 VOUT_n4 VOUT_t3 17.0005
R32 VOUT_n5 VOUT_t0 17.0005
R33 VOUT_n6 VOUT_t6 17.0005
R34 VOUT_n7 VOUT_n6 10.7841
R35 VOUT VOUT_n8 6.58311
R36 VOUT_n8 VOUT_t8 3.07737
R37 VOUT_n7 VOUT_t9 2.48514
R38 VOUT_n8 VOUT_n7 0.606387
R39 VOUT_n1 VOUT_n0 0.351125
R40 VOUT_n2 VOUT_n1 0.351125
R41 VOUT_n3 VOUT_n2 0.351125
R42 VOUT_n4 VOUT_n3 0.351125
R43 VOUT_n5 VOUT_n4 0.351125
R44 VOUT_n6 VOUT_n5 0.351125
R45 pn3_n6 pn3_t2 17.0005
R46 pn3_n5 pn3_t1 17.0005
R47 pn3_n4 pn3_t3 17.0005
R48 pn3_n3 pn3_t0 17.0005
R49 pn3 pn3_n7 7.13857
R50 pn3_n0 pn3_t6 7.13523
R51 pn3_n1 pn3_n0 4.648
R52 pn3_n2 pn3_t8 2.48841
R53 pn3_n7 pn3_t7 2.48797
R54 pn3_n0 pn3_t5 2.48758
R55 pn3_n1 pn3_t4 2.48713
R56 pn3_n2 pn3_n1 2.31737
R57 pn3_n7 pn3_n6 2.29383
R58 pn3_n3 pn3_n2 1.14571
R59 pn3_n6 pn3_n5 0.043
R60 pn3_n5 pn3_n4 0.043
R61 pn3_n4 pn3_n3 0.043
R62 IBIAS IBIAS_n0 20.9158
R63 IBIAS_n0 IBIAS_t1 17.2776
R64 IBIAS_n0 IBIAS_t0 5.3439
R65 VDD_t3 VDD_t4 17.0005
R66 VDD_t3 VDD_t5 17.0005
R67 VDD_t3 VDD_t6 17.0005
R68 VDD_t3 VDD_t7 17.0005
R69 VDD_t3 VDD_t8 17.0005
R70 VDD_t1 VDD_t0 17.0005
R71 VDD_t0 VDD_t2 17.0005
R72 VDD_t0 VDD_t9 17.0005
R73 VDD_t0 VDD_t10 17.0005
R74 VDD_t0 VDD_t11 17.0005
R75 VDD_t0 VDD_t12 17.0005
R76 VDD_t0 VDD_t13 17.0005
R77 VDD_t0 VDD_t14 17.0005
R78 VDD_n16 VDD_t4 8.79188
R79 VDD_n4 VDD_t14 8.56018
R80 VDD_t5 VDD_n16 8.5005
R81 VDD_n15 VDD_t6 8.5005
R82 VDD_n14 VDD_t7 8.5005
R83 VDD_n13 VDD_t8 8.5005
R84 VDD_n9 VDD_t1 8.5005
R85 VDD_t2 VDD_n3 8.5005
R86 VDD_t9 VDD_n8 8.5005
R87 VDD_n7 VDD_t10 8.5005
R88 VDD_n6 VDD_t11 8.5005
R89 VDD_n5 VDD_t12 8.5005
R90 VDD_n4 VDD_t13 8.5005
R91 VDD_t0 VDD_n0 3.03271
R92 VDD_n17 VDD_t3 2.62063
R93 VDD_n10 VDD_n2 1.37246
R94 VDD_n12 VDD_n2 1.3724
R95 VDD_n11 VDD_n0 1.1255
R96 VDD_n2 VDD_n1 0.709333
R97 VDD_n17 VDD_n0 0.425782
R98 VDD_n13 VDD_n12 0.266246
R99 VDD_n10 VDD_n9 0.243768
R100 VDD_n11 VDD_n10 0.146019
R101 VDD_n12 VDD_n11 0.143246
R102 VDD_n18 VDD 0.068
R103 VDD_n16 VDD_n15 0.0601808
R104 VDD_n15 VDD_n14 0.0601808
R105 VDD_n14 VDD_n13 0.0601808
R106 VDD_n9 VDD_n3 0.0601808
R107 VDD_n8 VDD_n3 0.0601808
R108 VDD_n8 VDD_n7 0.0601808
R109 VDD_n7 VDD_n6 0.0601808
R110 VDD_n6 VDD_n5 0.0601808
R111 VDD_n5 VDD_n4 0.0601808
R112 VDD_n18 VDD_n17 0.0373908
R113 VDD VDD_n18 0.0212511
R114 VDD_t0 VDD_n1 0.001
R115 VDD_t3 VDD_n1 0.001
R116 VSS_n76 VSS_n58 1181.11
R117 VSS_t9 VSS_t7 781.598
R118 VSS_t11 VSS_t13 781.598
R119 VSS_t13 VSS_t15 510.555
R120 VSS_n76 VSS_t9 446.005
R121 VSS_n58 VSS_t11 446.005
R122 VSS_t0 VSS_t2 271.051
R123 VSS_t2 VSS_t4 271.051
R124 VSS_t4 VSS_t5 271.051
R125 VSS_n30 VSS_t0 165.999
R126 VSS_t15 VSS_n30 134.724
R127 VSS_n16 VSS_n0 64.6044
R128 VSS_n78 VSS_n77 17.001
R129 VSS_n18 VSS_n17 17.0005
R130 VSS_n19 VSS_n18 17.0005
R131 VSS_n21 VSS_n20 17.0005
R132 VSS_n22 VSS_n21 17.0005
R133 VSS_t1 VSS_n23 17.0005
R134 VSS_n26 VSS_n25 17.0005
R135 VSS_t1 VSS_n27 17.0005
R136 VSS_n25 VSS_n24 17.0005
R137 VSS_n2 VSS_n1 17.0005
R138 VSS_n67 VSS_n2 17.0005
R139 VSS_n69 VSS_n65 17.0005
R140 VSS_n74 VSS_n73 17.0005
R141 VSS_n74 VSS_n63 17.0005
R142 VSS_n43 VSS_n42 17.0005
R143 VSS_n44 VSS_n43 17.0005
R144 VSS_n46 VSS_n45 17.0005
R145 VSS_n47 VSS_n46 17.0005
R146 VSS_n52 VSS_n51 17.0005
R147 VSS_n53 VSS_n52 17.0005
R148 VSS_n48 VSS_t12 17.0005
R149 VSS_n37 VSS_t12 17.0005
R150 VSS_n78 VSS_t10 17.0005
R151 VSS_n66 VSS_t10 17.0005
R152 VSS_n68 VSS_t10 17.0005
R153 VSS_n64 VSS_t10 17.0005
R154 VSS_n29 VSS_n28 8.53085
R155 VSS_n57 VSS_n36 8.5301
R156 VSS_n30 VSS_n4 8.501
R157 VSS_n30 VSS_n5 8.501
R158 VSS_n30 VSS_n6 8.501
R159 VSS_n30 VSS_n7 8.501
R160 VSS_n77 VSS_n76 8.501
R161 VSS_n76 VSS_n60 8.501
R162 VSS_n76 VSS_n75 8.501
R163 VSS_n58 VSS_n34 8.501
R164 VSS_n58 VSS_n35 8.501
R165 VSS_n58 VSS_n32 8.501
R166 VSS_n58 VSS_n31 8.501
R167 VSS_t1 VSS_n12 8.48425
R168 VSS_n15 VSS_n14 8.48425
R169 VSS_n9 VSS_n8 8.48425
R170 VSS_n71 VSS_n65 8.48425
R171 VSS_n49 VSS_n38 8.48425
R172 VSS_n56 VSS_n55 8.48425
R173 VSS_n39 VSS_t12 8.48425
R174 VSS_t1 VSS_n13 8.48402
R175 VSS_t1 VSS_n10 8.48402
R176 VSS_n40 VSS_t12 8.48402
R177 VSS_n54 VSS_t12 8.48402
R178 VSS_n70 VSS_t10 8.48402
R179 VSS_n62 VSS_n59 5.69548
R180 VSS_n30 VSS_n3 5.66778
R181 VSS_n58 VSS_n33 5.66778
R182 VSS_n30 VSS_n29 5.66767
R183 VSS_n58 VSS_n57 5.66767
R184 VSS_t12 VSS_n36 5.64949
R185 VSS_n28 VSS_t1 5.64915
R186 VSS_n16 VSS_t6 4.27294
R187 VSS_n76 VSS_n61 4.25113
R188 VSS_n76 VSS_n59 4.251
R189 VSS_n62 VSS_t10 4.23197
R190 VSS_t1 VSS_n11 3.37444
R191 VSS_n50 VSS_t12 3.37438
R192 VSS_n79 VSS_t8 3.32573
R193 VSS_n41 VSS_t14 3.32459
R194 VSS_n16 VSS_t3 2.39383
R195 VSS_n72 VSS_t10 2.3918
R196 VSS_n17 VSS_n16 2.11432
R197 VSS_n42 VSS_n41 1.16557
R198 VSS_n79 VSS_n78 1.16557
R199 VSS_n80 VSS_n0 0.569117
R200 VSS_n80 VSS_n79 0.5405
R201 VSS_n41 VSS_n0 0.5405
R202 VSS_n73 VSS_n72 0.154992
R203 VSS_n72 VSS_n71 0.151462
R204 VSS_n51 VSS_n50 0.122706
R205 VSS_n26 VSS_n11 0.122201
R206 VSS_n15 VSS_n11 0.116393
R207 VSS_n50 VSS_n49 0.115889
R208 VSS_n81 VSS 0.100423
R209 VSS_n28 VSS_n9 0.0911932
R210 VSS_n55 VSS_n36 0.0911916
R211 VSS_n63 VSS_n62 0.0816883
R212 VSS_n10 VSS_n9 0.0689507
R213 VSS_n55 VSS_n54 0.0689507
R214 VSS_n71 VSS_n70 0.0689507
R215 VSS_n23 VSS_n22 0.0676186
R216 VSS_n48 VSS_n47 0.0676186
R217 VSS_n78 VSS_n1 0.0676186
R218 VSS_n20 VSS_n19 0.0666864
R219 VSS_n27 VSS_n24 0.0666864
R220 VSS_n45 VSS_n44 0.0666864
R221 VSS_n53 VSS_n37 0.0666864
R222 VSS_n67 VSS_n66 0.0666864
R223 VSS_n69 VSS_n68 0.0666864
R224 VSS_n64 VSS_n63 0.0666864
R225 VSS_n81 VSS_n80 0.0468086
R226 VSS_n24 VSS_n10 0.0358897
R227 VSS_n54 VSS_n53 0.0358897
R228 VSS_n70 VSS_n69 0.0358897
R229 VSS_n20 VSS_n12 0.0354254
R230 VSS_n22 VSS_n12 0.0354254
R231 VSS_n45 VSS_n39 0.0354254
R232 VSS_n47 VSS_n39 0.0354254
R233 VSS_n17 VSS_n13 0.0349575
R234 VSS_n19 VSS_n13 0.0349575
R235 VSS_n42 VSS_n40 0.0349575
R236 VSS_n44 VSS_n40 0.0349575
R237 VSS_n23 VSS_n15 0.0344932
R238 VSS_n49 VSS_n48 0.0344932
R239 VSS VSS_n81 0.00667143
R240 VSS_n61 VSS_t10 0.002125
R241 VSS_n65 VSS_n61 0.00187493
R242 VSS_n74 VSS_n59 0.00175
R243 VSS_n21 VSS_n3 0.00166667
R244 VSS_n46 VSS_n33 0.00166667
R245 VSS_n27 VSS_n26 0.0014322
R246 VSS_n51 VSS_n37 0.0014322
R247 VSS_n66 VSS_n1 0.0014322
R248 VSS_n68 VSS_n67 0.0014322
R249 VSS_n73 VSS_n64 0.0014322
R250 VSS_n18 VSS_n3 0.00133332
R251 VSS_n43 VSS_n33 0.00133332
R252 VSS_n14 VSS_n4 0.001
R253 VSS_t1 VSS_n5 0.001
R254 VSS_n25 VSS_n6 0.001
R255 VSS_n8 VSS_n7 0.001
R256 VSS_n21 VSS_n4 0.001
R257 VSS_n14 VSS_n5 0.001
R258 VSS_t1 VSS_n6 0.001
R259 VSS_n25 VSS_n7 0.001
R260 VSS_n29 VSS_n8 0.001
R261 VSS_n65 VSS_n60 0.001
R262 VSS_n75 VSS_t10 0.001
R263 VSS_n38 VSS_n34 0.001
R264 VSS_t12 VSS_n35 0.001
R265 VSS_t12 VSS_n32 0.001
R266 VSS_n52 VSS_n31 0.001
R267 VSS_n57 VSS_n56 0.001
R268 VSS_n46 VSS_n34 0.001
R269 VSS_n38 VSS_n35 0.001
R270 VSS_n52 VSS_n32 0.001
R271 VSS_n56 VSS_n31 0.001
R272 VSS_n77 VSS_n2 0.001
R273 VSS_n60 VSS_n2 0.001
R274 VSS_n75 VSS_n74 0.001
C0 pn2 pn4 0.03272f
C1 pn2 VDD 6.46369f
C2 pn1 pn3 0.21172f
C3 pn4 VDD 0.48122f
C4 VINP pn1 0.34954f
C5 pn3 a_6348_5078_ 0.01599f
C6 IBIAS VDD 2.05781f
C7 pn4 pn1 0.73237f
C8 pn2 a_6348_5078_ 0.0326f
C9 VINN pn3 1.25816f
C10 pn1 VDD 0.47516f
C11 pn4 a_6348_5078_ 0.02407f
C12 VINP VINN 0.44378f
C13 VOUT pn3 0.32339f
C14 VINP VOUT 0.02823f
C15 VDD a_6348_5078_ 0.0251f
C16 pn2 VOUT 0.44392f
C17 VOUT pn4 3.52716f
C18 VINN VDD 9.98953f
C19 VINP pn3 1.2457f
C20 IBIAS VINN 0.23169f
C21 VOUT VDD 0.89818f
C22 VOUT IBIAS 0.03536f
C23 pn2 pn3 0.04323f
C24 pn2 VINP 0.04787f
C25 pn4 pn3 0.23321f
C26 pn1 VINN 1.86615f
C27 VINP pn4 1.8247f
C28 VOUT pn1 0.01413f
C29 pn3 VDD 2.38612f
C30 VINP VDD 10.1302f
C31 IBIAS pn3 0.29344f
C32 VINP IBIAS 0.05023f
C33 VOUT a_6348_5078_ 0.03938f
C34 pn2 VSS 21.49166f
C35 pn4 VSS 13.93035f
C36 VINP VSS 2.05229f
C37 VINN VSS 0.92589f
C38 VOUT VSS 13.88711f
C39 pn3 VSS 1.07086f
C40 IBIAS VSS 1.1584f
C41 VDD VSS 7.44191f
C42 VSS_t10 VSS 10.71019f
C43 VSS_t1 VSS 2.84973f
C44 VSS_t12 VSS 0.83697f
C45 VDD_n0 VSS 9.70098f
C46 VDD_t4 VSS 0.01802f
C47 VDD_t6 VSS 0.01598f
C48 VDD_t8 VSS 0.01598f
C49 VDD_t7 VSS 0.01598f
C50 VDD_n2 VSS 0.17109f
C51 VDD_n3 VSS 0.0229f
C52 VDD_t14 VSS 0.0161f
C53 VDD_t13 VSS 0.01598f
C54 VDD_t12 VSS 0.01598f
C55 VDD_t11 VSS 0.01598f
C56 VDD_t10 VSS 0.01598f
C57 VDD_n4 VSS 0.04007f
C58 VDD_n5 VSS 0.0229f
C59 VDD_n6 VSS 0.0229f
C60 VDD_n7 VSS 0.0229f
C61 VDD_n8 VSS 0.0229f
C62 VDD_t9 VSS 0.55098f
C63 VDD_t2 VSS 0.01598f
C64 VDD_t0 VSS 9.37935f
C65 VDD_t1 VSS 0.01598f
C66 VDD_n9 VSS 0.06349f
C67 VDD_n10 VSS 0.06056f
C68 VDD_n11 VSS 0.21291f
C69 VDD_n12 VSS 0.06415f
C70 VDD_n13 VSS 0.067f
C71 VDD_n14 VSS 0.0229f
C72 VDD_n15 VSS 0.0229f
C73 VDD_n16 VSS 0.12705f
C74 VDD_t5 VSS 0.01598f
C75 VDD_t3 VSS 10.5767f
C76 VDD_n17 VSS 1.62342f
C77 VDD_n18 VSS 0.56952f
C78 IBIAS_t1 VSS 0.04181f
C79 IBIAS_n0 VSS 0.75643f
C80 pn3_t7 VSS 7.32886f
C81 pn3_t8 VSS 0.5478f
C82 pn3_t4 VSS 0.54782f
C83 pn3_t5 VSS 7.34588f
C84 pn3_t6 VSS 0.71834f
C85 pn3_n0 VSS 0.48996f
C86 pn3_n1 VSS 0.32838f
C87 pn3_n2 VSS 0.22293f
C88 pn3_t0 VSS 0.02606f
C89 pn3_n3 VSS 0.16546f
C90 pn3_t3 VSS 0.02606f
C91 pn3_n4 VSS 0.17455f
C92 pn3_t1 VSS 0.02606f
C93 pn3_n5 VSS 0.17455f
C94 pn3_t2 VSS 0.02606f
C95 pn3_n6 VSS 0.20021f
C96 pn3_n7 VSS 0.41914f
C97 VOUT_t8 VSS 0.08117f
C98 VOUT_t9 VSS 2.92165f
C99 VOUT_t2 VSS 0.53813f
C100 VOUT_n6 VSS 0.093f
C101 VOUT_n7 VSS 0.34526f
C102 VOUT_n8 VSS 2.34113f
C103 pn1_t2 VSS 10.76213f
C104 pn1_t1 VSS 0.06316f
C105 pn1_t0 VSS 6.78647f
C106 pn1_n0 VSS 0.0591f
C107 pn1_n1 VSS 0.04207f
C108 pn1_n2 VSS 0.06908f
C109 pn1_n6 VSS 0.01363f
C110 pn4_t1 VSS 6.89452f
C111 pn4_t2 VSS 0.12484f
C112 pn4_n0 VSS 0.39682f
C113 pn4_t0 VSS 0.99775f
C114 pn4_n1 VSS 0.17815f
C115 pn4_n2 VSS 0.08757f
XCM_1 pn2 VOUT cap_cmomi w=14.880u l=16.080u mmin=1 mmax=4 feed=double subblock=0 m=1
XCM_2 pn2 VOUT cap_cmomi w=14.880u l=16.080u mmin=1 mmax=4 feed=double subblock=0 m=1
XCM_3 pn2 VOUT cap_cmomi w=14.880u l=16.080u mmin=1 mmax=4 feed=double subblock=0 m=1
XCM_4 pn2 VOUT cap_cmomi w=14.880u l=16.080u mmin=1 mmax=4 feed=double subblock=0 m=1
XCM_5 VOUT pn2 cap_cmomi w=14.880u l=16.080u mmin=1 mmax=4 feed=double subblock=0 m=1
XCM_6 VOUT pn2 cap_cmomi w=14.880u l=16.080u mmin=1 mmax=4 feed=double subblock=0 m=1
XCM_7 VOUT pn2 cap_cmomi w=14.880u l=16.080u mmin=1 mmax=4 feed=double subblock=0 m=1
XCM_8 VOUT pn2 cap_cmomi w=14.880u l=16.080u mmin=1 mmax=4 feed=double subblock=0 m=1
XCM_9 VOUT pn2 cap_cmomi w=14.880u l=16.080u mmin=1 mmax=4 feed=double subblock=0 m=1
.ends ota_cmos5l
