** post-layout netlist of ota_cmos5l: kpex -> ngspice by scripts/pex_netlist.py (source: /foss/designs/sg13cmos5l_spma_ip__instramp/runs/pex/ota_cmos5l/kpex/ota_cmos5l__ota_cmos5l/ota_cmos5l_k25d_pex_netlist.spice)
.subckt ota_cmos5l VSS IBIAS VDD VINN VINP VOUT
XM_1 n71 n70 VSS VSS sg13_lv_nmos L=5U W=5U AS=1.8P AD=0.95P PS=10.72U PD=5.38U rfmode=0
XM_2 VSS n70 n71 VSS sg13_lv_nmos L=5U W=5U AS=0.95P AD=1.7P PS=5.38U PD=10.68U rfmode=0
XM_3 n70 n70 VSS VSS sg13_lv_nmos L=5U W=5U AS=1.7P AD=0.95P PS=10.68U PD=5.38U rfmode=0
XM_4 VSS n70 n70 VSS sg13_lv_nmos L=5U W=5U AS=0.95P AD=1.8P PS=5.38U PD=10.72U rfmode=0
XM_5 VOUT n71 VSS VSS sg13_lv_nmos L=3U W=5U AS=1.8P AD=0.95P PS=10.72U PD=5.38U rfmode=0
XM_6 VSS n71 VOUT VSS sg13_lv_nmos L=3U W=5U AS=0.95P AD=0.95P PS=5.38U PD=5.38U rfmode=0
XM_7 VOUT n71 VSS VSS sg13_lv_nmos L=3U W=5U AS=0.95P AD=0.95P PS=5.38U PD=5.38U rfmode=0
XM_8 VSS n71 VOUT VSS sg13_lv_nmos L=3U W=5U AS=0.95P AD=1.7P PS=5.38U PD=10.68U rfmode=0
XM_9 VDD IBIAS VOUT VDD sg13_lv_pmos L=0.15U W=0.15U AS=0.1005P AD=0.1545P PS=1.34U PD=1.7U rfmode=0
XM_10 VDD IBIAS VOUT VDD sg13_lv_pmos L=0.15U W=0.15U AS=0.1005P AD=0.1545P PS=1.34U PD=1.7U rfmode=0
XM_11 VDD IBIAS VOUT VDD sg13_lv_pmos L=0.15U W=0.15U AS=0.1005P AD=0.1545P PS=1.34U PD=1.7U rfmode=0
XM_12 VDD IBIAS n149 VDD sg13_lv_pmos L=0.15U W=0.15U AS=0.1005P AD=0.1545P PS=1.34U PD=1.7U rfmode=0
XM_13 VDD IBIAS n149 VDD sg13_lv_pmos L=0.15U W=0.15U AS=0.1005P AD=0.1545P PS=1.34U PD=1.7U rfmode=0
XM_14 n70 VINN n149 VDD sg13_lv_pmos L=3U W=5U AS=1.7P AD=0.95P PS=10.68U PD=5.38U rfmode=0
XM_15 n149 VINN n70 VDD sg13_lv_pmos L=3U W=5U AS=0.95P AD=0.95P PS=5.38U PD=5.38U rfmode=0
XM_16 n70 VINN n149 VDD sg13_lv_pmos L=3U W=5U AS=0.95P AD=0.95P PS=5.38U PD=5.38U rfmode=0
XM_17 n149 VINN n70 VDD sg13_lv_pmos L=3U W=5U AS=0.95P AD=1.7P PS=5.38U PD=10.68U rfmode=0
XM_18 VDD IBIAS VOUT VDD sg13_lv_pmos L=0.15U W=0.15U AS=0.1005P AD=0.1545P PS=1.34U PD=1.7U rfmode=0
XM_19 VDD IBIAS VOUT VDD sg13_lv_pmos L=0.15U W=0.15U AS=0.1005P AD=0.1545P PS=1.34U PD=1.7U rfmode=0
XM_20 n71 VINP n149 VDD sg13_lv_pmos L=3U W=5U AS=1.7P AD=0.95P PS=10.68U PD=5.38U rfmode=0
XM_21 n149 VINP n71 VDD sg13_lv_pmos L=3U W=5U AS=0.95P AD=0.95P PS=5.38U PD=5.38U rfmode=0
XM_22 n71 VINP n149 VDD sg13_lv_pmos L=3U W=5U AS=0.95P AD=0.95P PS=5.38U PD=5.38U rfmode=0
XM_23 n149 VINP n71 VDD sg13_lv_pmos L=3U W=5U AS=0.95P AD=1.7P PS=5.38U PD=10.68U rfmode=0
XM_24 VDD IBIAS VOUT VDD sg13_lv_pmos L=0.15U W=0.15U AS=0.1005P AD=0.1545P PS=1.34U PD=1.7U rfmode=0
XM_25 VDD IBIAS n149 VDD sg13_lv_pmos L=0.15U W=0.15U AS=0.1005P AD=0.1545P PS=1.34U PD=1.7U rfmode=0
XM_26 VDD IBIAS VOUT VDD sg13_lv_pmos L=0.15U W=0.15U AS=0.1005P AD=0.1545P PS=1.34U PD=1.7U rfmode=0
XM_27 VDD IBIAS IBIAS VDD sg13_lv_pmos L=0.15U W=0.15U AS=0.1005P AD=0.1545P PS=1.34U PD=1.7U rfmode=0
XM_28 VDD IBIAS n149 VDD sg13_lv_pmos L=0.15U W=0.15U AS=0.1005P AD=0.1545P PS=1.34U PD=1.7U rfmode=0
XM_29 VDD IBIAS VOUT VDD sg13_lv_pmos L=0.15U W=0.15U AS=0.1005P AD=0.1545P PS=1.34U PD=1.7U rfmode=0
XR_30 n71 n243 VSS rhigh w=0.5u l=1.95u ps=0 b=0 m=1
XC_31 VOUT n243 cap_cmomi w=15e-6 l=15e-6 mmin=1 mmax=4 feed=double subblock=0 m=1
XC_32 VOUT n243 cap_cmomi w=15e-6 l=15e-6 mmin=1 mmax=4 feed=double subblock=0 m=1
XC_33 n243 VOUT cap_cmomi w=15e-6 l=15e-6 mmin=1 mmax=4 feed=double subblock=0 m=1
XC_34 VOUT n243 cap_cmomi w=15e-6 l=15e-6 mmin=1 mmax=4 feed=double subblock=0 m=1
XC_35 n243 VOUT cap_cmomi w=15e-6 l=15e-6 mmin=1 mmax=4 feed=double subblock=0 m=1
XC_36 VOUT n243 cap_cmomi w=15e-6 l=15e-6 mmin=1 mmax=4 feed=double subblock=0 m=1
XC_37 n243 VOUT cap_cmomi w=15e-6 l=15e-6 mmin=1 mmax=4 feed=double subblock=0 m=1
XC_38 n243 VOUT cap_cmomi w=15e-6 l=15e-6 mmin=1 mmax=4 feed=double subblock=0 m=1
XC_39 VOUT n243 cap_cmomi w=15e-6 l=15e-6 mmin=1 mmax=4 feed=double subblock=0 m=1
Cext_1 n149 n243 53.1772a
Cext_2 n149 n70 262.92a
Cext_3 n149 n71 288.207a
Cext_4 n149 IBIAS 413.382a
Cext_5 n149 VDD 421.617a
Cext_6 n149 VINN 1.39193f
Cext_7 n149 VINP 1.37763f
Cext_8 n149 VOUT 446.265a
Cext_9 n149 VSS 2.33263f
Cext_10 n243 n71 39.1145a
Cext_11 n243 VDD 11.3514f
Cext_12 n243 VINP 76.383a
Cext_13 n243 VOUT 661.405a
Cext_14 n243 VSS 3.8583f
Cext_15 n243 VSS 7.93902f
Cext_16 n70 n71 847.629a
Cext_17 n70 IBIAS 5.34089a
Cext_18 n70 VDD 6.02607a
Cext_19 n70 VINN 2.04363f
Cext_20 n70 VINP 383.869a
Cext_21 n70 VOUT 15.9742a
Cext_22 n70 VSS 4.10906f
Cext_23 n70 VSS 18.0756f
Cext_24 n71 IBIAS 0.597256a
Cext_25 n71 VDD 8.51675a
Cext_26 n71 VINN 0.178189a
Cext_27 n71 VINP 2.04984f
Cext_28 n71 VOUT 3.98165f
Cext_29 n71 VSS 2.45349f
Cext_30 n71 VSS 13.0574f
Cext_31 IBIAS VDD 822.652a
Cext_32 IBIAS VINN 255.385a
Cext_33 IBIAS VINP 34.1153a
Cext_34 IBIAS VOUT 41.3938a
Cext_35 IBIAS VSS 1.95841f
Cext_36 VDD VINN 206.085a
Cext_37 VDD VINP 281.372a
Cext_38 VDD VOUT 599.884a
Cext_39 VDD VSS 10.5468f
Cext_40 VINN VINP 622.909a
Cext_41 VINN VSS 0.126826a
Cext_42 VINN VSS 11.3233f
Cext_43 VINP VOUT 34.3905a
Cext_44 VINP VSS 6.53905a
Cext_45 VINP VSS 12.1318f
Cext_46 VOUT VSS 551.651a
Cext_47 VOUT VSS 8.40408f
Cext_48 VSS VSS 16.0906f
.ends ota_cmos5l
