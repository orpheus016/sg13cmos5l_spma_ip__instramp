** sch_path: /foss/designs/Chipalooza/Programmable-Instrumentation-Amplifier-IP/designs/libs/core_digital/dec2to4/dec2to4.sch
**.subckt dec2to4 A0 A1 Y0 Y1 Y2 Y3 VDD VSS
*.ipin A0
*.ipin A1
*.opin Y0
*.opin Y1
*.opin Y2
*.opin Y3
*.iopin VDD
*.iopin VSS
**.ends
.end
