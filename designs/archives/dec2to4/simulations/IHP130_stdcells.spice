** sch_path: /foss/pdks/ihp-sg13cmos5l/libs.tech/xschem/sg13cmos5l_stdcells/IHP130_stdcells.sch
**.subckt IHP130_stdcells
*  x1 -  sg13cmos5l_xor2_1  IS MISSING !!!!
*  x2 -  sg13cmos5l_xnor2_1  IS MISSING !!!!
*  x3 -  sg13cmos5l_or4_2  IS MISSING !!!!
*  x4 -  sg13cmos5l_or4_1  IS MISSING !!!!
*  x5 -  sg13cmos5l_or3_2  IS MISSING !!!!
*  x6 -  sg13cmos5l_or3_1  IS MISSING !!!!
*  x7 -  sg13cmos5l_or2_2  IS MISSING !!!!
*  x8 -  sg13cmos5l_nor4_2  IS MISSING !!!!
*  x9 -  sg13cmos5l_nor4_1  IS MISSING !!!!
*  x10 -  sg13cmos5l_nor3_2  IS MISSING !!!!
*  x11 -  sg13cmos5l_nor3_1  IS MISSING !!!!
*  x12 -  sg13cmos5l_nor2b_2  IS MISSING !!!!
*  x13 -  sg13cmos5l_nor2b_1  IS MISSING !!!!
*  x14 -  sg13cmos5l_nor2_2  IS MISSING !!!!
*  x15 -  sg13cmos5l_nor2_1  IS MISSING !!!!
*  x16 -  sg13cmos5l_or2_1  IS MISSING !!!!
*  x17 -  sg13cmos5l_nand4_1  IS MISSING !!!!
*  x18 -  sg13cmos5l_nand3b_1  IS MISSING !!!!
*  x19 -  sg13cmos5l_nand3_1  IS MISSING !!!!
*  x20 -  sg13cmos5l_nand2b_2  IS MISSING !!!!
*  x21 -  sg13cmos5l_nand2b_1  IS MISSING !!!!
*  x22 -  sg13cmos5l_nand2_2  IS MISSING !!!!
*  x23 -  sg13cmos5l_nand2_1  IS MISSING !!!!
*  x24 -  sg13cmos5l_mux4_1  IS MISSING !!!!
*  x25 -  sg13cmos5l_mux2_2  IS MISSING !!!!
*  x26 -  sg13cmos5l_mux2_1  IS MISSING !!!!
*  x27 -  sg13cmos5l_inv_8  IS MISSING !!!!
*  x29 -  sg13cmos5l_inv_4  IS MISSING !!!!
*  x30 -  sg13cmos5l_inv_2  IS MISSING !!!!
*  x31 -  sg13cmos5l_inv_16  IS MISSING !!!!
*  x32 -  sg13cmos5l_inv_1  IS MISSING !!!!
*  x33 -  sg13cmos5l_einvn_2  IS MISSING !!!!
*  x34 -  sg13cmos5l_einvn_4  IS MISSING !!!!
*  x35 -  sg13cmos5l_einvn_8  IS MISSING !!!!
*  x36 -  sg13cmos5l_ebufn_8  IS MISSING !!!!
*  x37 -  sg13cmos5l_ebufn_4  IS MISSING !!!!
*  x38 -  sg13cmos5l_ebufn_2  IS MISSING !!!!
*  x40 -  sg13cmos5l_dlygate4sd2_1  IS MISSING !!!!
*  x41 -  sg13cmos5l_dlygate4sd1_1  IS MISSING !!!!
*  x42 -  sg13cmos5l_dlygate4sd3_1  IS MISSING !!!!
*  x28 -  sg13cmos5l_and4_2  IS MISSING !!!!
*  x39 -  sg13cmos5l_and4_1  IS MISSING !!!!
*  x43 -  sg13cmos5l_and3_2  IS MISSING !!!!
*  x44 -  sg13cmos5l_and3_1  IS MISSING !!!!
*  x45 -  sg13cmos5l_and2_2  IS MISSING !!!!
*  x46 -  sg13cmos5l_and2_1  IS MISSING !!!!
*  x47 -  sg13cmos5l_a22oi_1  IS MISSING !!!!
*  x48 -  sg13cmos5l_a21o_2  IS MISSING !!!!
*  x49 -  sg13cmos5l_a21oi_1  IS MISSING !!!!
*  x50 -  sg13cmos5l_a221oi_1  IS MISSING !!!!
*  x51 -  sg13cmos5l_a21o_2  IS MISSING !!!!
*  x52 -  sg13cmos5l_a21oi_2  IS MISSING !!!!
*  x53 -  sg13cmos5l_dfrbp_1  IS MISSING !!!!
*  x54 -  sg13cmos5l_dfrbp_2  IS MISSING !!!!
*  x55 -  sg13cmos5l_dlhq_1  IS MISSING !!!!
*  x56 -  sg13cmos5l_dlhr_1  IS MISSING !!!!
*  x57 -  sg13cmos5l_dlhrq_1  IS MISSING !!!!
*  x58 -  sg13cmos5l_dllr_1  IS MISSING !!!!
*  x59 -  sg13cmos5l_dllrq_1  IS MISSING !!!!
*  x60 -  sg13cmos5l_sdfbbp_1  IS MISSING !!!!
**.ends
.end
