* NGSPICE file created from decoder_top_10b.ext - technology: ihp-sg13g2

* Black-box entry subcircuit for sg13g2_fill_1 abstract view
.subckt sg13g2_fill_1 VDD VSS
.ends

* Black-box entry subcircuit for sg13g2_decap_8 abstract view
.subckt sg13g2_decap_8 VDD VSS
.ends

* Black-box entry subcircuit for sg13g2_decap_4 abstract view
.subckt sg13g2_decap_4 VDD VSS
.ends

* Black-box entry subcircuit for sg13g2_fill_2 abstract view
.subckt sg13g2_fill_2 VDD VSS
.ends

* Black-box entry subcircuit for sg13g2_buf_1 abstract view
.subckt sg13g2_buf_1 X A VDD VSS
.ends

* Black-box entry subcircuit for sg13g2_nor3_1 abstract view
.subckt sg13g2_nor3_1 Y A B C VDD VSS
.ends

* Black-box entry subcircuit for sg13g2_nor4_1 abstract view
.subckt sg13g2_nor4_1 Y A B C D VDD VSS
.ends

* Black-box entry subcircuit for sg13g2_inv_1 abstract view
.subckt sg13g2_inv_1 Y A VDD VSS
.ends

* Black-box entry subcircuit for sg13g2_nor2_1 abstract view
.subckt sg13g2_nor2_1 Y A B VDD VSS
.ends

* Black-box entry subcircuit for sg13g2_nand3_1 abstract view
.subckt sg13g2_nand3_1 Y A B C VDD VSS
.ends

* Black-box entry subcircuit for sg13g2_nand2_1 abstract view
.subckt sg13g2_nand2_1 Y A B VDD VSS
.ends

* Black-box entry subcircuit for sg13g2_nand2b_1 abstract view
.subckt sg13g2_nand2b_1 Y A_N B VDD VSS
.ends

.subckt decoder_top_10b VGND VPWR d[0] d[1] d[2] d[3] d[4] d[5] d[6] d[7] d[8] d[9]
+ s[4] s[5] s[6] s[7] s[8] s[9] sb[4] sb[5] sb[6] sb[7] sb[8] sb[9] y[0] y[10] y[11]
+ y[12] y[13] y[14] y[15] y[1] y[2] y[3] y[4] y[5] y[6] y[7] y[8] y[9]
XFILLER_3_56 VPWR VGND sg13g2_fill_1
XFILLER_6_107 VPWR VGND sg13g2_decap_8
XFILLER_9_126 VPWR VGND sg13g2_decap_4
XFILLER_0_35 VPWR VGND sg13g2_decap_8
XFILLER_9_77 VPWR VGND sg13g2_decap_8
XFILLER_6_23 VPWR VGND sg13g2_decap_8
XFILLER_3_35 VPWR VGND sg13g2_decap_8
XFILLER_7_8 VPWR VGND sg13g2_fill_2
Xoutput31 y[2] _18_/Y VPWR VGND sg13g2_buf_1
Xoutput20 sb[7] _09_/Y VPWR VGND sg13g2_buf_1
XFILLER_9_105 VPWR VGND sg13g2_decap_8
XFILLER_0_14 VPWR VGND sg13g2_decap_8
XFILLER_9_34 VPWR VGND sg13g2_decap_8
XFILLER_6_79 VPWR VGND sg13g2_decap_8
Xoutput32 y[3] _20_/Y VPWR VGND sg13g2_buf_1
Xoutput21 sb[8] _10_/Y VPWR VGND sg13g2_buf_1
XFILLER_10_127 VPWR VGND sg13g2_decap_4
XFILLER_3_14 VPWR VGND sg13g2_decap_8
XFILLER_3_69 VPWR VGND sg13g2_decap_8
XFILLER_9_57 VPWR VGND sg13g2_fill_2
XFILLER_9_13 VPWR VGND sg13g2_decap_8
XFILLER_1_91 VPWR VGND sg13g2_decap_8
XFILLER_6_58 VPWR VGND sg13g2_decap_4
Xoutput33 y[4] _21_/Y VPWR VGND sg13g2_buf_1
Xoutput22 sb[9] _11_/Y VPWR VGND sg13g2_buf_1
Xoutput11 s[4] _34_/X VPWR VGND sg13g2_buf_1
XFILLER_10_106 VPWR VGND sg13g2_decap_8
XFILLER_0_49 VPWR VGND sg13g2_decap_4
XFILLER_2_113 VPWR VGND sg13g2_decap_8
XFILLER_1_70 VPWR VGND sg13g2_decap_8
XFILLER_6_37 VPWR VGND sg13g2_decap_8
Xoutput34 y[5] _22_/Y VPWR VGND sg13g2_buf_1
Xoutput23 y[0] _14_/Y VPWR VGND sg13g2_buf_1
Xoutput12 s[5] _35_/X VPWR VGND sg13g2_buf_1
X_29_ _29_/Y _33_/A _29_/B _29_/C VPWR VGND sg13g2_nor3_1
XFILLER_3_49 VPWR VGND sg13g2_decap_8
XFILLER_7_91 VPWR VGND sg13g2_decap_8
XFILLER_8_130 VPWR VGND sg13g2_fill_2
XFILLER_9_119 VPWR VGND sg13g2_decap_8
XFILLER_0_28 VPWR VGND sg13g2_decap_8
XFILLER_5_8 VPWR VGND sg13g2_fill_1
X_28_ _28_/Y _33_/A _29_/B _32_/C VPWR VGND sg13g2_nor3_1
XFILLER_7_70 VPWR VGND sg13g2_decap_8
Xoutput35 y[6] _23_/Y VPWR VGND sg13g2_buf_1
Xoutput24 y[10] _28_/Y VPWR VGND sg13g2_buf_1
Xoutput13 s[6] _36_/X VPWR VGND sg13g2_buf_1
XFILLER_3_28 VPWR VGND sg13g2_decap_8
XFILLER_5_123 VPWR VGND sg13g2_fill_1
XFILLER_4_93 VPWR VGND sg13g2_decap_8
XFILLER_9_27 VPWR VGND sg13g2_decap_8
XFILLER_10_92 VPWR VGND sg13g2_decap_8
X_27_ _27_/Y _33_/A _29_/B _31_/C VPWR VGND sg13g2_nor3_1
Xoutput36 y[7] _25_/Y VPWR VGND sg13g2_buf_1
Xoutput25 y[11] _29_/Y VPWR VGND sg13g2_buf_1
Xoutput14 s[7] _37_/X VPWR VGND sg13g2_buf_1
XFILLER_2_127 VPWR VGND sg13g2_decap_4
XFILLER_4_72 VPWR VGND sg13g2_decap_8
XFILLER_5_102 VPWR VGND sg13g2_decap_8
XFILLER_1_4 VPWR VGND sg13g2_decap_4
XFILLER_1_84 VPWR VGND sg13g2_decap_8
X_26_ _26_/Y _33_/A _30_/B _30_/C _26_/D VPWR VGND sg13g2_nor4_1
XFILLER_10_71 VPWR VGND sg13g2_decap_8
Xoutput37 y[8] _26_/Y VPWR VGND sg13g2_buf_1
Xoutput26 y[12] _30_/Y VPWR VGND sg13g2_buf_1
Xoutput15 s[8] _38_/X VPWR VGND sg13g2_buf_1
X_09_ _09_/Y _37_/A VPWR VGND sg13g2_inv_1
XFILLER_2_106 VPWR VGND sg13g2_decap_8
XFILLER_3_8 VPWR VGND sg13g2_fill_2
XFILLER_4_51 VPWR VGND sg13g2_decap_8
XFILLER_1_63 VPWR VGND sg13g2_decap_8
X_25_ _25_/Y _25_/A _33_/B VPWR VGND sg13g2_nor2_1
X_08_ _08_/Y _36_/A VPWR VGND sg13g2_inv_1
XFILLER_7_84 VPWR VGND sg13g2_decap_8
XFILLER_8_112 VPWR VGND sg13g2_decap_8
Xoutput38 y[9] _27_/Y VPWR VGND sg13g2_buf_1
Xoutput27 y[13] _31_/Y VPWR VGND sg13g2_buf_1
Xoutput16 s[9] _39_/X VPWR VGND sg13g2_buf_1
XFILLER_4_30 VPWR VGND sg13g2_decap_8
XFILLER_1_42 VPWR VGND sg13g2_decap_8
Xfanout40 _29_/B _26_/D VPWR VGND sg13g2_buf_1
X_24_ _33_/B _30_/B _30_/C _29_/B VPWR VGND sg13g2_nand3_1
Xoutput28 y[14] _32_/Y VPWR VGND sg13g2_buf_1
Xoutput17 sb[4] _06_/Y VPWR VGND sg13g2_buf_1
X_07_ _07_/Y _35_/A VPWR VGND sg13g2_inv_1
XFILLER_5_116 VPWR VGND sg13g2_decap_8
XFILLER_7_63 VPWR VGND sg13g2_decap_8
XFILLER_1_130 VPWR VGND sg13g2_fill_2
XFILLER_4_20 VPWR VGND sg13g2_fill_1
XFILLER_4_86 VPWR VGND sg13g2_decap_8
XFILLER_10_85 VPWR VGND sg13g2_decap_8
XFILLER_1_21 VPWR VGND sg13g2_decap_8
XFILLER_1_98 VPWR VGND sg13g2_decap_8
X_23_ _23_/Y _23_/A _32_/B _32_/C VPWR VGND sg13g2_nor3_1
XFILLER_7_42 VPWR VGND sg13g2_decap_8
Xoutput29 y[15] _33_/Y VPWR VGND sg13g2_buf_1
Xoutput18 sb[5] _07_/Y VPWR VGND sg13g2_buf_1
X_06_ _06_/Y _34_/A VPWR VGND sg13g2_inv_1
XFILLER_1_77 VPWR VGND sg13g2_decap_8
XFILLER_1_8 VPWR VGND sg13g2_fill_2
X_22_ _22_/Y _25_/A _32_/B _31_/C VPWR VGND sg13g2_nor3_1
Xoutput19 sb[6] _08_/Y VPWR VGND sg13g2_buf_1
XFILLER_7_21 VPWR VGND sg13g2_decap_8
XFILLER_7_98 VPWR VGND sg13g2_decap_8
XFILLER_8_126 VPWR VGND sg13g2_decap_4
XFILLER_4_44 VPWR VGND sg13g2_decap_8
XFILLER_10_21 VPWR VGND sg13g2_decap_8
XFILLER_10_32 VPWR VGND sg13g2_fill_2
XFILLER_1_56 VPWR VGND sg13g2_decap_8
X_21_ _21_/Y _25_/A _30_/B _30_/C _32_/B VPWR VGND sg13g2_nor4_1
XFILLER_7_77 VPWR VGND sg13g2_decap_8
XFILLER_8_105 VPWR VGND sg13g2_decap_8
XFILLER_10_99 VPWR VGND sg13g2_decap_8
XFILLER_1_35 VPWR VGND sg13g2_decap_8
Xinput1 _30_/B d[0] VPWR VGND sg13g2_buf_1
X_20_ _20_/Y _25_/A _29_/B _29_/C VPWR VGND sg13g2_nor3_1
XFILLER_7_56 VPWR VGND sg13g2_decap_8
XFILLER_1_112 VPWR VGND sg13g2_decap_8
XFILLER_4_79 VPWR VGND sg13g2_decap_8
XFILLER_5_109 VPWR VGND sg13g2_decap_8
XFILLER_8_4 VPWR VGND sg13g2_decap_4
XFILLER_10_78 VPWR VGND sg13g2_decap_8
XFILLER_1_14 VPWR VGND sg13g2_decap_8
Xinput2 _30_/C d[1] VPWR VGND sg13g2_buf_1
XFILLER_7_35 VPWR VGND sg13g2_decap_8
XFILLER_4_121 VPWR VGND sg13g2_decap_8
XFILLER_4_58 VPWR VGND sg13g2_fill_2
Xinput3 _26_/D d[2] VPWR VGND sg13g2_buf_1
XFILLER_7_14 VPWR VGND sg13g2_decap_8
XFILLER_8_119 VPWR VGND sg13g2_decap_8
XFILLER_4_100 VPWR VGND sg13g2_decap_8
XFILLER_4_37 VPWR VGND sg13g2_decap_8
XFILLER_1_49 VPWR VGND sg13g2_decap_8
Xinput4 _23_/A d[3] VPWR VGND sg13g2_buf_1
XFILLER_10_14 VPWR VGND sg13g2_decap_8
XFILLER_2_92 VPWR VGND sg13g2_decap_8
XFILLER_8_91 VPWR VGND sg13g2_decap_8
XFILLER_1_126 VPWR VGND sg13g2_decap_4
XFILLER_5_81 VPWR VGND sg13g2_decap_8
XFILLER_1_28 VPWR VGND sg13g2_decap_8
Xinput5 _34_/A d[4] VPWR VGND sg13g2_buf_1
XFILLER_2_71 VPWR VGND sg13g2_decap_8
XFILLER_7_49 VPWR VGND sg13g2_decap_8
XFILLER_8_70 VPWR VGND sg13g2_decap_8
XFILLER_1_105 VPWR VGND sg13g2_decap_8
XFILLER_8_8 VPWR VGND sg13g2_fill_2
XFILLER_2_50 VPWR VGND sg13g2_decap_8
Xinput6 _35_/A d[5] VPWR VGND sg13g2_buf_1
XFILLER_7_28 VPWR VGND sg13g2_decap_8
XFILLER_4_114 VPWR VGND sg13g2_decap_8
XFILLER_4_18 VPWR VGND sg13g2_fill_2
Xfanout39 _25_/A _23_/A VPWR VGND sg13g2_buf_1
XFILLER_10_28 VPWR VGND sg13g2_decap_4
XFILLER_5_61 VPWR VGND sg13g2_decap_4
Xinput7 _36_/A d[6] VPWR VGND sg13g2_buf_1
Xinput10 _39_/A d[9] VPWR VGND sg13g2_buf_1
XFILLER_7_112 VPWR VGND sg13g2_decap_8
XFILLER_7_123 VPWR VGND sg13g2_fill_1
XFILLER_5_95 VPWR VGND sg13g2_decap_8
XFILLER_2_85 VPWR VGND sg13g2_decap_8
Xinput8 _37_/A d[7] VPWR VGND sg13g2_buf_1
X_39_ _39_/X _39_/A VPWR VGND sg13g2_buf_1
XFILLER_1_119 VPWR VGND sg13g2_decap_8
XFILLER_8_84 VPWR VGND sg13g2_decap_8
XFILLER_10_0 VPWR VGND sg13g2_decap_8
XFILLER_5_52 VPWR VGND sg13g2_decap_4
XFILLER_5_74 VPWR VGND sg13g2_decap_8
Xinput9 _38_/A d[8] VPWR VGND sg13g2_buf_1
XFILLER_2_64 VPWR VGND sg13g2_decap_8
XFILLER_4_128 VPWR VGND sg13g2_decap_4
XFILLER_8_63 VPWR VGND sg13g2_decap_8
X_38_ _38_/X _38_/A VPWR VGND sg13g2_buf_1
XFILLER_0_120 VPWR VGND sg13g2_decap_8
XFILLER_0_131 VPWR VGND sg13g2_fill_1
XFILLER_2_43 VPWR VGND sg13g2_decap_8
XFILLER_0_0 VPWR VGND sg13g2_decap_8
X_37_ _37_/X _37_/A VPWR VGND sg13g2_buf_1
XFILLER_4_107 VPWR VGND sg13g2_decap_8
XFILLER_8_42 VPWR VGND sg13g2_decap_8
XFILLER_5_65 VPWR VGND sg13g2_fill_1
XFILLER_2_22 VPWR VGND sg13g2_decap_8
XFILLER_2_99 VPWR VGND sg13g2_decap_8
XFILLER_7_105 VPWR VGND sg13g2_decap_8
XFILLER_8_21 VPWR VGND sg13g2_decap_8
X_36_ _36_/X _36_/A VPWR VGND sg13g2_buf_1
X_19_ _29_/C _30_/B _30_/C VPWR VGND sg13g2_nand2_1
XFILLER_8_98 VPWR VGND sg13g2_decap_8
XFILLER_5_88 VPWR VGND sg13g2_decap_8
XFILLER_2_78 VPWR VGND sg13g2_decap_8
X_35_ _35_/X _35_/A VPWR VGND sg13g2_buf_1
X_18_ _18_/Y _25_/A _29_/B _32_/C VPWR VGND sg13g2_nor3_1
XFILLER_8_77 VPWR VGND sg13g2_decap_8
XFILLER_5_45 VPWR VGND sg13g2_decap_8
XFILLER_5_56 VPWR VGND sg13g2_fill_2
XFILLER_2_57 VPWR VGND sg13g2_decap_8
XFILLER_8_56 VPWR VGND sg13g2_decap_8
X_34_ _34_/X _34_/A VPWR VGND sg13g2_buf_1
X_17_ _32_/C _30_/B _30_/C VPWR VGND sg13g2_nand2b_1
XFILLER_0_113 VPWR VGND sg13g2_decap_8
XFILLER_2_36 VPWR VGND sg13g2_decap_8
XFILLER_3_90 VPWR VGND sg13g2_decap_8
X_33_ _33_/Y _33_/A _33_/B VPWR VGND sg13g2_nor2_1
XFILLER_3_111 VPWR VGND sg13g2_decap_8
XFILLER_7_119 VPWR VGND sg13g2_decap_4
XFILLER_8_35 VPWR VGND sg13g2_decap_8
X_16_ _16_/Y _25_/A _29_/B _31_/C VPWR VGND sg13g2_nor3_1
XFILLER_5_25 VPWR VGND sg13g2_fill_2
XFILLER_2_15 VPWR VGND sg13g2_decap_8
XFILLER_8_14 VPWR VGND sg13g2_decap_8
X_32_ _32_/Y _33_/A _32_/B _32_/C VPWR VGND sg13g2_nor3_1
X_15_ _31_/C _30_/C _30_/B VPWR VGND sg13g2_nand2b_1
XFILLER_10_7 VPWR VGND sg13g2_decap_8
X_31_ _31_/Y _33_/A _32_/B _31_/C VPWR VGND sg13g2_nor3_1
XFILLER_6_121 VPWR VGND sg13g2_fill_2
X_14_ _14_/Y _25_/A _30_/B _30_/C _26_/D VPWR VGND sg13g2_nor4_1
XFILLER_0_127 VPWR VGND sg13g2_decap_4
XFILLER_0_82 VPWR VGND sg13g2_decap_4
XFILLER_5_27 VPWR VGND sg13g2_fill_1
XFILLER_5_38 VPWR VGND sg13g2_decap_8
XFILLER_9_91 VPWR VGND sg13g2_decap_8
XFILLER_0_7 VPWR VGND sg13g2_decap_8
XFILLER_6_100 VPWR VGND sg13g2_decap_8
XFILLER_8_49 VPWR VGND sg13g2_decap_8
X_30_ _30_/Y _33_/A _30_/B _30_/C _32_/B VPWR VGND sg13g2_nor4_1
XFILLER_9_130 VPWR VGND sg13g2_fill_2
XFILLER_0_106 VPWR VGND sg13g2_decap_8
XFILLER_0_61 VPWR VGND sg13g2_decap_4
XFILLER_3_125 VPWR VGND sg13g2_decap_8
X_13_ _32_/B _29_/B VPWR VGND sg13g2_inv_1
XFILLER_9_70 VPWR VGND sg13g2_decap_8
XFILLER_6_93 VPWR VGND sg13g2_decap_8
XFILLER_2_29 VPWR VGND sg13g2_decap_8
XFILLER_3_104 VPWR VGND sg13g2_decap_8
XFILLER_3_83 VPWR VGND sg13g2_decap_8
XFILLER_6_123 VPWR VGND sg13g2_fill_1
XFILLER_8_28 VPWR VGND sg13g2_decap_8
X_12_ _33_/A _25_/A VPWR VGND sg13g2_inv_1
XFILLER_5_18 VPWR VGND sg13g2_decap_8
XFILLER_10_120 VPWR VGND sg13g2_decap_8
XFILLER_10_131 VPWR VGND sg13g2_fill_1
X_11_ _11_/Y _39_/A VPWR VGND sg13g2_inv_1
XFILLER_6_51 VPWR VGND sg13g2_decap_8
XFILLER_6_62 VPWR VGND sg13g2_fill_2
XFILLER_6_114 VPWR VGND sg13g2_decap_8
X_10_ _10_/Y _38_/A VPWR VGND sg13g2_inv_1
XFILLER_0_42 VPWR VGND sg13g2_decap_8
XFILLER_0_75 VPWR VGND sg13g2_decap_8
XFILLER_0_86 VPWR VGND sg13g2_fill_1
XFILLER_9_84 VPWR VGND sg13g2_decap_8
XFILLER_6_30 VPWR VGND sg13g2_decap_8
XFILLER_3_42 VPWR VGND sg13g2_decap_8
XFILLER_3_97 VPWR VGND sg13g2_decap_8
XFILLER_9_112 VPWR VGND sg13g2_decap_8
XFILLER_0_21 VPWR VGND sg13g2_decap_8
XFILLER_0_65 VPWR VGND sg13g2_fill_2
XFILLER_3_118 VPWR VGND sg13g2_decap_8
XFILLER_9_63 VPWR VGND sg13g2_decap_8
XFILLER_6_86 VPWR VGND sg13g2_decap_8
XFILLER_9_8 VPWR VGND sg13g2_fill_2
XFILLER_3_21 VPWR VGND sg13g2_decap_8
XFILLER_3_76 VPWR VGND sg13g2_decap_8
XFILLER_9_20 VPWR VGND sg13g2_decap_8
XFILLER_10_113 VPWR VGND sg13g2_decap_8
XFILLER_2_120 VPWR VGND sg13g2_decap_8
XFILLER_2_131 VPWR VGND sg13g2_fill_1
XFILLER_9_98 VPWR VGND sg13g2_decap_8
XFILLER_6_44 VPWR VGND sg13g2_decap_8
Xoutput30 y[1] _16_/Y VPWR VGND sg13g2_buf_1
.ends
