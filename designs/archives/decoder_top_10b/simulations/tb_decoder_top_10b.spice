** sch_path: /foss/designs/Chipalooza/Programmable-Instrumentation-Amplifier-IP/designs/libs/core_digital/decoder_top_10b/tb_decoder_top_10b.sch
**.subckt tb_decoder_top_10b
x1 VD0 VD3 VY0 VY1 VY2 VY3 net1 0 VY4 VY5 VY6 VY7 VY8 VY9 VY10 VY11 VY12 VY13 VY14 VY15 VD1 VD2 VD4 VD7 VD5 VD6 VD8 VD9 VS4 VS4B
+ VS5 VS5B VS6 VS6B VS7 VS7B VS8 VS8B VS9 VS9B decoder_top_10b
VDD net1 0 1.2
VI0 VD0 0 PULSE(0 1.2 10n 100p 100p 10n 20n)
VI1 VD1 0 PULSE(0 1.2 20n 100p 100p 20n 40n)
VI2 VD2 0 PULSE(0 1.2 40n 100p 100p 40n 80n)
VI3 VD3 0 PULSE(0 1.2 80n 100p 100p 80n 160n)
VI4 VD4 0 PULSE(0 1.2 5n 100p 100p 5n 10n)
VI5 VD5 0 PULSE(0 1.2 10n 100p 100p 10n 20n)
VI6 VD6 0 PULSE(0 1.2 20n 100p 100p 20n 40n)
VI7 VD7 0 PULSE(0 1.2 40n 100p 100p 40n 80n)
VI8 VD8 0 PULSE(0 1.2 80n 100p 100p 80n 160n)
VI9 VD9 0 PULSE(0 1.2 160n 100p 100p 160n 320n)
CLY0 VY0 0 10f
CLY1 VY1 0 10f
CLY2 VY2 0 10f
CLY3 VY3 0 10f
CLY4 VY4 0 10f
CLY5 VY5 0 10f
CLY6 VY6 0 10f
CLY7 VY7 0 10f
CLY8 VY8 0 10f
CLY9 VY9 0 10f
CLY10 VY10 0 10f
CLY11 VY11 0 10f
CLY12 VY12 0 10f
CLY13 VY13 0 10f
CLY14 VY14 0 10f
CLY15 VY15 0 10f
CLS4 VS4 0 10f
CLS4B VS4B 0 10f
CLS6B VS6B 0 10f
CLS5B VS5B 0 10f
CLS5 VS5 0 10f
CLS6 VS6 0 10f
CLS7 VS7 0 10f
CLS7B VS7B 0 10f
CLS8 VS8 0 10f
CLS8B VS8B 0 10f
CLS9 VS9 0 10f
CLS9B VS9B 0 10f
**** begin user architecture code

.lib cornerMOSlv.lib mos_tt
.include /foss/pdks/ihp-sg13cmos5l/libs.ref/sg13cmos5l_stdcell/spice/sg13cmos5l_stdcell.spice

.control
  tran 100p 320n
  write tb_decoder_top_10b.raw

  * ==========================================
  * 1. COARSE GAIN STAGE (D0..D3 -> Y0..Y15)
  * ==========================================
  * Coarse 4-bit Binary Inputs (D0..D3)
  plot v(VD0) v(VD1)+1.5 v(VD2)+3.0 v(VD3)+4.5 title 'Coarse Inputs (D0, D1, D2, D3)' xlabel 'Time (s)' ylabel 'Voltage (V)'

  * Coarse Outputs Lower 8 Channels (Y0..Y7)
  plot v(VY0) v(VY1)+1.5 v(VY2)+3.0 v(VY3)+4.5 v(VY4)+6.0 v(VY5)+7.5 v(VY6)+9.0 v(VY7)+10.5 title 'Coarse Decoded Outputs (Y0..Y7)' xlabel 'Time (s)' ylabel 'Voltage (V)'

  * Coarse Outputs Upper 8 Channels (Y8..Y15)
  plot v(VY8) v(VY9)+1.5 v(VY10)+3.0 v(VY11)+4.5 v(VY12)+6.0 v(VY13)+7.5 v(VY14)+9.0 v(VY15)+10.5 title 'Coarse Decoded Outputs (Y8..Y15)' xlabel 'Time (s)' ylabel 'Voltage (V)'

  * ==========================================
  * 2. FINE GAIN STAGE (D4..D9 -> S4..S9B)
  * ==========================================
  * Fine 6-bit Inputs (D4..D9)
  plot v(VD4) v(VD5)+1.5 v(VD6)+3.0 v(VD7)+4.5 v(VD8)+6.0 v(VD9)+7.5 title 'Fine Inputs (D4, D5, D6, D7, D8, D9)' xlabel 'Time (s)' ylabel 'Voltage (V)'

  * Fine Complementary Outputs: Bits 4 - 6 (S4/S4B, S5/S5B, S6/S6B)
  plot v(VS4) v(VS4B)+1.5 v(VS5)+3.0 v(VS5B)+4.5 v(VS6)+6.0 v(VS6B)+7.5 title 'Fine Driver Outputs (Bits 4-6)' xlabel 'Time (s)' ylabel 'Voltage (V)'

  * Fine Complementary Outputs: Bits 7 - 9 (S7/S7B, S8/S8B, S9/S9B)
  plot v(VS7) v(VS7B)+1.5 v(VS8)+3.0 v(VS8B)+4.5 v(VS9)+6.0 v(VS9B)+7.5 title 'Fine Driver Outputs (Bits 7-9)' xlabel 'Time (s)' ylabel 'Voltage (V)'
.endc

**** end user architecture code
**.ends

* expanding   symbol:  decoder_top_10b.sym # of pins=40
** sym_path: /foss/designs/Chipalooza/Programmable-Instrumentation-Amplifier-IP/designs/libs/core_digital/decoder_top_10b/decoder_top_10b.sym
** sch_path: /foss/designs/Chipalooza/Programmable-Instrumentation-Amplifier-IP/designs/libs/core_digital/decoder_top_10b/decoder_top_10b.sch
.subckt decoder_top_10b D0 D3 Y0 Y1 Y2 Y3 VDD VSS Y4 Y5 Y6 Y7 Y8 Y9 Y10 Y11 Y12 Y13 Y14 Y15 D1 D2 D4 D7 D5 D6 D8 D9 S4 S4B S5 S5B
+ S6 S6B S7 S7B S8 S8B S9 S9B
*.ipin D0
*.ipin D1
*.ipin D2
*.ipin D3
*.ipin D4
*.ipin D5
*.ipin D6
*.ipin D7
*.ipin D8
*.ipin D9
*.opin Y0
*.opin Y1
*.opin Y2
*.opin Y3
*.opin Y4
*.opin Y5
*.opin Y6
*.opin Y7
*.opin Y8
*.opin Y9
*.opin Y10
*.opin Y11
*.opin Y12
*.opin Y13
*.opin Y14
*.opin Y15
*.opin S4
*.opin S4B
*.opin S5
*.opin S5B
*.opin S6
*.opin S6B
*.opin S7
*.opin S7B
*.opin S8
*.opin S8B
*.opin S9
*.opin S9B
*.iopin VDD
*.iopin VSS
x_coarse_dec D0 D3 Y0 Y1 Y2 Y3 VDD VSS Y4 Y5 Y6 Y7 Y8 Y9 Y10 Y11 Y12 Y13 Y14 Y15 D1 D2 dec4to16
x_fine_driver D4 D7 S4 S4B VDD VSS D5 D6 D8 D9 S5 S5B S6 S6B S7 S7B S8 S8B S9 S9B fine_driver_6b
.ends

* expanding   symbol:
*+  /foss/designs/Chipalooza/Programmable-Instrumentation-Amplifier-IP/designs/libs/core_digital/dec4to16/dec4to16.sym # of pins=22
** sym_path: /foss/designs/Chipalooza/Programmable-Instrumentation-Amplifier-IP/designs/libs/core_digital/dec4to16/dec4to16.sym
** sch_path: /foss/designs/Chipalooza/Programmable-Instrumentation-Amplifier-IP/designs/libs/core_digital/dec4to16/dec4to16.sch
.subckt dec4to16 A0 A3 Y0 Y1 Y2 Y3 VDD VSS Y4 Y5 Y6 Y7 Y8 Y9 Y10 Y11 Y12 Y13 Y14 Y15 A1 A2
*.ipin A0
*.ipin A1
*.ipin A2
*.ipin A3
*.iopin VDD
*.iopin VSS
*.opin Y0
*.opin Y1
*.opin Y2
*.opin Y3
*.opin Y4
*.opin Y5
*.opin Y6
*.opin Y7
*.opin Y8
*.opin Y9
*.opin Y10
*.opin Y11
*.opin Y12
*.opin Y13
*.opin Y14
*.opin Y15
x_dec_low A0 A1 P0 P1 P2 P3 VDD VSS dec2to4
x_dec_high A2 A3 Q0 Q1 Q2 Q3 VDD VSS dec2to4
x1 Y0 P0 Q0 VDD VSS sg13cmos5l_and2_1
x2 Y4 P0 Q1 VDD VSS sg13cmos5l_and2_1
x3 Y8 P0 Q2 VDD VSS sg13cmos5l_and2_1
x4 Y12 P0 Q3 VDD VSS sg13cmos5l_and2_1
x5 Y1 P1 Q0 VDD VSS sg13cmos5l_and2_1
x6 Y5 P1 Q1 VDD VSS sg13cmos5l_and2_1
x7 Y9 P1 Q2 VDD VSS sg13cmos5l_and2_1
x8 Y13 P1 Q3 VDD VSS sg13cmos5l_and2_1
x9 Y2 P2 Q0 VDD VSS sg13cmos5l_and2_1
x10 Y6 P2 Q1 VDD VSS sg13cmos5l_and2_1
x11 Y10 P2 Q2 VDD VSS sg13cmos5l_and2_1
x12 Y14 P2 Q3 VDD VSS sg13cmos5l_and2_1
x13 Y3 P3 Q0 VDD VSS sg13cmos5l_and2_1
x14 Y7 P3 Q1 VDD VSS sg13cmos5l_and2_1
x15 Y11 P3 Q2 VDD VSS sg13cmos5l_and2_1
x16 Y15 P3 Q3 VDD VSS sg13cmos5l_and2_1
.ends

* expanding   symbol:
*+  /foss/designs/Chipalooza/Programmable-Instrumentation-Amplifier-IP/designs/libs/core_digital/fine_driver_6b/fine_driver_6b.sym # of pins=20
** sym_path: /foss/designs/Chipalooza/Programmable-Instrumentation-Amplifier-IP/designs/libs/core_digital/fine_driver_6b/fine_driver_6b.sym
** sch_path: /foss/designs/Chipalooza/Programmable-Instrumentation-Amplifier-IP/designs/libs/core_digital/fine_driver_6b/fine_driver_6b.sch
.subckt fine_driver_6b D4 D7 S4 S4B VDD VSS D5 D6 D8 D9 S5 S5B S6 S6B S7 S7B S8 S8B S9 S9B
*.ipin D4
*.opin S4
*.opin S4B
*.iopin VDD
*.iopin VSS
*.ipin D5
*.opin S5
*.opin S5B
*.ipin D6
*.opin S6
*.opin S6B
*.ipin D7
*.opin S7
*.opin S7B
*.ipin D8
*.opin S8
*.opin S8B
*.ipin D9
*.opin S9
*.opin S9B
x1 S4 D4 VDD VSS sg13cmos5l_buf_1
x2 S4B D4 VDD VSS sg13cmos5l_inv_1
x3 S5 D5 VDD VSS sg13cmos5l_buf_1
x4 S5B D5 VDD VSS sg13cmos5l_inv_1
x5 S6 D6 VDD VSS sg13cmos5l_buf_1
x6 S6B D6 VDD VSS sg13cmos5l_inv_1
x7 S7 D7 VDD VSS sg13cmos5l_buf_1
x8 S7B D7 VDD VSS sg13cmos5l_inv_1
x9 S8 D8 VDD VSS sg13cmos5l_buf_1
x10 S8B D8 VDD VSS sg13cmos5l_inv_1
x11 S9 D9 VDD VSS sg13cmos5l_buf_1
x12 S9B D9 VDD VSS sg13cmos5l_inv_1
.ends

* expanding   symbol:
*+  /foss/designs/Chipalooza/Programmable-Instrumentation-Amplifier-IP/designs/libs/core_digital/dec2to4/dec2to4.sym # of pins=8
** sym_path: /foss/designs/Chipalooza/Programmable-Instrumentation-Amplifier-IP/designs/libs/core_digital/dec2to4/dec2to4.sym
** sch_path: /foss/designs/Chipalooza/Programmable-Instrumentation-Amplifier-IP/designs/libs/core_digital/dec2to4/dec2to4.sch
.subckt dec2to4 A0 A1 Y0 Y1 Y2 Y3 VDD VSS
*.ipin A0
*.ipin A1
*.opin Y0
*.opin Y1
*.opin Y2
*.opin Y3
*.iopin VDD
*.iopin VSS
x1 net2 A0 VDD VSS sg13cmos5l_inv_1
x2 net1 A1 VDD VSS sg13cmos5l_inv_1
x11 Y0 net2 net1 VDD VSS sg13cmos5l_and2_1
x3 Y1 A0 net1 VDD VSS sg13cmos5l_and2_1
x4 Y2 A1 net2 VDD VSS sg13cmos5l_and2_1
x5 Y3 A1 A0 VDD VSS sg13cmos5l_and2_1
.ends

.end
