** sch_path: /foss/designs/chipalooza/Programmable-Instrumentation-Amplifier-IP/xschem/fine_gain/fine_gain.sch
**.subckt fine_gain VIN3 BIAS VOUT VCM AVDD AVSS D4 D5 D6 D7 D8 D9
*.ipin VIN3
*.ipin VCM
*.ipin D4
*.ipin D5
*.ipin D6
*.ipin D7
*.ipin D8
*.ipin D9
*.ipin BIAS
*.iopin VOUT
*.ipin AVDD
*.ipin AVSS
XR1 VIN3 net1 sub! rhigh w={W_RES} l={L_R} m=1 b=0 mm_ok=1
XM1 net3 D4 net4 net3 sg13_lv_nmos w={W_TG_N} l={L_TG_N} ng={NG_TG_N} m=1 mm_ok=1
XM2 VCM D4_inv net3 VCM sg13_lv_pmos w={W_TG_P} l={L_TG_P} ng={NG_TG_P} m=1 mm_ok=1
XR2 net1 net2 sub! rhigh w={W_RES} l={L_R} m=1 b=0 mm_ok=1
XR8 net1 net3 sub! rhigh w={W_RES} l={L_2R} m=1 b=0 mm_ok=1
XR9 net2 net5 sub! rhigh w={W_RES} l={L_2R} m=1 b=0 mm_ok=1
XR15 net4 VOUT sub! rhigh w={W_RES} l={L_R} m=1 b=0 mm_ok=1
XM3 net5 D5 net4 net5 sg13_lv_nmos w={W_TG_N} l={L_TG_N} ng={NG_TG_N} m=1 mm_ok=1
XM4 VCM D5_inv net5 VCM sg13_lv_pmos w={W_TG_P} l={L_TG_P} ng={NG_TG_P} m=1 mm_ok=1
XR3 net2 net6 sub! rhigh w={W_RES} l={L_R} m=1 b=0 mm_ok=1
XR4 net6 net8 sub! rhigh w={W_RES} l={L_R} m=1 b=0 mm_ok=1
XR5 net8 net10 sub! rhigh w={W_RES} l={L_R} m=1 b=0 mm_ok=1
XR6 net10 net12 sub! rhigh w={W_RES} l={L_R} m=1 b=0 mm_ok=1
XR7 net12 net14 sub! rhigh w={W_RES} l={L_R} m=1 b=0 mm_ok=1
XR10 net6 net7 sub! rhigh w={W_RES} l={L_2R} m=1 b=0 mm_ok=1
XM5 net7 D6 net4 net7 sg13_lv_nmos w={W_TG_N} l={L_TG_N} ng={NG_TG_N} m=1 mm_ok=1
XM6 VCM D6_inv net7 VCM sg13_lv_pmos w={W_TG_P} l={L_TG_P} ng={NG_TG_P} m=1 mm_ok=1
XR11 net8 net9 sub! rhigh w={W_RES} l={L_2R} m=1 b=0 mm_ok=1
XM7 net9 D7 net4 net9 sg13_lv_nmos w={W_TG_N} l={L_TG_N} ng={NG_TG_N} m=1 mm_ok=1
XM8 VCM D7_inv net9 VCM sg13_lv_pmos w={W_TG_P} l={L_TG_P} ng={NG_TG_P} m=1 mm_ok=1
XR12 net10 net11 sub! rhigh w={W_RES} l={L_2R} m=1 b=0 mm_ok=1
XM9 net11 D8 net4 net11 sg13_lv_nmos w={W_TG_N} l={L_TG_N} ng={NG_TG_N} m=1 mm_ok=1
XM10 VCM D8_inv net11 VCM sg13_lv_pmos w={W_TG_P} l={L_TG_P} ng={NG_TG_P} m=1 mm_ok=1
XR13 net12 net13 sub! rhigh w={W_RES} l={L_2R} m=1 b=0 mm_ok=1
XM11 net13 D9 net4 net13 sg13_lv_nmos w={W_TG_N} l={L_TG_N} ng={NG_TG_N} m=1 mm_ok=1
XM12 VCM D9_inv net13 VCM sg13_lv_pmos w={W_TG_P} l={L_TG_P} ng={NG_TG_P} m=1 mm_ok=1
XR14 net14 VCM sub! rhigh w={W_RES} l={L_2R} m=1 b=0 mm_ok=1
XM13 D4_inv D4 AVSS AVSS sg13_lv_nmos w={W_INV_N} l={L_INV_N} ng={NG_INV_N} m=1 mm_ok=1
XM14 D4_inv D4 AVDD AVDD sg13_lv_pmos w={W_INV_P} l={L_INV_P} ng={NG_INV_P} m=1 mm_ok=1
XM15 D5_inv D5 AVSS AVSS sg13_lv_nmos w={W_INV_N} l={L_INV_N} ng={NG_INV_N} m=1 mm_ok=1
XM16 D5_inv D5 AVDD AVDD sg13_lv_pmos w={W_INV_P} l={L_INV_P} ng={NG_INV_P} m=1 mm_ok=1
XM17 D6_inv D6 AVSS AVSS sg13_lv_nmos w={W_INV_N} l={L_INV_N} ng={NG_INV_N} m=1 mm_ok=1
XM18 D6_inv D6 AVDD AVDD sg13_lv_pmos w={W_INV_P} l={L_INV_P} ng={NG_INV_P} m=1 mm_ok=1
XM19 D7_inv D7 AVSS AVSS sg13_lv_nmos w={W_INV_N} l={L_INV_N} ng={NG_INV_N} m=1 mm_ok=1
XM20 D7_inv D7 AVDD AVDD sg13_lv_pmos w={W_INV_P} l={L_INV_P} ng={NG_INV_P} m=1 mm_ok=1
XM21 D8_inv D8 AVSS AVSS sg13_lv_nmos w={W_INV_N} l={L_INV_N} ng={NG_INV_N} m=1 mm_ok=1
XM22 D8_inv D8 AVDD AVDD sg13_lv_pmos w={W_INV_P} l={L_INV_P} ng={NG_INV_P} m=1 mm_ok=1
XM23 D9_inv D9 AVSS AVSS sg13_lv_nmos w={W_INV_N} l={L_INV_N} ng={NG_INV_N} m=1 mm_ok=1
XM24 D9_inv D9 AVDD AVDD sg13_lv_pmos w={W_INV_P} l={L_INV_P} ng={NG_INV_P} m=1 mm_ok=1
x1 AVSS BIAS AVDD net4 VCM VOUT ota_cmos5l
**.ends

* expanding   symbol:  /foss/designs/chipalooza/Programmable-Instrumentation-Amplifier-IP/xschem/ota_cmos5l/ota_cmos5l.sym # of
*+ pins=6
** sym_path: /foss/designs/chipalooza/Programmable-Instrumentation-Amplifier-IP/xschem/ota_cmos5l/ota_cmos5l.sym
** sch_path: /foss/designs/chipalooza/Programmable-Instrumentation-Amplifier-IP/xschem/ota_cmos5l/ota_cmos5l.sch
.subckt ota_cmos5l VSS IBIAS VDD VINN VINP VOUT
*.iopin IBIAS
*.iopin VDD
*.iopin VSS
*.iopin VOUT
*.iopin VINP
*.iopin VINN
XM6 net1 net1 VDD VDD sg13_lv_pmos w={wbias} l={lbias} ng=1 m={m6} mm_ok=1
XM7 net5 net1 VDD VDD sg13_lv_pmos w={wbias} l={lbias} ng=1 m={m7} mm_ok=1
XM8 net6 net1 VDD VDD sg13_lv_pmos w={wbias} l={lbias} ng=1 m={m8} mm_ok=1
XM1 net7 VINN net2 VDD sg13_lv_pmos w={winpair} l={linpair} ng=1 m=1 mm_ok=1
XM2 net8 VINP net2 VDD sg13_lv_pmos w={winpair} l={linpair} ng=1 m=1 mm_ok=1
XM3 net3 net3 VSS VSS sg13_lv_nmos w={wload} l={lload} ng=1 m=1 mm_ok=1
XM4 net4 net3 VSS VSS sg13_lv_nmos w={wload} l={lload} ng=1 m=1 mm_ok=1
XM5 net9 net4 VSS VSS sg13_lv_nmos w={wcs} l={lcs} ng=1 m=1 mm_ok=1
C1 net10 net9 {Cc}
XR1 net4 net10 sub! rhigh w=0.5e-6 l=1.95e-6 m=1 b=0 mm_ok=1
VIBIAS net1 IBIAS 0
.save i(vibias)
VID7 net5 net2 0
.save i(vid7)
VID8 net6 VOUT 0
.save i(vid8)
.save v(vinp)
.save v(vinn)
.save v(vout)
VID1 net7 net3 0
.save i(vid1)
VID2 net8 net4 0
.save i(vid2)
VID5 VOUT net9 0
.save i(vid5)
.ends

.end
