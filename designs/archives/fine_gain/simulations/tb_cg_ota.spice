** sch_path: /foss/designs/chipalooza/Programmable-Instrumentation-Amplifier-IP/xschem/coarse_gain/tb/tb_cg_ota/tb_cg_ota.sch
**.subckt tb_cg_ota
I0 VDD I_B {ib}
V2 VDD 0 {vdd}
V6 VINP2 VSS {vicm}
C3 OUT2 VSS {cl}
*  x1 -  loopgainprobe  IS MISSING !!!!
V3 VSS 0 0
*  x2 -  cg_ota  IS MISSING !!!!
**** begin user architecture code

.param temp=27
.param cl=2p
.param ib=1u
.param vdd=1.2
.param vicm=vdd/2
.param vid=0

.subckt loopgainprobe a b
Ii 0 x DC 0 AC 0
Vi x a DC 0 AC 1
Vnodebuffer b x 0
.ends loopgainprobe

.func tian_loop() {1/(1/(2*(ac1.i(v.x999.Vi)*ac2.v(x999.x)-ac1.v(x999.x)*ac2.i(v.x999.Vi))+ac1.v(x999.x)+ac2.i(v.x999.Vi))-1)}

**** end user architecture code
**.ends
.GLOBAL VDD
.end
