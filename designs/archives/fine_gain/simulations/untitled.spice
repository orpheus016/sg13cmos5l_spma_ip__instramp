** sch_path: /foss/designs/chipalooza/Programmable-Instrumentation-Amplifier-IP/xschem/fine_gain/untitled.sch
**.subckt untitled IN OUT Vcon Vcon_inv
*.ipin IN
*.opin OUT
*.ipin Vcon
*.ipin Vcon_inv
XM1 OUT Vcon IN IN sg13_lv_nmos w={W_INV_N} l={L_INV_N} ng={NG_INV_N} m=1 mm_ok=1
XM2 OUT Vcon_inv IN OUT sg13_lv_pmos w={W_INV_P} l={L_INV_P} ng={NG_INV_P} m=1 mm_ok=1
**.ends
.end
