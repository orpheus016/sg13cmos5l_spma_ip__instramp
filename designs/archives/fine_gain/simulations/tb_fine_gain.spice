** sch_path: /foss/designs/chipalooza/Programmable-Instrumentation-Amplifier-IP/xschem/fine_gain/tb/tb_fine_gain.sch
**.subckt tb_fine_gain
I0 VDD I_B {ib}
V2 VDD 0 {vdd}
V3 VSS 0 0
V1 VCM VSS {vicm}
C1 OUT2 VSS {cl}
VS1 D4 VSS 0
VS2 D5 VSS 0
VS3 D6 VSS 0
VS4 D7 VSS 0
VS5 D8 VSS 0
VS6 D9 VSS 0
V4 IN2 VSS DC 0.6 AC 1
x1 IN2 I_B OUT2 VCM VDD VSS D4 D5 D6 D7 D8 D9 fine_gain
**** begin user architecture code

.param temp=27
.param cl=2p
.param ib=1u
.param vdd=1.2
.param vicm=vdd/2
.param vid=0

.lib /foss/pdks/ihp-sg13cmos5l/libs.tech/ngspice/models/cornerMOSlv.lib mos_tt
.lib /foss/pdks/ihp-sg13cmos5l/libs.tech/ngspice/models/cornerMOShv.lib mos_tt
.lib /foss/pdks/ihp-sg13cmos5l/libs.tech/ngspice/models/cornerRES.lib res_typ
.lib /foss/pdks/ihp-sg13cmos5l/libs.tech/ngspice/models/cornerDIO.lib dio_tt
.lib /foss/pdks/ihp-sg13cmos5l/libs.tech/ngspice/models/cornerCAP.lib cap_typ
.lib /foss/pdks/ihp-sg13cmos5l/libs.tech/ngspice/models/cornerMOSCAP.lib moscap_tt

.control
* ==============================================================================
* COARSE-GAIN NETWORK (PGA) 16-TAP AUTOMATED TELEMETRY & ACCURACY CHARACTERIZATION
* Topology  : Inverting Closed-Loop Logarithmic Resistor Ladder (R to 649R)
* Technology: IHP SG13CMOS5L (130nm BiCMOS)
* ==============================================================================

destroy all
save all
shell mkdir -p result
shell rm -f ./result/tb_cg_network_summary.txt

echo "==================================================================================================================================================" >> ./result/tb_cg_network_summary.txt
echo " Tap   Code   Target(dB)   Meas(dB)   Err(dB)    Err(Step)   Acc_FS(%)    -3dB BW(Hz)    Vos_out(mV)   V_vg_err(mV)   P_dc(uW) " >> ./result/tb_cg_network_summary.txt
echo "==================================================================================================================================================" >> ./result/tb_cg_network_summary.txt

echo "=================================================================================================================================================="
echo " STARTING AUTOMATED 16-TAP PGA AC & DC TELEMETRY CHARACTERIZATION (DB-BASED ERROR)                                                                "
echo "=================================================================================================================================================="

* ------------------------------------------------------------------------------
* STEP 0: DC OFFSET PRE-CALIBRATION
* ------------------------------------------------------------------------------
alter @vs1[dc]  = 1.2
alter @vs2[dc]  = 0
alter @vs3[dc]  = 0
alter @vs4[dc]  = 0
alter @vs5[dc]  = 0
alter @vs6[dc]  = 0
alter @vs7[dc]  = 0
alter @vs8[dc]  = 0
alter @vs9[dc]  = 0
alter @vs10[dc] = 0
alter @vs11[dc] = 0
alter @vs12[dc] = 0
alter @vs13[dc] = 0
alter @vs14[dc] = 0
alter @vs15[dc] = 0
alter @vs16[dc] = 0

op
let v_vg_nominal = v(x1.net17)
echo " Calibrated Input DC Bias to Virtual Ground: " $&v_vg_nominal " V"

alter @v4[dc] = $&v_vg_nominal

set appendwrite

* ------------------------------------------------------------------------------
* STEP 1: SEQUENTIAL 16-TAP EVALUATION LOOP
* ------------------------------------------------------------------------------
foreach tap 0 1 2 3 4 5 6 7 8 9 10 11 12 13 14 15

  * Reset all switch voltages
  alter @vs1[dc]  = 0
  alter @vs2[dc]  = 0
  alter @vs3[dc]  = 0
  alter @vs4[dc]  = 0
  alter @vs5[dc]  = 0
  alter @vs6[dc]  = 0
  alter @vs7[dc]  = 0
  alter @vs8[dc]  = 0
  alter @vs9[dc]  = 0
  alter @vs10[dc] = 0
  alter @vs11[dc] = 0
  alter @vs12[dc] = 0
  alter @vs13[dc] = 0
  alter @vs14[dc] = 0
  alter @vs15[dc] = 0
  alter @vs16[dc] = 0

  * Assert active tap
  if ($tap = 0)
    alter @vs1[dc] = 1.2
  end
  if ($tap = 1)
    alter @vs2[dc] = 1.2
  end
  if ($tap = 2)
    alter @vs3[dc] = 1.2
  end
  if ($tap = 3)
    alter @vs4[dc] = 1.2
  end
  if ($tap = 4)
    alter @vs5[dc] = 1.2
  end
  if ($tap = 5)
    alter @vs6[dc] = 1.2
  end
  if ($tap = 6)
    alter @vs7[dc] = 1.2
  end
  if ($tap = 7)
    alter @vs8[dc] = 1.2
  end
  if ($tap = 8)
    alter @vs9[dc] = 1.2
  end
  if ($tap = 9)
    alter @vs10[dc] = 1.2
  end
  if ($tap = 10)
    alter @vs11[dc] = 1.2
  end
  if ($tap = 11)
    alter @vs12[dc] = 1.2
  end
  if ($tap = 12)
    alter @vs13[dc] = 1.2
  end
  if ($tap = 13)
    alter @vs14[dc] = 1.2
  end
  if ($tap = 14)
    alter @vs15[dc] = 1.2
  end
  if ($tap = 15)
    alter @vs16[dc] = 1.2
  end

  * Run DC Operating Point
  op
  let cur_vos_mv  = (v(out2) - v(vcm)) * 1e3
  let cur_vvg_mv  = (v(x1.net17) - v(vcm)) * 1e3
  let cur_pdc_uw  = -i(v2) * 1.2 * 1e6

  set s_vos = "$&cur_vos_mv"
  set s_vvg = "$&cur_vvg_mv"
  set s_pdc = "$&cur_pdc_uw"

  * Run AC Analysis
  ac dec 30 10 100MEG

  let gain_db = db(v(out2))
  let ph_deg  = cph(v(out2)) * 180 / pi

  * Measure midband gain at 1 kHz flatband
  meas ac g_meas_db find gain_db at=1k

  * Measure -3 dB bandwidth
  let target_3db = g_meas_db - 3
  meas ac f_3db when gain_db=target_3db

  * Calculate theoretical gain and dB-based error metrics
  let ideal_db   = $tap * 3.75
  let err_db     = g_meas_db - ideal_db
  let err_step   = err_db / 3.75
  let acc_fs     = 100 - (abs(err_db) / 56.25 * 100)

  write ./result/tb_cg_network_all_taps.raw gain_db ph_deg

  * Telemetry Output
  echo " S$tap | Target: $&ideal_db dB | Meas: $&g_meas_db dB | Err: $&err_db dB ($&err_step Step) | Acc_FS: $&acc_fs % | -3dB BW: $&f_3db Hz | Vos: $s_vos mV"

  echo " S$tap  |  $tap  |  $&ideal_db  |  $&g_meas_db  |  $&err_db  |  $&err_step  |  $&acc_fs  |  $&f_3db  |  $s_vos  |  $s_vvg  |  $s_pdc" >> ./result/tb_cg_network_summary.txt

end

unset appendwrite
echo "=================================================================================================================================================="
echo " CHARACTERIZATION COMPLETED! Full telemetry log is exported to:                                                                                   "
echo " ./result/tb_cg_network_summary.txt                                                                                                              "
echo "=================================================================================================================================================="
.endc

.include $PDK_ROOT/$PDK/libs.ref/sg13cmos5l_stdcell/spice/sg13cmos5l_stdcell.spice

**** end user architecture code
**.ends

* expanding   symbol:  fine_gain.sym # of pins=12
** sym_path: /foss/designs/chipalooza/Programmable-Instrumentation-Amplifier-IP/xschem/fine_gain/fine_gain.sym
** sch_path: /foss/designs/chipalooza/Programmable-Instrumentation-Amplifier-IP/xschem/fine_gain/fine_gain.sch
.subckt fine_gain VIN3 BIAS VOUT VCM AVDD AVSS D4 D5 D6 D7 D8 D9
*.ipin VIN3
*.ipin VCM
*.ipin D4
*.ipin D5
*.ipin D6
*.ipin D7
*.ipin D8
*.ipin D9
*.ipin BIAS
*.iopin VOUT
*.ipin AVDD
*.ipin AVSS
XR1 VIN3 net1 sub! rhigh w={W_RES} l={L_R} m=1 b=0 mm_ok=1
XM1 net3 D4 net4 net3 sg13_lv_nmos w={W_TG_N} l={L_TG_N} ng={NG_TG_N} m=1 mm_ok=1
XM2 VCM D4_inv net3 VCM sg13_lv_pmos w={W_TG_P} l={L_TG_P} ng={NG_TG_P} m=1 mm_ok=1
XR2 net1 net2 sub! rhigh w={W_RES} l={L_R} m=1 b=0 mm_ok=1
XR8 net1 net3 sub! rhigh w={W_RES} l={L_2R} m=1 b=0 mm_ok=1
XR9 net2 net5 sub! rhigh w={W_RES} l={L_2R} m=1 b=0 mm_ok=1
XR15 net4 VOUT sub! rhigh w={W_RES} l={L_R} m=1 b=0 mm_ok=1
XM3 net5 D5 net4 net5 sg13_lv_nmos w={W_TG_N} l={L_TG_N} ng={NG_TG_N} m=1 mm_ok=1
XM4 VCM D5_inv net5 VCM sg13_lv_pmos w={W_TG_P} l={L_TG_P} ng={NG_TG_P} m=1 mm_ok=1
XR3 net2 net6 sub! rhigh w={W_RES} l={L_R} m=1 b=0 mm_ok=1
XR4 net6 net8 sub! rhigh w={W_RES} l={L_R} m=1 b=0 mm_ok=1
XR5 net8 net10 sub! rhigh w={W_RES} l={L_R} m=1 b=0 mm_ok=1
XR6 net10 net12 sub! rhigh w={W_RES} l={L_R} m=1 b=0 mm_ok=1
XR7 net12 net14 sub! rhigh w={W_RES} l={L_R} m=1 b=0 mm_ok=1
XR10 net6 net7 sub! rhigh w={W_RES} l={L_2R} m=1 b=0 mm_ok=1
XM5 net7 D6 net4 net7 sg13_lv_nmos w={W_TG_N} l={L_TG_N} ng={NG_TG_N} m=1 mm_ok=1
XM6 VCM D6_inv net7 VCM sg13_lv_pmos w={W_TG_P} l={L_TG_P} ng={NG_TG_P} m=1 mm_ok=1
XR11 net8 net9 sub! rhigh w={W_RES} l={L_2R} m=1 b=0 mm_ok=1
XM7 net9 D7 net4 net9 sg13_lv_nmos w={W_TG_N} l={L_TG_N} ng={NG_TG_N} m=1 mm_ok=1
XM8 VCM D7_inv net9 VCM sg13_lv_pmos w={W_TG_P} l={L_TG_P} ng={NG_TG_P} m=1 mm_ok=1
XR12 net10 net11 sub! rhigh w={W_RES} l={L_2R} m=1 b=0 mm_ok=1
XM9 net11 D8 net4 net11 sg13_lv_nmos w={W_TG_N} l={L_TG_N} ng={NG_TG_N} m=1 mm_ok=1
XM10 VCM D8_inv net11 VCM sg13_lv_pmos w={W_TG_P} l={L_TG_P} ng={NG_TG_P} m=1 mm_ok=1
XR13 net12 net13 sub! rhigh w={W_RES} l={L_2R} m=1 b=0 mm_ok=1
XM11 net13 D9 net4 net13 sg13_lv_nmos w={W_TG_N} l={L_TG_N} ng={NG_TG_N} m=1 mm_ok=1
XM12 VCM D9_inv net13 VCM sg13_lv_pmos w={W_TG_P} l={L_TG_P} ng={NG_TG_P} m=1 mm_ok=1
XR14 net14 VCM sub! rhigh w={W_RES} l={L_2R} m=1 b=0 mm_ok=1
XM13 D4_inv D4 AVSS AVSS sg13_lv_nmos w={W_INV_N} l={L_INV_N} ng={NG_INV_N} m=1 mm_ok=1
XM14 D4_inv D4 AVDD AVDD sg13_lv_pmos w={W_INV_P} l={L_INV_P} ng={NG_INV_P} m=1 mm_ok=1
XM15 D5_inv D5 AVSS AVSS sg13_lv_nmos w={W_INV_N} l={L_INV_N} ng={NG_INV_N} m=1 mm_ok=1
XM16 D5_inv D5 AVDD AVDD sg13_lv_pmos w={W_INV_P} l={L_INV_P} ng={NG_INV_P} m=1 mm_ok=1
XM17 D6_inv D6 AVSS AVSS sg13_lv_nmos w={W_INV_N} l={L_INV_N} ng={NG_INV_N} m=1 mm_ok=1
XM18 D6_inv D6 AVDD AVDD sg13_lv_pmos w={W_INV_P} l={L_INV_P} ng={NG_INV_P} m=1 mm_ok=1
XM19 D7_inv D7 AVSS AVSS sg13_lv_nmos w={W_INV_N} l={L_INV_N} ng={NG_INV_N} m=1 mm_ok=1
XM20 D7_inv D7 AVDD AVDD sg13_lv_pmos w={W_INV_P} l={L_INV_P} ng={NG_INV_P} m=1 mm_ok=1
XM21 D8_inv D8 AVSS AVSS sg13_lv_nmos w={W_INV_N} l={L_INV_N} ng={NG_INV_N} m=1 mm_ok=1
XM22 D8_inv D8 AVDD AVDD sg13_lv_pmos w={W_INV_P} l={L_INV_P} ng={NG_INV_P} m=1 mm_ok=1
XM23 D9_inv D9 AVSS AVSS sg13_lv_nmos w={W_INV_N} l={L_INV_N} ng={NG_INV_N} m=1 mm_ok=1
XM24 D9_inv D9 AVDD AVDD sg13_lv_pmos w={W_INV_P} l={L_INV_P} ng={NG_INV_P} m=1 mm_ok=1
x1 AVSS BIAS AVDD net4 VCM VOUT ota_cmos5l
.ends

* expanding   symbol:  /foss/designs/chipalooza/Programmable-Instrumentation-Amplifier-IP/xschem/ota_cmos5l/ota_cmos5l.sym # of
*+ pins=6
** sym_path: /foss/designs/chipalooza/Programmable-Instrumentation-Amplifier-IP/xschem/ota_cmos5l/ota_cmos5l.sym
** sch_path: /foss/designs/chipalooza/Programmable-Instrumentation-Amplifier-IP/xschem/ota_cmos5l/ota_cmos5l.sch
.subckt ota_cmos5l VSS IBIAS VDD VINN VINP VOUT
*.iopin IBIAS
*.iopin VDD
*.iopin VSS
*.iopin VOUT
*.iopin VINP
*.iopin VINN
XM6 net1 net1 VDD VDD sg13_lv_pmos w={wbias} l={lbias} ng=1 m={m6} mm_ok=1
XM7 net5 net1 VDD VDD sg13_lv_pmos w={wbias} l={lbias} ng=1 m={m7} mm_ok=1
XM8 net6 net1 VDD VDD sg13_lv_pmos w={wbias} l={lbias} ng=1 m={m8} mm_ok=1
XM1 net7 VINN net2 VDD sg13_lv_pmos w={winpair} l={linpair} ng=1 m=1 mm_ok=1
XM2 net8 VINP net2 VDD sg13_lv_pmos w={winpair} l={linpair} ng=1 m=1 mm_ok=1
XM3 net3 net3 VSS VSS sg13_lv_nmos w={wload} l={lload} ng=1 m=1 mm_ok=1
XM4 net4 net3 VSS VSS sg13_lv_nmos w={wload} l={lload} ng=1 m=1 mm_ok=1
XM5 net9 net4 VSS VSS sg13_lv_nmos w={wcs} l={lcs} ng=1 m=1 mm_ok=1
C1 net10 net9 {Cc}
XR1 net4 net10 sub! rhigh w=0.5e-6 l=1.95e-6 m=1 b=0 mm_ok=1
VIBIAS net1 IBIAS 0
.save i(vibias)
VID7 net5 net2 0
.save i(vid7)
VID8 net6 VOUT 0
.save i(vid8)
.save v(vinp)
.save v(vinn)
.save v(vout)
VID1 net7 net3 0
.save i(vid1)
VID2 net8 net4 0
.save i(vid2)
VID5 VOUT net9 0
.save i(vid5)
.ends

.GLOBAL VDD
.end
