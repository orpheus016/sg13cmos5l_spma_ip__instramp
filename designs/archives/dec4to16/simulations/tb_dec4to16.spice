** sch_path: /foss/designs/Chipalooza/Programmable-Instrumentation-Amplifier-IP/designs/libs/core_digital/dec4to16/tb_dec4to16.sch
**.subckt tb_dec4to16
x1 VA0 VA3 VY0 VY1 VY2 VY3 net1 0 VY4 VY5 VY6 VY7 VY8 VY9 VY10 VY11 VY12 VY13 VY14 VY15 VA1 VA2 dec4to16
V1 VA0 0 PULSE(0 1.2 10n 100p 100p 10n 20n)
V2 VA1 0 PULSE(0 1.2 20n 100p 100p 20n 40n)
V3 VA2 0 PULSE(0 1.2 40n 100p 100p 40n 80n)
V4 VA3 0 PULSE(0 1.2 80n 100p 100p 80n 160n)
VDD net1 0 1.2
C15 VY15 0 10f
C14 VY14 0 10f
C13 VY13 0 10f
C12 VY12 0 10f
C11 VY11 0 10f
C10 VY10 0 10f
C9 VY9 0 10f
C8 VY8 0 10f
C7 VY7 0 10f
C0 VY0 0 10f
C1 VY1 0 10f
C2 VY2 0 10f
C3 VY3 0 10f
C4 VY4 0 10f
C5 VY5 0 10f
C6 VY6 0 10f
**** begin user architecture code

.lib cornerMOSlv.lib mos_tt
.include /foss/pdks/ihp-sg13cmos5l/libs.ref/sg13cmos5l_stdcell/spice/sg13cmos5l_stdcell.spice

.control
  tran 100p 160n
  write tb_dec4to16.raw

  * ==========================================
  * AUTOMATED TRUTH TABLE VOLTAGE MEASUREMENTS
  * (Each state is sampled at its mid-window)
  * ==========================================
  meas tran v_y0_0000  find v(VY0)  at=5n
  meas tran v_y1_0001  find v(VY1)  at=15n
  meas tran v_y2_0010  find v(VY2)  at=25n
  meas tran v_y3_0011  find v(VY3)  at=35n
  meas tran v_y4_0100  find v(VY4)  at=45n
  meas tran v_y5_0101  find v(VY5)  at=55n
  meas tran v_y6_0110  find v(VY6)  at=65n
  meas tran v_y7_0111  find v(VY7)  at=75n
  meas tran v_y8_1000  find v(VY8)  at=85n
  meas tran v_y9_1001  find v(VY9)  at=95n
  meas tran v_y10_1010 find v(VY10) at=105n
  meas tran v_y11_1011 find v(VY11) at=115n
  meas tran v_y12_1100 find v(VY12) at=125n
  meas tran v_y13_1101 find v(VY13) at=135n
  meas tran v_y14_1110 find v(VY14) at=145n
  meas tran v_y15_1111 find v(VY15) at=155n

  * ==========================================
  * MULTI-TRACE OFFSET PLOTS
  * ==========================================
  * 1. 4-bit Binary Input Code (A0..A3)
  plot v(VA0) v(VA1)+1.5 v(VA2)+3.0 v(VA3)+4.5 title 'Decoder Inputs (A0, A1, A2, A3)' xlabel 'Time (s)' ylabel 'Voltage (V)'

  * 2. Lower 8 Decoded Channels (Y0..Y7)
  plot v(VY0) v(VY1)+1.5 v(VY2)+3.0 v(VY3)+4.5 v(VY4)+6.0 v(VY5)+7.5 v(VY6)+9.0 v(VY7)+10.5 title 'Decoded Outputs (Y0..Y7)' xlabel 'Time (s)' ylabel 'Voltage (V)'

  * 3. Upper 8 Decoded Channels (Y8..Y15)
  plot v(VY8) v(VY9)+1.5 v(VY10)+3.0 v(VY11)+4.5 v(VY12)+6.0 v(VY13)+7.5 v(VY14)+9.0 v(VY15)+10.5 title 'Decoded Outputs (Y8..Y15)' xlabel 'Time (s)' ylabel 'Voltage (V)'
.endc

**** end user architecture code
**.ends

* expanding   symbol:  dec4to16.sym # of pins=22
** sym_path: /foss/designs/Chipalooza/Programmable-Instrumentation-Amplifier-IP/designs/libs/core_digital/dec4to16/dec4to16.sym
** sch_path: /foss/designs/Chipalooza/Programmable-Instrumentation-Amplifier-IP/designs/libs/core_digital/dec4to16/dec4to16.sch
.subckt dec4to16 A0 A3 Y0 Y1 Y2 Y3 VDD VSS Y4 Y5 Y6 Y7 Y8 Y9 Y10 Y11 Y12 Y13 Y14 Y15 A1 A2
*.ipin A0
*.ipin A1
*.ipin A2
*.ipin A3
*.iopin VDD
*.iopin VSS
*.opin Y0
*.opin Y1
*.opin Y2
*.opin Y3
*.opin Y4
*.opin Y5
*.opin Y6
*.opin Y7
*.opin Y8
*.opin Y9
*.opin Y10
*.opin Y11
*.opin Y12
*.opin Y13
*.opin Y14
*.opin Y15
x_dec_low A0 A1 P0 P1 P2 P3 VDD VSS dec2to4
x_dec_high A2 A3 Q0 Q1 Q2 Q3 VDD VSS dec2to4
x1 Y0 P0 Q0 VDD VSS sg13cmos5l_and2_1
x2 Y4 P0 Q1 VDD VSS sg13cmos5l_and2_1
x3 Y8 P0 Q2 VDD VSS sg13cmos5l_and2_1
x4 Y12 P0 Q3 VDD VSS sg13cmos5l_and2_1
x5 Y1 P1 Q0 VDD VSS sg13cmos5l_and2_1
x6 Y5 P1 Q1 VDD VSS sg13cmos5l_and2_1
x7 Y9 P1 Q2 VDD VSS sg13cmos5l_and2_1
x8 Y13 P1 Q3 VDD VSS sg13cmos5l_and2_1
x9 Y2 P2 Q0 VDD VSS sg13cmos5l_and2_1
x10 Y6 P2 Q1 VDD VSS sg13cmos5l_and2_1
x11 Y10 P2 Q2 VDD VSS sg13cmos5l_and2_1
x12 Y14 P2 Q3 VDD VSS sg13cmos5l_and2_1
x13 Y3 P3 Q0 VDD VSS sg13cmos5l_and2_1
x14 Y7 P3 Q1 VDD VSS sg13cmos5l_and2_1
x15 Y11 P3 Q2 VDD VSS sg13cmos5l_and2_1
x16 Y15 P3 Q3 VDD VSS sg13cmos5l_and2_1
.ends

* expanding   symbol:
*+  /foss/designs/Chipalooza/Programmable-Instrumentation-Amplifier-IP/designs/libs/core_digital/dec2to4/dec2to4.sym # of pins=8
** sym_path: /foss/designs/Chipalooza/Programmable-Instrumentation-Amplifier-IP/designs/libs/core_digital/dec2to4/dec2to4.sym
** sch_path: /foss/designs/Chipalooza/Programmable-Instrumentation-Amplifier-IP/designs/libs/core_digital/dec2to4/dec2to4.sch
.subckt dec2to4 A0 A1 Y0 Y1 Y2 Y3 VDD VSS
*.ipin A0
*.ipin A1
*.opin Y0
*.opin Y1
*.opin Y2
*.opin Y3
*.iopin VDD
*.iopin VSS
x1 net2 A0 VDD VSS sg13cmos5l_inv_1
x2 net1 A1 VDD VSS sg13cmos5l_inv_1
x11 Y0 net2 net1 VDD VSS sg13cmos5l_and2_1
x3 Y1 A0 net1 VDD VSS sg13cmos5l_and2_1
x4 Y2 A1 net2 VDD VSS sg13cmos5l_and2_1
x5 Y3 A1 A0 VDD VSS sg13cmos5l_and2_1
.ends

.end
