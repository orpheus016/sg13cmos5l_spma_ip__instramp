* Extracted by KLayout with SG13CMOS5L LVS runset on : 03/11/2026 10:10

.SUBCKT gain_stage AVDD AVSS IBIAS VCM VIN VOUT s[0] s[1] s[2] s[3] s[4]
X$1 AVDD AVSS s[0] \$4 s[1] s[2] sg13cmos5l_nor3_1
X$2 AVSS VOUT IBIAS VCM VIN AVDD s[0] s[3] \$6 s[1] s[4] s[2] gain_network
X$3 AVDD AVSS \$6 \$5 \$4 sg13cmos5l_and2_1
X$4 AVDD AVSS \$5 s[3] s[4] sg13cmos5l_nor2_1
.ENDS gain_stage

.SUBCKT gain_network AVSS \$6 \$8 \$10 \$14 AVDD \$24 \$25 \$29 \$30 \$33 \$68
X$1 AVSS \$8 \$6 AVDD \$10 \$15 gain_ota
X$2 \$14 \$15 AVSS rhigh$4
X$3 \$6 \$75 AVSS rhigh$2
X$4 AVDD AVSS \$63 \$29 sg13cmos5l_inv_1
X$5 \$64 \$15 AVDD \$65 pmos$13
X$6 \$66 \$15 AVDD \$67 pmos$14
X$7 \$69 \$15 AVDD \$31 pmos$12
X$8 \$75 \$15 AVSS \$29 nmos$10
X$9 \$75 \$15 AVDD \$63 pmos$15
X$10 \$64 \$15 AVSS \$24 nmos$13
X$11 \$64 \$66 AVSS rhigh$6
X$12 \$66 \$15 AVSS \$30 nmos$11
X$13 \$66 \$69 AVSS rhigh$5
X$14 \$69 \$15 AVSS \$68 nmos$12
X$15 \$33 AVSS dantenna
X$16 \$69 \$70 AVSS rhigh$3
X$17 \$92 \$70 AVSS rhigh$3
X$18 \$92 \$71 AVSS rhigh$3
X$19 \$71 \$15 AVSS \$33 nmos$12
X$20 \$70 \$15 AVSS \$25 nmos$12
X$21 \$71 \$15 AVDD \$34 pmos$12
X$22 \$70 \$15 AVDD \$32 pmos$12
X$23 AVDD AVSS \$34 \$33 sg13cmos5l_inv_1
X$24 AVDD AVSS \$32 \$25 sg13cmos5l_inv_1
X$25 AVDD AVSS \$31 \$68 sg13cmos5l_inv_1
X$26 AVDD AVSS \$67 \$30 sg13cmos5l_inv_1
X$27 AVDD AVSS \$65 \$24 sg13cmos5l_inv_1
X$28 \$75 \$64 AVSS rhigh$4
.ENDS gain_network

.SUBCKT sg13cmos5l_and2_1 \$1 \$2 \$3 \$5 \$6
M$1 \$4 \$6 \$9 \$2 sg13_lv_nmos L=0.13u W=0.64u AS=0.2176p AD=0.1216p PS=1.96u
+ PD=1.02u rfmode=0
M$2 \$2 \$5 \$9 \$2 sg13_lv_nmos L=0.13u W=0.64u AS=0.1331p AD=0.1216p PS=1.12u
+ PD=1.02u rfmode=0
M$3 \$2 \$4 \$3 \$2 sg13_lv_nmos L=0.13u W=0.74u AS=0.1331p AD=0.2516p PS=1.12u
+ PD=2.16u rfmode=0
M$4 \$1 \$6 \$4 \$1 sg13_lv_pmos L=0.13u W=0.84u AS=0.2856p AD=0.1596p PS=2.36u
+ PD=1.22u rfmode=0
M$5 \$1 \$5 \$4 \$1 sg13_lv_pmos L=0.13u W=0.84u AS=0.1918p AD=0.1596p PS=1.5u
+ PD=1.22u rfmode=0
M$6 \$1 \$4 \$3 \$1 sg13_lv_pmos L=0.13u W=1.12u AS=0.1918p AD=0.3808p PS=1.5u
+ PD=2.92u rfmode=0
.ENDS sg13cmos5l_and2_1

.SUBCKT sg13cmos5l_nor2_1 \$1 \$2 \$3 \$4 \$5
M$1 \$2 \$4 \$3 \$2 sg13_lv_nmos L=0.13u W=0.74u AS=0.2516p AD=0.1406p PS=2.16u
+ PD=1.12u rfmode=0
M$2 \$3 \$5 \$2 \$2 sg13_lv_nmos L=0.13u W=0.74u AS=0.1406p AD=0.2516p PS=1.12u
+ PD=2.16u rfmode=0
M$3 \$1 \$4 \$7 \$1 sg13_lv_pmos L=0.13u W=1.12u AS=0.4032p AD=0.1176p PS=2.96u
+ PD=1.33u rfmode=0
M$4 \$7 \$5 \$3 \$1 sg13_lv_pmos L=0.13u W=1.12u AS=0.1176p AD=0.3808p PS=1.33u
+ PD=2.92u rfmode=0
.ENDS sg13cmos5l_nor2_1

.SUBCKT sg13cmos5l_nor3_1 \$1 \$2 \$3 \$4 \$5 \$6
M$1 \$2 \$3 \$4 \$2 sg13_lv_nmos L=0.13u W=0.77u AS=0.2618p AD=0.1694p PS=2.22u
+ PD=1.21u rfmode=0
M$2 \$4 \$5 \$2 \$2 sg13_lv_nmos L=0.13u W=0.77u AS=0.1694p AD=0.1463p PS=1.21u
+ PD=1.15u rfmode=0
M$3 \$2 \$6 \$4 \$2 sg13_lv_nmos L=0.13u W=0.77u AS=0.1463p AD=0.2618p PS=1.15u
+ PD=2.22u rfmode=0
M$4 \$1 \$3 \$10 \$1 sg13_lv_pmos L=0.13u W=1.12u AS=0.3808p AD=0.2464p
+ PS=2.92u PD=1.56u rfmode=0
M$5 \$10 \$5 \$9 \$1 sg13_lv_pmos L=0.13u W=1.12u AS=0.2464p AD=0.2128p
+ PS=1.56u PD=1.5u rfmode=0
M$6 \$9 \$6 \$4 \$1 sg13_lv_pmos L=0.13u W=1.12u AS=0.2128p AD=0.3808p PS=1.5u
+ PD=2.92u rfmode=0
.ENDS sg13cmos5l_nor3_1

.SUBCKT dantenna \$1 \$2
D$1 \$2 \$1 dantenna A=0.6084p P=3.12u m=1
.ENDS dantenna

.SUBCKT sg13cmos5l_inv_1 \$1 \$2 \$3 \$4
M$1 \$2 \$4 \$3 \$2 sg13_lv_nmos L=0.13u W=0.74u AS=0.2516p AD=0.2516p PS=2.16u
+ PD=2.16u rfmode=0
M$2 \$1 \$4 \$3 \$1 sg13_lv_pmos L=0.13u W=1.12u AS=0.3808p AD=0.3808p PS=2.92u
+ PD=2.92u rfmode=0
.ENDS sg13cmos5l_inv_1

.SUBCKT nmos$13 \$1 \$2 \$3 \$5
M$1 \$1 \$5 \$2 \$3 sg13_lv_nmos L=0.13u W=0.3u AS=0.102p AD=0.102p PS=1.28u
+ PD=1.28u rfmode=0
.ENDS nmos$13

.SUBCKT pmos$15 \$1 \$2 \$3 \$6
M$1 \$1 \$6 \$2 \$3 sg13_lv_pmos L=0.13u W=1.2u AS=0.408p AD=0.408p PS=3.08u
+ PD=3.08u rfmode=0
.ENDS pmos$15

.SUBCKT rhigh$6 \$1 \$2 \$3
R$1 \$1 \$2 \$3 rhigh w=0.5u l=13.42u ps=0u b=0 m=1
.ENDS rhigh$6

.SUBCKT rhigh$5 \$1 \$2 \$3
R$1 \$1 \$2 \$3 rhigh w=0.5u l=26.95u ps=0u b=0 m=1
.ENDS rhigh$5

.SUBCKT rhigh$4 \$1 \$2 \$3
R$1 \$1 \$2 \$3 rhigh w=0.5u l=6.66u ps=0u b=0 m=1
.ENDS rhigh$4

.SUBCKT rhigh$3 \$1 \$2 \$3
R$1 \$1 \$2 \$3 rhigh w=0.5u l=54u ps=0u b=0 m=1
.ENDS rhigh$3

.SUBCKT nmos$12 \$1 \$2 \$3 \$5
M$1 \$1 \$5 \$2 \$3 sg13_lv_nmos L=0.13u W=0.18u AS=0.1026p AD=0.1026p PS=1.34u
+ PD=1.34u rfmode=0
.ENDS nmos$12

.SUBCKT pmos$14 \$1 \$2 \$3 \$6
M$1 \$1 \$6 \$2 \$3 sg13_lv_pmos L=0.13u W=0.6u AS=0.204p AD=0.204p PS=1.88u
+ PD=1.88u rfmode=0
.ENDS pmos$14

.SUBCKT pmos$13 \$1 \$2 \$3 \$6
M$1 \$1 \$6 \$2 \$3 sg13_lv_pmos L=0.13u W=0.9u AS=0.306p AD=0.306p PS=2.48u
+ PD=2.48u rfmode=0
.ENDS pmos$13

.SUBCKT pmos$12 \$1 \$2 \$3 \$6
M$1 \$1 \$6 \$2 \$3 sg13_lv_pmos L=0.13u W=0.54u AS=0.1836p AD=0.1836p PS=1.76u
+ PD=1.76u rfmode=0
.ENDS pmos$12

.SUBCKT nmos$11 \$1 \$2 \$3 \$5
M$1 \$1 \$5 \$2 \$3 sg13_lv_nmos L=0.13u W=0.2u AS=0.104p AD=0.104p PS=1.34u
+ PD=1.34u rfmode=0
.ENDS nmos$11

.SUBCKT nmos$10 \$1 \$2 \$3 \$5
M$1 \$1 \$5 \$2 \$3 sg13_lv_nmos L=0.13u W=0.4u AS=0.136p AD=0.136p PS=1.48u
+ PD=1.48u rfmode=0
.ENDS nmos$10

.SUBCKT rhigh$2 \$1 \$2 \$3
R$1 \$1 \$2 \$3 rhigh w=0.5u l=3.2u ps=0u b=0 m=1
.ENDS rhigh$2

.SUBCKT gain_ota \$1 \$32 \$35 \$104 \$123 \$157
X$1 \$6 \$35 cap_cmomi$1
X$2 \$4 \$11 \$1 \$11 nmos$6
X$3 \$1 \$1 \$12 \$12 nmos
X$4 \$4 \$1 \$1 rhigh$1
X$5 \$1 \$1 \$38 \$32 nmos$3
X$6 \$1 \$77 \$1 \$32 nmos$5
X$7 \$1 \$88 \$20 \$11 nmos$8
X$8 \$88 \$6 \$1 rhigh
X$9 \$32 \$1 \$1 \$32 nmos$2
X$10 \$1 \$65 \$1 \$32 nmos$4
X$11 \$1 \$47 \$1 \$47 nmos$9
X$12 \$47 \$66 \$1 \$66 nmos$7
X$13 \$1 \$1 \$35 \$77 nmos$1
X$14 \$20 \$35 cap_cmomi
X$15 \$65 \$116 \$104 \$65 pmos$10
X$16 \$104 \$104 \$116 \$116 pmos$9
X$17 \$104 \$104 \$12 \$104 \$12 \$104 \$64 \$64 \$64 \$64 pmos$6
X$18 \$104 \$159 \$20 \$159 \$20 \$159 \$123 \$123 \$123 \$123 pmos
X$19 \$104 \$88 \$104 \$58 pmos$1
X$20 \$104 \$104 \$88 \$64 pmos$8
X$21 \$104 \$64 \$104 \$64 pmos$4
X$22 \$104 \$104 \$35 \$104 \$35 \$104 \$88 \$88 \$88 \$88 pmos$2
X$23 \$104 \$104 \$66 \$64 pmos$7
X$24 \$104 \$104 \$11 \$104 \$64 \$64 pmos$5
X$25 \$77 \$88 \$104 \$65 pmos$3
X$26 \$104 \$58 \$104 \$58 pmos$1
X$27 \$104 \$159 \$13 \$159 \$13 \$159 \$157 \$157 \$157 \$157 pmos
X$28 \$77 \$88 \$1 \$66 nmos$7
X$29 \$1 \$64 \$1 \$32 nmos$2
X$30 \$1 \$13 \$58 \$11 nmos$8
X$31 \$1 \$1 \$20 \$12 nmos
X$32 \$1 \$13 \$1 \$12 nmos
X$33 \$6 \$35 cap_cmomi$1
X$34 \$6 \$35 cap_cmomi$1
X$35 \$6 \$35 cap_cmomi$1
X$36 \$159 \$104 \$104 \$38 pmos$11
X$37 \$159 \$104 \$104 \$38 pmos$11
X$38 \$159 \$104 \$104 \$38 pmos$11
X$39 \$159 \$104 \$104 \$38 pmos$11
X$40 \$159 \$104 \$104 \$38 pmos$11
X$41 \$159 \$104 \$104 \$38 pmos$11
X$42 \$159 \$104 \$104 \$38 pmos$11
X$43 \$159 \$104 \$104 \$38 pmos$11
X$44 \$38 \$104 \$104 \$38 pmos$11
X$45 \$38 \$104 \$104 \$38 pmos$11
X$46 \$38 \$104 \$104 \$38 pmos$11
X$47 \$38 \$104 \$104 \$38 pmos$11
X$48 \$38 \$104 \$104 \$38 pmos$11
X$49 \$38 \$104 \$104 \$38 pmos$11
X$50 \$38 \$104 \$104 \$38 pmos$11
X$51 \$38 \$104 \$104 \$38 pmos$11
.ENDS gain_ota

.SUBCKT pmos$11 \$1 \$2 \$3 \$6
M$1 \$1 \$6 \$2 \$3 sg13_lv_pmos L=2u W=7.46u AS=2.5364p AD=2.5364p PS=15.6u
+ PD=15.6u rfmode=0
.ENDS pmos$11

.SUBCKT cap_cmomi$1 \$3 \$5
C$1 \$3 \$5 cap_cmomi w=8.65u l=10.2u A=0p P=0u m=1
.ENDS cap_cmomi$1

.SUBCKT cap_cmomi \$4 \$7
C$1 \$4 \$7 cap_cmomi w=25.56u l=26.16u A=0p P=0u m=1
.ENDS cap_cmomi

.SUBCKT pmos$10 \$1 \$2 \$3 \$7
M$1 \$1 \$7 \$2 \$3 sg13_lv_pmos L=0.5u W=2.2u AS=0.748p AD=0.748p PS=5.08u
+ PD=5.08u rfmode=0
.ENDS pmos$10

.SUBCKT pmos$9 \$1 \$2 \$4 \$6
M$1 \$2 \$6 \$4 \$1 sg13_lv_pmos L=0.5u W=5.55u AS=1.887p AD=1.887p PS=11.78u
+ PD=11.78u rfmode=0
.ENDS pmos$9

.SUBCKT pmos$8 \$1 \$2 \$3 \$6
M$1 \$2 \$6 \$3 \$1 sg13_lv_pmos L=2u W=9.21u AS=3.1314p AD=3.1314p PS=19.1u
+ PD=19.1u rfmode=0
.ENDS pmos$8

.SUBCKT pmos$7 \$1 \$2 \$3 \$6
M$1 \$2 \$6 \$3 \$1 sg13_lv_pmos L=2u W=4.6u AS=1.564p AD=1.564p PS=9.88u
+ PD=9.88u rfmode=0
.ENDS pmos$7

.SUBCKT pmos$6 \$1 \$2 \$3 \$4 \$5 \$6 \$9 \$10 \$11 \$12
M$1 \$2 \$9 \$3 \$1 sg13_lv_pmos L=2u W=5.75u AS=1.955p AD=1.0925p PS=12.18u
+ PD=6.13u rfmode=0
M$2 \$3 \$10 \$4 \$1 sg13_lv_pmos L=2u W=5.75u AS=1.0925p AD=1.0925p PS=6.13u
+ PD=6.13u rfmode=0
M$3 \$4 \$11 \$5 \$1 sg13_lv_pmos L=2u W=5.75u AS=1.0925p AD=1.0925p PS=6.13u
+ PD=6.13u rfmode=0
M$4 \$5 \$12 \$6 \$1 sg13_lv_pmos L=2u W=5.75u AS=1.0925p AD=1.955p PS=6.13u
+ PD=12.18u rfmode=0
.ENDS pmos$6

.SUBCKT pmos$5 \$1 \$2 \$3 \$4 \$7 \$8
M$1 \$2 \$7 \$3 \$1 sg13_lv_pmos L=2u W=5.75u AS=1.955p AD=1.0925p PS=12.18u
+ PD=6.13u rfmode=0
M$2 \$3 \$8 \$4 \$1 sg13_lv_pmos L=2u W=5.75u AS=1.0925p AD=1.955p PS=6.13u
+ PD=12.18u rfmode=0
.ENDS pmos$5

.SUBCKT pmos$4 \$1 \$2 \$3 \$7
M$1 \$1 \$7 \$2 \$3 sg13_lv_pmos L=2u W=2.3u AS=0.782p AD=0.782p PS=5.28u
+ PD=5.28u rfmode=0
.ENDS pmos$4

.SUBCKT nmos$9 \$1 \$2 \$3 \$6
M$1 \$1 \$6 \$2 \$3 sg13_lv_nmos L=0.5u W=2.1u AS=0.714p AD=0.714p PS=4.88u
+ PD=4.88u rfmode=0
.ENDS nmos$9

.SUBCKT nmos$8 \$1 \$2 \$3 \$7
M$1 \$2 \$7 \$3 \$1 sg13_lv_nmos L=2u W=6.41u AS=2.1794p AD=2.1794p PS=13.5u
+ PD=13.5u rfmode=0
.ENDS nmos$8

.SUBCKT nmos$7 \$1 \$2 \$3 \$6
M$1 \$1 \$6 \$2 \$3 sg13_lv_nmos L=0.5u W=0.84u AS=0.2856p AD=0.2856p PS=2.36u
+ PD=2.36u rfmode=0
.ENDS nmos$7

.SUBCKT nmos$6 \$1 \$2 \$3 \$6
M$1 \$1 \$6 \$2 \$3 sg13_lv_nmos L=2u W=1.6u AS=0.544p AD=0.544p PS=3.88u
+ PD=3.88u rfmode=0
.ENDS nmos$6

.SUBCKT nmos$5 \$1 \$2 \$3 \$6
M$1 \$1 \$6 \$2 \$3 sg13_lv_nmos L=2u W=3.2u AS=1.088p AD=1.088p PS=7.08u
+ PD=7.08u rfmode=0
.ENDS nmos$5

.SUBCKT nmos$4 \$1 \$2 \$3 \$6
M$1 \$1 \$6 \$2 \$3 sg13_lv_nmos L=2u W=1.74u AS=0.5916p AD=0.5916p PS=4.16u
+ PD=4.16u rfmode=0
.ENDS nmos$4

.SUBCKT nmos$3 \$1 \$2 \$3 \$7
M$1 \$2 \$7 \$3 \$1 sg13_lv_nmos L=2u W=6u AS=2.04p AD=2.04p PS=12.68u
+ PD=12.68u rfmode=0
.ENDS nmos$3

.SUBCKT nmos$2 \$1 \$2 \$3 \$6
M$1 \$1 \$6 \$2 \$3 sg13_lv_nmos L=2u W=0.87u AS=0.2958p AD=0.2958p PS=2.42u
+ PD=2.42u rfmode=0
.ENDS nmos$2

.SUBCKT nmos$1 \$1 \$4 \$5 \$7
M$1 \$4 \$7 \$5 \$1 sg13_lv_nmos L=0.5u W=8.4u AS=2.856p AD=2.856p PS=17.48u
+ PD=17.48u rfmode=0
.ENDS nmos$1

.SUBCKT pmos$3 \$1 \$2 \$3 \$7
M$1 \$1 \$7 \$2 \$3 sg13_lv_pmos L=0.5u W=2.2u AS=0.748p AD=0.748p PS=5.08u
+ PD=5.08u rfmode=0
.ENDS pmos$3

.SUBCKT pmos$2 \$1 \$2 \$4 \$5 \$6 \$7 \$9 \$10 \$11 \$12
M$1 \$2 \$9 \$4 \$1 sg13_lv_pmos L=0.5u W=5.55u AS=1.887p AD=1.0545p PS=11.78u
+ PD=5.93u rfmode=0
M$2 \$4 \$10 \$5 \$1 sg13_lv_pmos L=0.5u W=5.55u AS=1.0545p AD=1.0545p PS=5.93u
+ PD=5.93u rfmode=0
M$3 \$5 \$12 \$6 \$1 sg13_lv_pmos L=0.5u W=5.55u AS=1.0545p AD=1.0545p PS=5.93u
+ PD=5.93u rfmode=0
M$4 \$6 \$11 \$7 \$1 sg13_lv_pmos L=0.5u W=5.55u AS=1.0545p AD=1.887p PS=5.93u
+ PD=11.78u rfmode=0
.ENDS pmos$2

.SUBCKT nmos \$1 \$2 \$3 \$7
M$1 \$2 \$7 \$3 \$1 sg13_lv_nmos L=2u W=9.21u AS=3.1314p AD=3.1314p PS=19.1u
+ PD=19.1u rfmode=0
.ENDS nmos

.SUBCKT pmos$1 \$1 \$2 \$3 \$6
M$1 \$2 \$6 \$3 \$1 sg13_lv_pmos L=2u W=7.33u AS=2.4922p AD=2.4922p PS=15.34u
+ PD=15.34u rfmode=0
.ENDS pmos$1

.SUBCKT pmos \$1 \$2 \$3 \$4 \$5 \$6 \$9 \$10 \$11 \$12
M$1 \$2 \$9 \$3 \$1 sg13_lv_pmos L=2u W=6.64u AS=2.2576p AD=1.2616p PS=13.96u
+ PD=7.02u rfmode=0
M$2 \$3 \$10 \$4 \$1 sg13_lv_pmos L=2u W=6.64u AS=1.2616p AD=1.2616p PS=7.02u
+ PD=7.02u rfmode=0
M$3 \$4 \$11 \$5 \$1 sg13_lv_pmos L=2u W=6.64u AS=1.2616p AD=1.2616p PS=7.02u
+ PD=7.02u rfmode=0
M$4 \$5 \$12 \$6 \$1 sg13_lv_pmos L=2u W=6.64u AS=1.2616p AD=2.2576p PS=7.02u
+ PD=13.96u rfmode=0
.ENDS pmos

.SUBCKT rhigh$1 \$1 \$2 \$3
R$1 \$1 \$2 \$3 rhigh w=0.5u l=15u ps=0u b=0 m=1
.ENDS rhigh$1

.SUBCKT rhigh \$1 \$2 \$3
R$1 \$1 \$2 \$3 rhigh w=0.5u l=4u ps=0u b=0 m=1
.ENDS rhigh
