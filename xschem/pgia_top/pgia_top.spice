** sch_path: /foss/designs/sg13cmos5l_spma_ip__instramp/xschem/pgia_top/pgia_top.sch
.subckt pgia_top VINP VINN VCM gain_sel[0] gain_sel[1] gain_sel[2] gain_sel[3] VOUT AVDD VPWR IBIAS_IA AVSS VGND
*.PININFO AVDD:B AVSS:B VPWR:B VGND:B VINP:I VINN:I VCM:I gain_sel[0]:I gain_sel[1]:I gain_sel[2]:I gain_sel[3]:I IBIAS_IA:I
*+ VOUT:O
x_dec VGND VPWR gain_sel[0] gain_sel[1] gain_sel[2] gain_sel[3] s1[0] s1[1] s1[2] s1[3] s1[4] net3 net4 net5 net6 net7 s2[0] s2[1]
+ s2[2] s2[3] s2[4] net8 net9 net10 net11 net12 gain_decoder_4b
x_ia AVSS AVDD IBIAS_IA VINN V_IA VINP VCM instramp_cmos5l
x_stage1 AVDD AVSS IBIAS_IA V_IA VCM v_stage1 s1[0] s1[1] s1[2] s1[3] s1[4] gain_stage
x_stage2 AVDD AVSS IBIAS_IA v_stage1 VCM v_stage2 s2[0] s2[1] s2[2] s2[3] s2[4] gain_stage
x_buf AVDD AVSS IBIAS_IA v_stage2 VOUT output_buffer
MM1 net1 net1 VCM AVDD sg13_lv_pmos w=0.2u l=2u ng=1
MM2 net1 net1 VINN AVDD sg13_lv_pmos w=0.2u l=2u ng=1
MM3 net2 net2 VINP AVDD sg13_lv_pmos w=0.2u l=2u ng=1
MM4 net2 net2 VCM AVDD sg13_lv_pmos w=0.2u l=2u ng=1
**** begin user architecture code

* Standard cell models & synthesized gain decoder macro
.include /foss/pdks/ihp-sg13cmos5l/libs.ref/sg13cmos5l_stdcell/spice/sg13cmos5l_stdcell.spice
.include /foss/designs/sg13cmos5l_spma_ip__instramp/gds/gain_decoder_4b/final/spice/gain_decoder_4b.spice

**** end user architecture code
.ends

* expanding   symbol:  /foss/designs/sg13cmos5l_spma_ip__instramp/xschem/instramp_cmos5l/instramp_cmos5l.sym # of pins=7
** sym_path: /foss/designs/sg13cmos5l_spma_ip__instramp/xschem/instramp_cmos5l/instramp_cmos5l.sym
** sch_path: /foss/designs/sg13cmos5l_spma_ip__instramp/xschem/instramp_cmos5l/instramp_cmos5l.sch
.subckt instramp_cmos5l VSS VDD IBIAS VINN VOUT VINP CM
*.PININFO VDD:B IBIAS:B VSS:B CM:B VOUT:B VINN:B VINP:B
x1 VSS IBIAS VDD net3 VINP net4 ota_cmos5l
x2 VSS IBIAS VDD net1 VINN net2 ota_cmos5l
x3 VSS IBIAS VDD net5 net6 VOUT ota_cmos5l
RR1 net4 net6 6.233k $SUB=VSS $[rhigh] w=0.5e-6 l=2e-6 b=0
RR2 net2 net5 6.233k $SUB=VSS $[rhigh] w=0.5e-6 l=2e-6 b=0
RR3 net6 CM 53.06k $SUB=VSS $[rhigh] w=0.5e-6 l=8*2.23e-6 b=0
RR4 net5 VOUT 53.06k $SUB=VSS $[rhigh] w=0.5e-6 l=8*2.23e-6 b=0
RR7 net2 net1 6.233k $SUB=VSS $[rhigh] w=0.5e-6 l=2e-6 b=0
RR8 net4 net3 6.233k $SUB=VSS $[rhigh] w=0.5e-6 l=2e-6 b=0
.ends

* expanding   symbol:  /foss/designs/sg13cmos5l_spma_ip__instramp/xschem/gain_stage/gain_stage.sym # of pins=11
** sym_path: /foss/designs/sg13cmos5l_spma_ip__instramp/xschem/gain_stage/gain_stage.sym
** sch_path: /foss/designs/sg13cmos5l_spma_ip__instramp/xschem/gain_stage/gain_stage.sch
.subckt gain_stage AVDD AVSS IBIAS VIN VCM VOUT s[0] s[1] s[2] s[3] s[4]
*.PININFO AVDD:B AVSS:B IBIAS:I VIN:I VCM:I VOUT:O s[0]:I s[1]:I s[2]:I s[3]:I s[4]:I
x_nor3 nor3_out s[0] s[1] s[2] AVDD AVSS sg13cmos5l_nor3_1
x_nor2 nor2_out s[3] s[4] AVDD AVSS sg13cmos5l_nor2_1
x_and2 S0 nor3_out nor2_out AVDD AVSS sg13cmos5l_and2_1
x1 s[3] s[4] S0 s[1] s[0] s[2] AVDD VCM VIN VOUT IBIAS AVSS gain_network
.ends

* expanding   symbol:  /foss/designs/sg13cmos5l_spma_ip__instramp/xschem/output_buffer/output_buffer.sym # of pins=5
** sym_path: /foss/designs/sg13cmos5l_spma_ip__instramp/xschem/output_buffer/output_buffer.sym
** sch_path: /foss/designs/sg13cmos5l_spma_ip__instramp/xschem/output_buffer/output_buffer.sch
.subckt output_buffer VDD VSS IBIAS VINN VOUT
*.PININFO VDD:B VSS:B IBIAS:B VINN:B VOUT:B
x1 VSS IBIAS VDD VINN VOUT VOUT ota_cmos5l
.ends

* expanding   symbol:  /foss/designs/sg13cmos5l_spma_ip__instramp/xschem/ota_cmos5l/ota_cmos5l.sym # of pins=6
** sym_path: /foss/designs/sg13cmos5l_spma_ip__instramp/xschem/ota_cmos5l/ota_cmos5l.sym
** sch_path: /foss/designs/sg13cmos5l_spma_ip__instramp/xschem/ota_cmos5l/ota_cmos5l.sch
.subckt ota_cmos5l VSS IBIAS VDD VINN VINP VOUT
*.PININFO IBIAS:B VDD:B VSS:B VOUT:B VINP:B VINN:B
MM6 IBIAS IBIAS VDD VDD sg13_lv_pmos w={wbias} l={lbias} ng=1 m={m6}
MM7 net1 IBIAS VDD VDD sg13_lv_pmos w={wbias} l={lbias} ng=1 m={m7}
MM8 VOUT IBIAS VDD VDD sg13_lv_pmos w={wbias} l={lbias} ng=1 m={m8}
MM1 net2 VINN net1 VDD sg13_lv_pmos w={winpair} l={linpair} ng=1
MM2 net3 VINP net1 VDD sg13_lv_pmos w={winpair} l={linpair} ng=1
MM3 net2 net2 VSS VSS sg13_lv_nmos w={wload} l={lload} ng=1
MM4 net3 net2 VSS VSS sg13_lv_nmos w={wload} l={lload} ng=1
MM5 VOUT net3 VSS VSS sg13_lv_nmos w={wcs} l={lcs} ng=1
RR1 net3 net4 6.085k $SUB=VSS $[rhigh] w=0.5e-6 l=1.95e-6 b=0
.save v(vinp)
.save v(vinn)
.save v(vout)
CC2 VOUT net4 cap_cmomi w=15e-6 l=15e-6 m=5
**** begin user architecture code

.param temp=27
.param lbias=0.15u wbias=0.15u
.param m6=1 m7=4 m8=8
.param linpair=3u winpair=20u
.param lload=5u wload=10u
.param lcs=3u wcs=20u
.param Cc=2p

**** end user architecture code
CC1 VOUT net4 cap_cmomi w=15e-6 l=15e-6 m=4
.ends

* expanding   symbol:  /foss/designs/sg13cmos5l_spma_ip__instramp/xschem/gain_network/gain_network.sym # of pins=12
** sym_path: /foss/designs/sg13cmos5l_spma_ip__instramp/xschem/gain_network/gain_network.sym
** sch_path: /foss/designs/sg13cmos5l_spma_ip__instramp/xschem/gain_network/gain_network.sch
.subckt gain_network S4 S5 S0 S2 S1 S3 AVDD V_CM V_IN2 V_OUT2 I_BIAS AVSS
*.PININFO I_BIAS:I V_IN2:I V_CM:I AVSS:I AVDD:I V_OUT2:O S5:I S4:I S3:I S2:I S1:I S0:I
x13 net8 S5 AVDD AVSS sg13cmos5l_inv_1
x12 net9 S4 AVDD AVSS sg13cmos5l_inv_1
x11 net10 S3 AVDD AVSS sg13cmos5l_inv_1
x10 net11 S2 AVDD AVSS sg13cmos5l_inv_1
x9 net12 S1 AVDD AVSS sg13cmos5l_inv_1
x8 net13 S0 AVDD AVSS sg13cmos5l_inv_1
*  x7 -  tgate  IS MISSING !!!!
*  x6 -  tgate  IS MISSING !!!!
*  x5 -  tgate  IS MISSING !!!!
*  x4 -  tgate  IS MISSING !!!!
*  x3 -  tgate  IS MISSING !!!!
*  x2 -  tgate  IS MISSING !!!!
RR6 net5 net4 160k $SUB=AVSS $[rhigh] w=0.5e-6 l=54e-6 b=0
RR5 net4 net3 80k $SUB=AVSS $[rhigh] w=0.5e-6 l=26.95e-6 b=0
x1 AVDD V_CM net7 V_OUT2 I_BIAS AVSS gain_ota
RR1 net7 V_IN2 20.01k $SUB=AVSS $[rhigh] w=0.5e-6 l=6.66e-6 b=0
RR2 V_OUT2 net1 9.781k $SUB=AVSS $[rhigh] w=0.5e-6 l=3.2e-6 b=0
RR3 net1 net2 20.01k $SUB=AVSS $[rhigh] w=0.5e-6 l=6.66e-6 b=0
RR4 net2 net3 40k $SUB=AVSS $[rhigh] w=0.5e-6 l=13.42e-6 b=0
RR7 net14 net5 160k $SUB=AVSS $[rhigh] w=0.5e-6 l=54e-6 b=0
RR8 net6 net14 160k $SUB=AVSS $[rhigh] w=0.5e-6 l=54e-6 b=0
DD1 AVSS S5 dantenna l=0.78u w=0.78u
.ends

* expanding   symbol:  /foss/designs/sg13cmos5l_spma_ip__instramp/xschem/gain_ota/gain_ota.sym # of pins=6
** sym_path: /foss/designs/sg13cmos5l_spma_ip__instramp/xschem/gain_ota/gain_ota.sym
** sch_path: /foss/designs/sg13cmos5l_spma_ip__instramp/xschem/gain_ota/gain_ota.sch
.subckt gain_ota VDD V_inp V_inn V_out I_bias VSS
*.PININFO V_inn:I VDD:I VSS:I V_out:O I_bias:I V_inp:I
MM1 F1 V_inn net6 VDD sg13_lv_pmos w=26.56u l=2u ng=4
MM2 F2 V_inp net6 VDD sg13_lv_pmos w=26.56u l=2u ng=4
MM3 net5 net5 VDD VDD sg13_lv_pmos w=7.33u l=2u ng=1
MM4 N_A net5 VDD VDD sg13_lv_pmos w=7.33u l=2u ng=1
MM7 F1 V_bn2 VSS VSS sg13_lv_nmos w=9.21u l=2u ng=1
MM8 F2 V_bn2 VSS VSS sg13_lv_nmos w=9.21u l=2u ng=1
MM_tail net6 V_btail VDD VDD sg13_lv_pmos w=7.46u l=2u ng=1 m=8
MM_ctrlp N_B V_ctrlp N_A VDD sg13_lv_pmos w=2.20u l=0.50u ng=1
MM_outp V_out N_A VDD VDD sg13_lv_pmos w=22.20u l=0.5u ng=4
MM_ctrln N_A V_ctrln N_B VSS sg13_lv_nmos w=0.84u l=0.5u ng=1
MM_outn V_out N_B VSS VSS sg13_lv_nmos w=8.4u l=0.5u ng=1
MM5 net5 V_bn1 F1 VSS sg13_lv_nmos w=6.41u l=2u ng=1
MM6 N_A V_bn1 F2 VSS sg13_lv_nmos w=6.41u l=2u ng=1
MM_mp1 net1 net1 VDD VDD sg13_lv_pmos w=2.30u l=2u ng=1
MM_mn1 net1 I_bias VSS VSS sg13_lv_nmos w=0.87u l=2u ng=1
MM_refn I_bias I_bias VSS VSS sg13_lv_nmos w=0.87u l=2u ng=1
MM_mp2 V_bn1 net1 VDD VDD sg13_lv_pmos w=11.50u l=2u ng=2
MM_mp3 V_bn2 net1 VDD VDD sg13_lv_pmos w=23u l=2u ng=4
MM_bn1 V_bn1 V_bn1 net2 VSS sg13_lv_nmos w=1.60u l=2u ng=1
MM_bn2 V_bn2 V_bn2 VSS VSS sg13_lv_nmos w=9.21u l=2u ng=1
MM_mn2 V_btail I_bias VSS VSS sg13_lv_nmos w=6u l=2u ng=1
MM_rep_tail V_btail V_btail VDD VDD sg13_lv_pmos w=7.46u l=2u ng=1 m=8
MM_mn4 N_B I_bias VSS VSS sg13_lv_nmos w=3.2u l=2u ng=1
RR1 net2 VSS 44.67k $SUB=VSS $[rhigh] w=0.5e-6 l=15e-6 b=0
MM_mp4 V_ctrln net1 VDD VDD sg13_lv_pmos w=4.60u l=2u ng=1
MM_rep_ctrln V_ctrln V_ctrln net3 VSS sg13_lv_nmos w=0.84u l=0.5u ng=1
MM_rep_outn net3 net3 VSS VSS sg13_lv_nmos w=2.10u l=0.5u ng=1
MM_mn3 V_ctrlp I_bias VSS VSS sg13_lv_nmos w=1.74u l=2u ng=1
MM_rep_outp net4 net4 VDD VDD sg13_lv_pmos w=5.55u l=0.5u ng=1
MM_rep_ctrlp V_ctrlp V_ctrlp net4 VDD sg13_lv_pmos w=2.20u l=0.50u ng=1
MM_mp5 N_A net1 VDD VDD sg13_lv_pmos w=9.21u l=2u ng=1
RR2 N_A net7 12.15k $SUB=VSS $[rhigh] w=0.5e-6 l=4e-6 b=0
CC3 F2 V_out cap_cmomi w=25e-6 l=25e-6
CC4 net7 V_out cap_cmomi w=8.5e-6 l=8.5e-6 m=4
.ends
