** sch_path: /foss/designs/backup_chipalooza/sg13cmos5l_spma_ip__instramp/xschem/pgia_top/tb_pgia_top.sch
**.subckt tb_pgia_top
x1 VINP VINN VCM gain_sel[0] gain_sel[1] gain_sel[2] gain_sel[3] VOUT AVDD VPWR IBIAS_IA IBIAS_G1 IBIAS_G2 IBIAS_BUF AVSS VGND
+ pgia_top
V_AVDD AVDD 0 1.2
V_AVSS AVSS 0 0
V_VPWR VPWR 0 1.2
V_VGND VGND 0 0
I_IA IBIAS_IA 0 4.2u
I_BUF IBIAS_BUF 0 1.4u
I_G1 AVDD IBIAS_G1 1.0u
I_G2 AVDD IBIAS_G2 1.0u
V_CM VCM 0 0.6
V_INP VINP VCM -334.7u AC 0.5 SIN(-334.7u 20u 10k 0 0 0)
V_INN VINN VCM 0 AC -0.5 SIN(0 20u 10k 0 0 180)
V_G0 gain_sel[0] 0 DC v_g0 PULSE(0 1.2 100u 1n 1n 100u 200u)
V_G1 gain_sel[1] 0 DC v_g1 PULSE(0 1.2 200u 1n 1n 200u 400u)
V_G2 gain_sel[2] 0 DC v_g2 PULSE(0 1.2 400u 1n 1n 400u 800u)
V_G3 gain_sel[3] 0 DC v_g3 PULSE(0 1.2 800u 1n 1n 800u 1600u)
CL VOUT 0 15p
RL VOUT 0 100k
**** begin user architecture code

.lib /foss/pdks/ihp-sg13cmos5l/libs.tech/ngspice/models/cornerMOSlv.lib mos_tt
.lib /foss/pdks/ihp-sg13cmos5l/libs.tech/ngspice/models/cornerRES.lib res_typ
.lib /foss/pdks/ihp-sg13cmos5l/libs.tech/ngspice/models/cornerCAP.lib cap_typ
.include /foss/pdks/ihp-sg13cmos5l/libs.ref/sg13cmos5l_stdcell/spice/sg13cmos5l_stdcell.spice

.param temp=27
.param lbias=0.15u wbias=0.15u
.param m6=1 m7=4 m8=8
.param linpair=3u winpair=20u
.param lload=5u wload=10u
.param lcs=3u wcs=20u
.param Cc=2p
.param v_g0=0 v_g1=0 v_g2=0 v_g3=0

.save v_inp#branch v_inn#branch v(VOUT) v(VINP) v(VINN) v(VCM) v(x1.v_ia) v(x1.v_stage1) v(x1.v_stage2) v_avdd#branch v_vpwr#branch

.control
  save all v(VOUT) v(x1.v_ia) v(x1.v_stage1) v(x1.v_stage2) v_inp#branch v_inn#branch
  echo ==========================================================================
  echo === TOP-LEVEL PGIA CO-SIMULATION BATTERY (MILESTONES 3, 4, 5) ===
  echo ==========================================================================

  * 1. DC Operating Point Verification
  echo
  echo --- Phase A: DC Operating Point Audit ---
  op
  let v_ia_dc     = v(x1.v_ia)
  let v_st1_dc    = v(x1.v_stage1)
  let v_st2_dc    = v(x1.v_stage2)
  let v_out_dc    = v(VOUT)
  let v_diff_dc   = v(VINP) - v(VINN)
  let i_avdd_dc   = -v_avdd#branch
  let i_vpwr_dc   = -v_vpwr#branch
  let p_tot_uW    = (i_avdd_dc + i_vpwr_dc) * 1.2 * 1e6

  echo Target Common-Mode: 0.600 V
  echo V(VINP) - V(VINN) = $&v_diff_dc V
  echo V(v_ia)           = $&v_ia_dc V
  echo V(v_stage1)       = $&v_st1_dc V
  echo V(v_stage2)       = $&v_st2_dc V
  echo V(VOUT)           = $&v_out_dc V
  echo Total Static DC Power = $&p_tot_uW uW (Spec Target: under 500 uW)

  * 2. Small-Signal AC Gain Sweeps Across All 11 Valid Gain Steps (0 to 10)
  echo
  echo --- Phase B: Small-Signal AC Frequency Response (11 Steps) ---

  * Step 0: 0000 (Target: 18.06 dB / 8x)
  alterparam v_g0=0
  alterparam v_g1=0
  alterparam v_g2=0
  alterparam v_g3=0
  reset
  op
  let v_out_dc0 = v(VOUT)
  set vdc0 = $&v_out_dc0
  let vos0_val = ($vdc0 - 0.6) * 1000
  set vos0 = $&vos0_val
  ac dec 10 10 100Meg
  let gain0 = db(v(VOUT))
  let g0_1k = gain0[20]
  echo Step 0  (0000): Gain @ 1kHz = $&g0_1k dB, V_OUT_dc = $vdc0 V, V_OS_out = $vos0 mV

  * Step 1: 0001 (Target: 24.08 dB / 16x)
  alterparam v_g0=1.2
  alterparam v_g1=0
  alterparam v_g2=0
  alterparam v_g3=0
  reset
  op
  let v_out_dc1 = v(VOUT)
  set vdc1 = $&v_out_dc1
  let vos1_val = ($vdc1 - 0.6) * 1000
  set vos1 = $&vos1_val
  ac dec 10 10 100Meg
  let gain1 = db(v(VOUT))
  let g1_1k = gain1[20]
  echo Step 1  (0001): Gain @ 1kHz = $&g1_1k dB, V_OUT_dc = $vdc1 V, V_OS_out = $vos1 mV

  * Step 2: 0010 (Target: 30.10 dB / 32x)
  alterparam v_g0=0
  alterparam v_g1=1.2
  alterparam v_g2=0
  alterparam v_g3=0
  reset
  op
  let v_out_dc2 = v(VOUT)
  set vdc2 = $&v_out_dc2
  let vos2_val = ($vdc2 - 0.6) * 1000
  set vos2 = $&vos2_val
  ac dec 10 10 100Meg
  let gain2 = db(v(VOUT))
  let g2_1k = gain2[20]
  echo Step 2  (0010): Gain @ 1kHz = $&g2_1k dB, V_OUT_dc = $vdc2 V, V_OS_out = $vos2 mV

  * Step 3: 0011 (Target: 36.12 dB / 64x)
  alterparam v_g0=1.2
  alterparam v_g1=1.2
  alterparam v_g2=0
  alterparam v_g3=0
  reset
  op
  let v_out_dc3 = v(VOUT)
  set vdc3 = $&v_out_dc3
  let vos3_val = ($vdc3 - 0.6) * 1000
  set vos3 = $&vos3_val
  ac dec 10 10 100Meg
  let gain3 = db(v(VOUT))
  let g3_1k = gain3[20]
  echo Step 3  (0011): Gain @ 1kHz = $&g3_1k dB, V_OUT_dc = $vdc3 V, V_OS_out = $vos3 mV

  * Step 4: 0100 (Target: 42.14 dB / 128x)
  alterparam v_g0=0
  alterparam v_g1=0
  alterparam v_g2=1.2
  alterparam v_g3=0
  reset
  op
  let v_out_dc4 = v(VOUT)
  set vdc4 = $&v_out_dc4
  let vos4_val = ($vdc4 - 0.6) * 1000
  set vos4 = $&vos4_val
  ac dec 10 10 100Meg
  let gain4 = db(v(VOUT))
  let g4_1k = gain4[20]
  echo Step 4  (0100): Gain @ 1kHz = $&g4_1k dB, V_OUT_dc = $vdc4 V, V_OS_out = $vos4 mV

  * Step 5: 0101 (Target: 48.16 dB / 256x)
  alterparam v_g0=1.2
  alterparam v_g1=0
  alterparam v_g2=1.2
  alterparam v_g3=0
  reset
  op
  let v_out_dc5 = v(VOUT)
  set vdc5 = $&v_out_dc5
  let vos5_val = ($vdc5 - 0.6) * 1000
  set vos5 = $&vos5_val
  ac dec 10 10 100Meg
  let gain5 = db(v(VOUT))
  let g5_1k = gain5[20]
  echo Step 5  (0101): Gain @ 1kHz = $&g5_1k dB, V_OUT_dc = $vdc5 V, V_OS_out = $vos5 mV

  * Step 6: 0110 (Target: 54.18 dB / 512x)
  alterparam v_g0=0
  alterparam v_g1=1.2
  alterparam v_g2=1.2
  alterparam v_g3=0
  reset
  op
  let v_out_dc6 = v(VOUT)
  set vdc6 = $&v_out_dc6
  let vos6_val = ($vdc6 - 0.6) * 1000
  set vos6 = $&vos6_val
  ac dec 10 10 100Meg
  let gain6 = db(v(VOUT))
  let g6_1k = gain6[20]
  echo Step 6  (0110): Gain @ 1kHz = $&g6_1k dB, V_OUT_dc = $vdc6 V, V_OS_out = $vos6 mV

  * Step 7: 0111 (Target: 60.20 dB / 1024x)
  alterparam v_g0=1.2
  alterparam v_g1=1.2
  alterparam v_g2=1.2
  alterparam v_g3=0
  reset
  op
  let v_out_dc7 = v(VOUT)
  set vdc7 = $&v_out_dc7
  let vos7_val = ($vdc7 - 0.6) * 1000
  set vos7 = $&vos7_val
  ac dec 10 10 100Meg
  let gain7 = db(v(VOUT))
  let g7_1k = gain7[20]
  echo Step 7  (0111): Gain @ 1kHz = $&g7_1k dB, V_OUT_dc = $vdc7 V, V_OS_out = $vos7 mV

  * Step 8: 1000 (Target: 66.22 dB / 2048x)
  alterparam v_g0=0
  alterparam v_g1=0
  alterparam v_g2=0
  alterparam v_g3=1.2
  reset
  op
  let v_out_dc8 = v(VOUT)
  set vdc8 = $&v_out_dc8
  let vos8_val = ($vdc8 - 0.6) * 1000
  set vos8 = $&vos8_val
  ac dec 10 10 100Meg
  let gain8 = db(v(VOUT))
  let g8_1k = gain8[20]
  echo Step 8  (1000): Gain @ 1kHz = $&g8_1k dB, V_OUT_dc = $vdc8 V, V_OS_out = $vos8 mV

  * Step 9: 1001 (Target: 72.24 dB / 4096x)
  alterparam v_g0=1.2
  alterparam v_g1=0
  alterparam v_g2=0
  alterparam v_g3=1.2
  reset
  op
  let v_out_dc9 = v(VOUT)
  set vdc9 = $&v_out_dc9
  let vos9_val = ($vdc9 - 0.6) * 1000
  set vos9 = $&vos9_val
  ac dec 10 10 100Meg
  let gain9 = db(v(VOUT))
  let g9_1k = gain9[20]
  echo Step 9  (1001): Gain @ 1kHz = $&g9_1k dB, V_OUT_dc = $vdc9 V, V_OS_out = $vos9 mV

  * Step 10: 1010 (Target: 78.26 dB / 8192x)
  alterparam v_g0=0
  alterparam v_g1=1.2
  alterparam v_g2=0
  alterparam v_g3=1.2
  reset
  op
  let v_out_dc10 = v(VOUT)
  set vdc10 = $&v_out_dc10
  let vos10_val = ($vdc10 - 0.6) * 1000
  set vos10 = $&vos10_val
  ac dec 10 10 100Meg
  let gain10 = db(v(VOUT))
  let g10_1k = gain10[20]
  echo Step 10 (1010): Gain @ 1kHz = $&g10_1k dB, V_OUT_dc = $vdc10 V, V_OS_out = $vos10 mV

  * Step 11: 1011 (Out-of-range Clamp Target)
  alterparam v_g0=1.2
  alterparam v_g1=1.2
  alterparam v_g2=0
  alterparam v_g3=1.2
  reset
  op
  let v_out_dc11 = v(VOUT)
  set vdc11 = $&v_out_dc11
  let vos11_val = ($vdc11 - 0.6) * 1000
  set vos11 = $&vos11_val
  ac dec 10 10 100Meg
  let gain11 = db(v(VOUT))
  let g11_1k = gain11[20]
  echo Step 11 (1011): Gain @ 1kHz = $&g11_1k dB, V_OUT_dc = $vdc11 V, V_OS_out = $vos11 mV (Expected Clamp to Step 0)

  * 3. Dynamic Transient Co-Simulation Across All 16 States (0 to 15)
  echo
  echo --- Phase C: Dynamic Transient Stepping (16 States x 100us) ---
  tran 1u 1.6m
  meas tran vpp_st0  pp  v(VOUT) from=50u to=90u
  meas tran vdc_st0  avg v(VOUT) from=50u to=90u
  let vos_st0 = (vdc_st0 - 0.6) * 1000

  meas tran vpp_st1  pp  v(VOUT) from=150u to=190u
  meas tran vdc_st1  avg v(VOUT) from=150u to=190u
  let vos_st1 = (vdc_st1 - 0.6) * 1000

  meas tran vpp_st2  pp  v(VOUT) from=250u to=290u
  meas tran vdc_st2  avg v(VOUT) from=250u to=290u
  let vos_st2 = (vdc_st2 - 0.6) * 1000

  meas tran vpp_st3  pp  v(VOUT) from=350u to=390u
  meas tran vdc_st3  avg v(VOUT) from=350u to=390u
  let vos_st3 = (vdc_st3 - 0.6) * 1000

  meas tran vpp_st4  pp  v(VOUT) from=450u to=490u
  meas tran vdc_st4  avg v(VOUT) from=450u to=490u
  let vos_st4 = (vdc_st4 - 0.6) * 1000

  meas tran vpp_st5  pp  v(VOUT) from=550u to=590u
  meas tran vdc_st5  avg v(VOUT) from=550u to=590u
  let vos_st5 = (vdc_st5 - 0.6) * 1000

  meas tran vpp_st6  pp  v(VOUT) from=650u to=690u
  meas tran vdc_st6  avg v(VOUT) from=650u to=690u
  let vos_st6 = (vdc_st6 - 0.6) * 1000

  meas tran vpp_st7  pp  v(VOUT) from=750u to=790u
  meas tran vdc_st7  avg v(VOUT) from=750u to=790u
  let vos_st7 = (vdc_st7 - 0.6) * 1000

  meas tran vpp_st8  pp  v(VOUT) from=850u to=890u
  meas tran vdc_st8  avg v(VOUT) from=850u to=890u
  let vos_st8 = (vdc_st8 - 0.6) * 1000

  meas tran vpp_st9  pp  v(VOUT) from=950u to=990u
  meas tran vdc_st9  avg v(VOUT) from=950u to=990u
  let vos_st9 = (vdc_st9 - 0.6) * 1000

  meas tran vpp_st10 pp  v(VOUT) from=1050u to=1090u
  meas tran vdc_st10 avg v(VOUT) from=1050u to=1090u
  let vos_st10 = (vdc_st10 - 0.6) * 1000

  meas tran vpp_st11 pp  v(VOUT) from=1150u to=1190u
  meas tran vdc_st11 avg v(VOUT) from=1150u to=1190u
  let vos_st11 = (vdc_st11 - 0.6) * 1000

  meas tran vpp_st12 pp  v(VOUT) from=1250u to=1290u
  meas tran vdc_st12 avg v(VOUT) from=1250u to=1290u
  let vos_st12 = (vdc_st12 - 0.6) * 1000

  meas tran vpp_st15 pp  v(VOUT) from=1550u to=1590u
  meas tran vdc_st15 avg v(VOUT) from=1550u to=1590u
  let vos_st15 = (vdc_st15 - 0.6) * 1000

  echo
  echo Transient Output Peak-to-Peak and DC Offset:
  echo State 0  (0000): $&vpp_st0 Vpp, V_OUT_dc = $&vdc_st0 V, V_OS_out = $&vos_st0 mV
  echo State 1  (0001): $&vpp_st1 Vpp, V_OUT_dc = $&vdc_st1 V, V_OS_out = $&vos_st1 mV
  echo State 2  (0010): $&vpp_st2 Vpp, V_OUT_dc = $&vdc_st2 V, V_OS_out = $&vos_st2 mV
  echo State 3  (0011): $&vpp_st3 Vpp, V_OUT_dc = $&vdc_st3 V, V_OS_out = $&vos_st3 mV
  echo State 4  (0100): $&vpp_st4 Vpp, V_OUT_dc = $&vdc_st4 V, V_OS_out = $&vos_st4 mV
  echo State 5  (0101): $&vpp_st5 Vpp, V_OUT_dc = $&vdc_st5 V, V_OS_out = $&vos_st5 mV
  echo State 6  (0110): $&vpp_st6 Vpp, V_OUT_dc = $&vdc_st6 V, V_OS_out = $&vos_st6 mV
  echo State 7  (0111): $&vpp_st7 Vpp, V_OUT_dc = $&vdc_st7 V, V_OS_out = $&vos_st7 mV
  echo State 8  (1000): $&vpp_st8 Vpp, V_OUT_dc = $&vdc_st8 V, V_OS_out = $&vos_st8 mV
  echo State 9  (1001): $&vpp_st9 Vpp, V_OUT_dc = $&vdc_st9 V, V_OS_out = $&vos_st9 mV
  echo State 10 (1010): $&vpp_st10 Vpp, V_OUT_dc = $&vdc_st10 V, V_OS_out = $&vos_st10 mV
  echo State 11 (1011): $&vpp_st11 Vpp (Clamped), V_OUT_dc = $&vdc_st11 V, V_OS_out = $&vos_st11 mV
  echo State 12 (1100): $&vpp_st12 Vpp (Clamped), V_OUT_dc = $&vdc_st12 V, V_OS_out = $&vos_st12 mV
  echo State 15 (1111): $&vpp_st15 Vpp (Clamped), V_OUT_dc = $&vdc_st15 V, V_OS_out = $&vos_st15 mV

  * 4. Pseudo-Resistor Input Resistance & Non-linear R-V Characterization
  echo
  echo --- Phase D: Pseudo-Resistor Characterization (Small-Signal AC & Narrow DC) ---

  * Method 1: Ultra-low Frequency Small-Signal AC (1 mHz)
  alterparam v_g0=0
  alterparam v_g1=0
  alterparam v_g2=0
  alterparam v_g3=0
  reset
  alter @v_inp[acmag] = 1.0
  alter @v_inn[acmag] = 1.0
  save all v_inp#branch v_inn#branch
  ac dec 10 0.001 1k
  let r_ac_p_giga = (1.0 / (abs(v_inp#branch[0]) + 1e-25)) / 1e9
  let r_ac_n_giga = (1.0 / (abs(v_inn#branch[0]) + 1e-25)) / 1e9
  let r_ac_p_mega = r_ac_p_giga * 1000.0
  let r_ac_n_mega = r_ac_n_giga * 1000.0

  echo Method 1 (Small-Signal AC @ 1mHz):
  echo   R_pseudo_AC (VINP - VCM) = $&r_ac_p_mega MOhms ($&r_ac_p_giga GOhms)
  echo   R_pseudo_AC (VINN - VCM) = $&r_ac_n_mega MOhms ($&r_ac_n_giga GOhms)

  * Method 2: Narrow DC Sweep (+/-50mV around VCM) & Dynamic Derivative R = dV / dI
  save all v_inp#branch v_inn#branch
  dc v_inp -50m 50m 0.5m
  let i_branch = -v_inp#branch
  let g_dyn = deriv(i_branch)
  let r_dyn = 1.0 / (g_dyn + 1e-25)
  meas dc r_peak_dc find r_dyn at=0
  meas dc r_m20_dc  find r_dyn at=-20m
  meas dc r_p20_dc  find r_dyn at=20m
  meas dc r_m50_dc  find r_dyn at=-50m
  meas dc r_p50_dc  find r_dyn at=50m

  let r_peak_giga = r_peak_dc / 1e9
  let r_m20_giga  = r_m20_dc / 1e9
  let r_p20_giga  = r_p20_dc / 1e9
  let r_m50_giga  = r_m50_dc / 1e9
  let r_p50_giga  = r_p50_dc / 1e9

  let r_peak_mega = r_peak_dc / 1e6
  let r_m20_mega  = r_m20_dc / 1e6
  let r_p20_mega  = r_p20_dc / 1e6
  let r_m50_mega  = r_m50_dc / 1e6
  let r_p50_mega  = r_p50_dc / 1e6

  echo Method 2 (Narrow DC Sweep Derivative):
  echo   R_pseudo_DC Peak @ 0.000V (Quiescent) = $&r_peak_mega MOhms ($&r_peak_giga GOhms)
  echo   R_pseudo_DC @ -20mV (-20mV vs VCM)    = $&r_m20_mega MOhms ($&r_m20_giga GOhms)
  echo   R_pseudo_DC @ +20mV (+20mV vs VCM)    = $&r_p20_mega MOhms ($&r_p20_giga GOhms)
  echo   R_pseudo_DC @ -50mV (-50mV vs VCM)    = $&r_m50_mega MOhms ($&r_m50_giga GOhms)
  echo   R_pseudo_DC @ +50mV (+50mV vs VCM)    = $&r_p50_mega MOhms ($&r_p50_giga GOhms)

  echo ==========================================================================
  echo === SIMULATION COMPLETE ===
  echo ==========================================================================
.endc

**** end user architecture code
**.ends

* expanding   symbol:  pgia_top.sym # of pins=16
** sym_path: /foss/designs/backup_chipalooza/sg13cmos5l_spma_ip__instramp/xschem/pgia_top/pgia_top.sym
** sch_path: /foss/designs/backup_chipalooza/sg13cmos5l_spma_ip__instramp/xschem/pgia_top/pgia_top.sch
.subckt pgia_top VINP VINN VCM gain_sel[0] gain_sel[1] gain_sel[2] gain_sel[3] VOUT AVDD VPWR IBIAS_IA IBIAS_G1 IBIAS_G2 IBIAS_BUF
+ AVSS VGND
*.iopin AVDD
*.iopin AVSS
*.iopin VPWR
*.iopin VGND
*.ipin VINP
*.ipin VINN
*.ipin VCM
*.ipin gain_sel[0]
*.ipin gain_sel[1]
*.ipin gain_sel[2]
*.ipin gain_sel[3]
*.ipin IBIAS_IA
*.ipin IBIAS_G1
*.ipin IBIAS_G2
*.ipin IBIAS_BUF
*.opin VOUT
x_dec VGND VPWR gain_sel[0] gain_sel[1] gain_sel[2] gain_sel[3] s1[0] s1[1] s1[2] s1[3] s1[4] net1 net2 net3 net4 net5 s2[0] s2[1]
+ s2[2] s2[3] s2[4] net6 net7 net8 net9 net10 gain_decoder_4b
x_ia AVSS AVDD IBIAS_IA VINN V_IA VINP VCM instramp_cmos5l
x_stage1 AVDD AVSS IBIAS_G1 V_IA VCM v_stage1 s1[0] s1[1] s1[2] s1[3] s1[4] gain_stage
x_stage2 AVDD AVSS IBIAS_G2 v_stage1 VCM v_stage2 s2[0] s2[1] s2[2] s2[3] s2[4] gain_stage
x_buf AVDD IBIAS_BUF VOUT v_stage2 VOUT AVSS output_buffer
**** begin user architecture code

* Standard cell models & synthesized gain decoder macro
.include /foss/pdks/ihp-sg13cmos5l/libs.ref/sg13cmos5l_stdcell/spice/sg13cmos5l_stdcell.spice
.include /foss/designs/sg13cmos5l_spma_ip__instramp/gds/gain_decoder_4b/final/spice/gain_decoder_4b.spice

**** end user architecture code
XM1 V_MID_N V_MID_N VCM AVDD sg13_lv_pmos w=0.2u l=2u ng=1 m=1 mm_ok=1
XM2 V_MID_N V_MID_N VINN AVDD sg13_lv_pmos w=0.2u l=2u ng=1 m=1 mm_ok=1
XM3 V_MID_P V_MID_P VINP AVDD sg13_lv_pmos w=0.2u l=2u ng=1 m=1 mm_ok=1
XM4 V_MID_P V_MID_P VCM AVDD sg13_lv_pmos w=0.2u l=2u ng=1 m=1 mm_ok=1
.ends

* expanding   symbol:  instramp_cmos5l.sym # of pins=7
** sym_path: /foss/designs/backup_chipalooza/sg13cmos5l_spma_ip__instramp/xschem/instramp_cmos5l/instramp_cmos5l.sym
** sch_path: /foss/designs/backup_chipalooza/sg13cmos5l_spma_ip__instramp/xschem/instramp_cmos5l/instramp_cmos5l.sch
.subckt instramp_cmos5l VSS VDD IBIAS VINN VOUT VINP CM
*.iopin VDD
*.iopin IBIAS
*.iopin VSS
*.iopin CM
*.iopin VOUT
*.iopin VINN
*.iopin VINP
x1 VSS IBIAS VDD net3 VINP net4 ota_cmos5l
x2 VSS IBIAS VDD net1 VINN net2 ota_cmos5l
x3 VSS IBIAS VDD net5 net6 VOUT ota_cmos5l
XR1 net4 net6 VSS rhigh w=0.5e-6 l=2e-6 m=1 b=0 mm_ok=1
XR2 net2 net5 VSS rhigh w=0.5e-6 l=2e-6 m=1 b=0 mm_ok=1
XR3 net6 CM VSS rhigh w=0.5e-6 l=8*2.23e-6 m=1 b=0 mm_ok=1
XR4 net5 VOUT VSS rhigh w=0.5e-6 l=8*2.23e-6 m=1 b=0 mm_ok=1
XR7 net2 net1 VSS rhigh w=0.5e-6 l=2e-6 m=1 b=0 mm_ok=1
XR8 net4 net3 VSS rhigh w=0.5e-6 l=2e-6 m=1 b=0 mm_ok=1
.ends

* expanding   symbol:  gain_stage.sym # of pins=11
** sym_path: /foss/designs/backup_chipalooza/sg13cmos5l_spma_ip__instramp/xschem/gain_stage/gain_stage.sym
** sch_path: /foss/designs/backup_chipalooza/sg13cmos5l_spma_ip__instramp/xschem/gain_stage/gain_stage.sch
.subckt gain_stage AVDD AVSS IBIAS VIN VCM VOUT s[0] s[1] s[2] s[3] s[4]
*.iopin AVDD
*.iopin AVSS
*.ipin IBIAS
*.ipin VIN
*.ipin VCM
*.opin VOUT
*.ipin s[0]
*.ipin s[1]
*.ipin s[2]
*.ipin s[3]
*.ipin s[4]
x_nor3 nor3_out s[0] s[1] s[2] AVDD AVSS sg13cmos5l_nor3_1
x_nor2 nor2_out s[3] s[4] AVDD AVSS sg13cmos5l_nor2_1
x_and2 S0 nor3_out nor2_out AVDD AVSS sg13cmos5l_and2_1
x1 s[3] s[4] S0 s[1] s[0] s[2] AVDD VCM VIN VOUT IBIAS AVSS gain_network
.ends

* expanding   symbol:  output_buffer.sym # of pins=6
** sym_path: /foss/designs/backup_chipalooza/sg13cmos5l_spma_ip__instramp/xschem/output_buffer/output_buffer.sym
** sch_path: /foss/designs/backup_chipalooza/sg13cmos5l_spma_ip__instramp/xschem/output_buffer/output_buffer.sch
.subckt output_buffer AVDD IBIAS VOUT VIN_BUF+ VIN_BUF- AVSS
*.iopin AVDD
*.iopin AVSS
*.iopin IBIAS
*.iopin VIN_BUF+
*.iopin VIN_BUF-
*.iopin VOUT
x1 AVSS IBIAS AVDD VIN_BUF- VIN_BUF+ VOUT ota_cmos5l
.ends

* expanding   symbol:  ota_cmos5l.sym # of pins=6
** sym_path: /foss/designs/backup_chipalooza/sg13cmos5l_spma_ip__instramp/xschem/output_buffer/ota_cmos5l.sym
** sch_path: /foss/designs/backup_chipalooza/sg13cmos5l_spma_ip__instramp/xschem/output_buffer/ota_cmos5l.sch
.subckt ota_cmos5l VSS IBIAS VDD VINN VINP VOUT
*.iopin IBIAS
*.iopin VDD
*.iopin VSS
*.iopin VOUT
*.iopin VINP
*.iopin VINN
XM6 IBIAS IBIAS VDD VDD sg13_lv_pmos w={wbias} l={lbias} ng=1 m={m6} mm_ok=1
XM7 net1 IBIAS VDD VDD sg13_lv_pmos w={wbias} l={lbias} ng=1 m={m7} mm_ok=1
XM8 VOUT IBIAS VDD VDD sg13_lv_pmos w={wbias} l={lbias} ng=1 m={m8} mm_ok=1
XM1 net2 VINN net1 VDD sg13_lv_pmos w={winpair} l={linpair} ng=1 m=1 mm_ok=1
XM2 net3 VINP net1 VDD sg13_lv_pmos w={winpair} l={linpair} ng=1 m=1 mm_ok=1
XM3 net2 net2 VSS VSS sg13_lv_nmos w={wload} l={lload} ng=1 m=1 mm_ok=1
XM4 net3 net2 VSS VSS sg13_lv_nmos w={wload} l={lload} ng=1 m=1 mm_ok=1
XM5 VOUT net3 VSS VSS sg13_lv_nmos w={wcs} l={lcs} ng=1 m=1 mm_ok=1
XR1 net3 net4 VSS rhigh w=0.5e-6 l=1.95e-6 m=1 b=0 mm_ok=1
.save v(vinp)
.save v(vinn)
.save v(vout)
XC2 VOUT net4 cap_cmomi w=15e-6 l=15e-6 mmin=1 mmax=4 feed=double subblock=0 m=5 mm_ok=1
**** begin user architecture code

.param temp=27
.param lbias=0.15u wbias=0.15u
.param m6=1 m7=4 m8=8
.param linpair=3u winpair=20u
.param lload=5u wload=10u
.param lcs=3u wcs=20u
.param Cc=2p

**** end user architecture code
XC1 VOUT net4 cap_cmomi w=15e-6 l=15e-6 mmin=1 mmax=4 feed=double subblock=0 m=4 mm_ok=1
.ends

* expanding   symbol:  sg13cmos5l_stdcells/sg13cmos5l_nor3_1.sym # of pins=4
** sym_path: /foss/designs/IHP-Open-PDK/ihp-sg13cmos5l/libs.tech/xschem/sg13cmos5l_stdcells/sg13cmos5l_nor3_1.sym
** sch_path: /foss/designs/IHP-Open-PDK/ihp-sg13cmos5l/libs.ref/sg13cmos5l_stdcell/sch/xschem/sg13cmos5l_nor3_1.sch
.subckt sg13cmos5l_nor3_1 Y A B C VDD VSS

*.ipin B
*.opin Y
*.ipin A
*.ipin C
XM1 Y A VSS VSS sg13_lv_nmos w=770.00n l=130.00n ng=1 m=1 mm_ok=1
XM2 Y B VSS VSS sg13_lv_nmos w=770.00n l=130.00n ng=1 m=1 mm_ok=1
XM3 Y C VSS VSS sg13_lv_nmos w=770.00n l=130.00n ng=1 m=1 mm_ok=1
XM4 net1 A VDD VDD sg13_lv_pmos w=1.12u l=130.00n ng=1 m=1 mm_ok=1
XM5 net2 B net1 VDD sg13_lv_pmos w=1.12u l=130.00n ng=1 m=1 mm_ok=1
XM6 Y C net2 VDD sg13_lv_pmos w=1.12u l=130.00n ng=1 m=1 mm_ok=1
.ends

* expanding   symbol:  sg13cmos5l_stdcells/sg13cmos5l_nor2_1.sym # of pins=3
** sym_path: /foss/designs/IHP-Open-PDK/ihp-sg13cmos5l/libs.tech/xschem/sg13cmos5l_stdcells/sg13cmos5l_nor2_1.sym
** sch_path: /foss/designs/IHP-Open-PDK/ihp-sg13cmos5l/libs.ref/sg13cmos5l_stdcell/sch/xschem/sg13cmos5l_nor2_1.sch
.subckt sg13cmos5l_nor2_1 Y A B VDD VSS

*.opin Y
*.ipin B
*.ipin A
XM1 Y A VSS VSS sg13_lv_nmos w=740.00n l=130.00n ng=1 m=1 mm_ok=1
XM2 Y B VSS VSS sg13_lv_nmos w=740.00n l=130.00n ng=1 m=1 mm_ok=1
XM3 net1 A VDD VDD sg13_lv_pmos w=1.12u l=130.00n ng=1 m=1 mm_ok=1
XM4 Y B net1 VDD sg13_lv_pmos w=1.12u l=130.00n ng=1 m=1 mm_ok=1
.ends

* expanding   symbol:  sg13cmos5l_stdcells/sg13cmos5l_and2_1.sym # of pins=3
** sym_path: /foss/designs/IHP-Open-PDK/ihp-sg13cmos5l/libs.tech/xschem/sg13cmos5l_stdcells/sg13cmos5l_and2_1.sym
** sch_path: /foss/designs/IHP-Open-PDK/ihp-sg13cmos5l/libs.ref/sg13cmos5l_stdcell/sch/xschem/sg13cmos5l_and2_1.sch
.subckt sg13cmos5l_and2_1 X A B VDD VSS

*.ipin A
*.ipin B
*.opin X
XM1 net1 A net2 VSS sg13_lv_nmos w=640.00n l=130.00n ng=1 m=1 mm_ok=1
XM2 net2 B VSS VSS sg13_lv_nmos w=640.00n l=130.00n ng=1 m=1 mm_ok=1
XM3 X net1 VSS VSS sg13_lv_nmos w=740.00n l=130.00n ng=1 m=1 mm_ok=1
XM4 net1 B VDD VDD sg13_lv_pmos w=840.00n l=130.00n ng=1 m=1 mm_ok=1
XM5 net1 A VDD VDD sg13_lv_pmos w=840.00n l=130.00n ng=1 m=1 mm_ok=1
XM6 X net1 VDD VDD sg13_lv_pmos w=1.12u l=130.00n ng=1 m=1 mm_ok=1
.ends

* expanding   symbol:  /foss/designs/backup_chipalooza/sg13cmos5l_spma_ip__instramp/xschem/gain_network/gain_network.sym # of
*+ pins=12
** sym_path: /foss/designs/backup_chipalooza/sg13cmos5l_spma_ip__instramp/xschem/gain_network/gain_network.sym
** sch_path: /foss/designs/backup_chipalooza/sg13cmos5l_spma_ip__instramp/xschem/gain_network/gain_network.sch
.subckt gain_network S4 S5 S0 S2 S1 S3 AVDD V_CM V_IN2 V_OUT2 I_BIAS AVSS
*.ipin I_BIAS
*.ipin V_IN2
*.ipin V_CM
*.ipin AVSS
*.ipin AVDD
*.opin V_OUT2
*.ipin S5
*.ipin S4
*.ipin S3
*.ipin S2
*.ipin S1
*.ipin S0
x13 net8 S5 AVDD AVSS sg13cmos5l_inv_1
x12 net9 S4 AVDD AVSS sg13cmos5l_inv_1
x11 net10 S3 AVDD AVSS sg13cmos5l_inv_1
x10 net11 S2 AVDD AVSS sg13cmos5l_inv_1
x9 net12 S1 AVDD AVSS sg13cmos5l_inv_1
x8 net13 S0 AVDD AVSS sg13cmos5l_inv_1
x7 net7 AVSS AVDD S5 net8 net6 tgate l=0.13e-6 wn=0.18e-6 wp=0.54e-6
x6 net7 AVSS AVDD S4 net9 net5 tgate l=0.13e-6 wn=0.18e-6 wp=0.54e-6
x5 net7 AVSS AVDD S3 net10 net4 tgate l=0.13e-6 wn=0.18e-6 wp=0.54e-6
x4 net7 AVSS AVDD S2 net11 net3 tgate l=0.13e-6 wn=0.2e-6 wp=0.6e-6
x3 net7 AVSS AVDD S1 net12 net2 tgate l=0.13e-6 wn=0.3e-6 wp=0.9e-6
x2 net7 AVSS AVDD S0 net13 net1 tgate l=0.13e-6 wn=0.4e-6 wp=1.2e-6
XR6 net5 net4 AVSS rhigh w=0.5e-6 l=54e-6 m=1 b=0 mm_ok=1
XR5 net4 net3 AVSS rhigh w=0.5e-6 l=26.95e-6 m=1 b=0 mm_ok=1
x1 AVDD V_CM net7 V_OUT2 I_BIAS AVSS gain_ota
XR1 net7 V_IN2 AVSS rhigh w=0.5e-6 l=6.66e-6 m=1 b=0 mm_ok=1
XR2 V_OUT2 net1 AVSS rhigh w=0.5e-6 l=3.2e-6 m=1 b=0 mm_ok=1
XR3 net1 net2 AVSS rhigh w=0.5e-6 l=6.66e-6 m=1 b=0 mm_ok=1
XR4 net2 net3 AVSS rhigh w=0.5e-6 l=13.42e-6 m=1 b=0 mm_ok=1
XR7 net14 net5 AVSS rhigh w=0.5e-6 l=54e-6 m=1 b=0 mm_ok=1
XR8 net6 net14 AVSS rhigh w=0.5e-6 l=54e-6 m=1 b=0 mm_ok=1
.ends

* expanding   symbol:  sg13cmos5l_stdcells/sg13cmos5l_inv_1.sym # of pins=2
** sym_path: /foss/designs/IHP-Open-PDK/ihp-sg13cmos5l/libs.tech/xschem/sg13cmos5l_stdcells/sg13cmos5l_inv_1.sym
** sch_path: /foss/designs/IHP-Open-PDK/ihp-sg13cmos5l/libs.ref/sg13cmos5l_stdcell/sch/xschem/sg13cmos5l_inv_1.sch
.subckt sg13cmos5l_inv_1 Y A VDD VSS

*.opin Y
*.ipin A
XM1 Y A VSS VSS sg13_lv_nmos w=740.00n l=130.00n ng=1 m=1 mm_ok=1
XM2 Y A VDD VDD sg13_lv_pmos w=1.12u l=130.00n ng=1 m=1 mm_ok=1
.ends

* expanding   symbol:  tgate.sym # of pins=6
** sym_path: /foss/designs/backup_chipalooza/sg13cmos5l_spma_ip__instramp/xschem/tgate/tgate.sym
** sch_path: /foss/designs/backup_chipalooza/sg13cmos5l_spma_ip__instramp/xschem/tgate/tgate.sch
.subckt tgate IN AVSS AVDD EN ENB OUT  l=0.13e-6 wn=1e-6 wp=3e-6
*.iopin AVDD
*.iopin AVSS
*.iopin IN
*.iopin OUT
*.ipin EN
*.ipin ENB
XM1 IN EN OUT AVSS sg13_lv_nmos w=wn l=l ng=1 m=1 mm_ok=1
XM2 OUT ENB IN AVDD sg13_lv_pmos w=wp l=l ng=1 m=1 mm_ok=1
.ends

* expanding   symbol:  /foss/designs/sg13cmos5l_spma_ip__instramp/xschem/gain_ota/gain_ota.sym # of pins=6
** sym_path: /foss/designs/sg13cmos5l_spma_ip__instramp/xschem/gain_ota/gain_ota.sym
** sch_path: /foss/designs/sg13cmos5l_spma_ip__instramp/xschem/gain_ota/gain_ota.sch
.subckt gain_ota VDD V_inp V_inn V_out I_bias VSS
*.ipin V_inn
*.ipin VDD
*.ipin VSS
*.opin V_out
*.ipin I_bias
*.ipin V_inp
XM1 F1 V_inn net6 VDD sg13_lv_pmos w=26.56u l=2u ng=4 m=1 mm_ok=1
XM2 F2 V_inp net6 VDD sg13_lv_pmos w=26.56u l=2u ng=4 m=1 mm_ok=1
XM3 net5 net5 VDD VDD sg13_lv_pmos w=7.33u l=2u ng=1 m=1 mm_ok=1
XM4 N_A net5 VDD VDD sg13_lv_pmos w=7.33u l=2u ng=1 m=1 mm_ok=1
XM7 F1 V_bn2 VSS VSS sg13_lv_nmos w=9.21u l=2u ng=1 m=1 mm_ok=1
XM8 F2 V_bn2 VSS VSS sg13_lv_nmos w=9.21u l=2u ng=1 m=1 mm_ok=1
XM_tail net6 V_btail VDD VDD sg13_lv_pmos w=7.46u l=2u ng=1 m=8 mm_ok=1
XM_ctrlp N_B V_ctrlp N_A VDD sg13_lv_pmos w=2.20u l=0.50u ng=1 m=1 mm_ok=1
XM_outp V_out N_A VDD VDD sg13_lv_pmos w=22.20u l=0.5u ng=4 m=1 mm_ok=1
XM_ctrln N_A V_ctrln N_B VSS sg13_lv_nmos w=0.84u l=0.5u ng=1 m=1 mm_ok=1
XM_outn V_out N_B VSS VSS sg13_lv_nmos w=8.4u l=0.5u ng=1 m=1 mm_ok=1
XM5 net5 V_bn1 F1 VSS sg13_lv_nmos w=6.41u l=2u ng=1 m=1 mm_ok=1
XM6 N_A V_bn1 F2 VSS sg13_lv_nmos w=6.41u l=2u ng=1 m=1 mm_ok=1
XM_mp1 net1 net1 VDD VDD sg13_lv_pmos w=2.30u l=2u ng=1 m=1 mm_ok=1
XM_mn1 net1 I_bias VSS VSS sg13_lv_nmos w=0.87u l=2u ng=1 m=1 mm_ok=1
XM_refn I_bias I_bias VSS VSS sg13_lv_nmos w=0.87u l=2u ng=1 m=1 mm_ok=1
XM_mp2 V_bn1 net1 VDD VDD sg13_lv_pmos w=11.50u l=2u ng=2 m=1 mm_ok=1
XM_mp3 V_bn2 net1 VDD VDD sg13_lv_pmos w=23u l=2u ng=4 m=1 mm_ok=1
XM_bn1 V_bn1 V_bn1 net2 VSS sg13_lv_nmos w=1.60u l=2u ng=1 m=1 mm_ok=1
XM_bn2 V_bn2 V_bn2 VSS VSS sg13_lv_nmos w=9.21u l=2u ng=1 m=1 mm_ok=1
XM_mn2 V_btail I_bias VSS VSS sg13_lv_nmos w=6u l=2u ng=1 m=1 mm_ok=1
XM_rep_tail V_btail V_btail VDD VDD sg13_lv_pmos w=7.46u l=2u ng=1 m=8 mm_ok=1
XM_mn4 N_B I_bias VSS VSS sg13_lv_nmos w=3.2u l=2u ng=1 m=1 mm_ok=1
XR1 net2 VSS VSS rhigh w=0.5e-6 l=15e-6 m=1 b=0 mm_ok=1
XM_mp4 V_ctrln net1 VDD VDD sg13_lv_pmos w=4.60u l=2u ng=1 m=1 mm_ok=1
XM_rep_ctrln V_ctrln V_ctrln net3 VSS sg13_lv_nmos w=0.84u l=0.5u ng=1 m=1 mm_ok=1
XM_rep_outn net3 net3 VSS VSS sg13_lv_nmos w=2.10u l=0.5u ng=1 m=1 mm_ok=1
XM_mn3 V_ctrlp I_bias VSS VSS sg13_lv_nmos w=1.74u l=2u ng=1 m=1 mm_ok=1
XM_rep_outp net4 net4 VDD VDD sg13_lv_pmos w=5.55u l=0.5u ng=1 m=1 mm_ok=1
XM_rep_ctrlp V_ctrlp V_ctrlp net4 VDD sg13_lv_pmos w=2.20u l=0.50u ng=1 m=1 mm_ok=1
XM_mp5 N_A net1 VDD VDD sg13_lv_pmos w=9.21u l=2u ng=1 m=1 mm_ok=1
XR2 N_A net7 VSS rhigh w=0.5e-6 l=4e-6 m=1 b=0 mm_ok=1
XC3 F2 V_out cap_cmomi w=25e-6 l=25e-6 mmin=1 mmax=4 feed=double subblock=0 m=1 mm_ok=1
XC4 net7 V_out cap_cmomi w=8.5e-6 l=8.5e-6 mmin=1 mmax=4 feed=double subblock=0 m=4 mm_ok=1
.ends

.end
