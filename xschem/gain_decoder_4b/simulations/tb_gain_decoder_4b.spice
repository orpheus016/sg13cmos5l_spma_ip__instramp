** sch_path: /foss/designs/Chipalooza/Programmable-Instrumentation-Amplifier-IP/xschem/gain_decoder_4b/tb_gain_decoder_4b.sch
**.subckt tb_gain_decoder_4b
x1 0 VPWR gain_sel[0] gain_sel[1] gain_sel[2] gain_sel[3] s1[0] s1[1] s1[2] s1[3] s1[4] s1_b[0] s1_b[1] s1_b[2] s1_b[3] s1_b[4]
+ s2[0] s2[1] s2[2] s2[3] s2[4] s2_b[0] s2_b[1] s2_b[2] s2_b[3] s2_b[4] gain_decoder_4b
**** begin user architecture code

* Power supply
VVDD VPWR 0 1.2

* Binary input pulse sources (16 states sweep 0 to 15 over 320ns, 20ns per state)
* Period = 2 * step_width
* State 0: 0000 (0 to 20ns)
* State 1: 0001 (20 to 40ns), etc.
V0 gain_sel[0] 0 PULSE(0 1.2 20n 100p 100p 20n 40n)
V1 gain_sel[1] 0 PULSE(0 1.2 40n 100p 100p 40n 80n)
V2 gain_sel[2] 0 PULSE(0 1.2 80n 100p 100p 80n 160n)
V3 gain_sel[3] 0 PULSE(0 1.2 160n 100p 100p 160n 320n)

* Output 10fF load capacitors
C_s1_0 s1[0] 0 10f
C_s1_1 s1[1] 0 10f
C_s1_2 s1[2] 0 10f
C_s1_3 s1[3] 0 10f
C_s1_4 s1[4] 0 10f

C_s1_b0 s1_b[0] 0 10f
C_s1_b1 s1_b[1] 0 10f
C_s1_b2 s1_b[2] 0 10f
C_s1_b3 s1_b[3] 0 10f
C_s1_b4 s1_b[4] 0 10f

C_s2_0 s2[0] 0 10f
C_s2_1 s2[1] 0 10f
C_s2_2 s2[2] 0 10f
C_s2_3 s2[3] 0 10f
C_s2_4 s2[4] 0 10f

C_s2_b0 s2_b[0] 0 10f
C_s2_b1 s2_b[1] 0 10f
C_s2_b2 s2_b[2] 0 10f
C_s2_b3 s2_b[3] 0 10f
C_s2_b4 s2_b[4] 0 10f

* Standard cell models & extracted layout macro
.include /foss/pdks/ihp-sg13cmos5l/libs.ref/sg13cmos5l_stdcell/spice/sg13cmos5l_stdcell.spice
.include /foss/designs/Chipalooza/Programmable-Instrumentation-Amplifier-IP/gds/gain_decoder_4b/final/spice/gain_decoder_4b.spice
.lib /foss/pdks/ihp-sg13cmos5l/libs.tech/ngspice/models/cornerMOSlv.lib mos_tt

.control
  tran 100p 320n
  remzerovec
  write tb_gain_decoder_4b.raw
  echo SIMULATION_COMPLETE
.endc

**** end user architecture code
**.ends
.end
