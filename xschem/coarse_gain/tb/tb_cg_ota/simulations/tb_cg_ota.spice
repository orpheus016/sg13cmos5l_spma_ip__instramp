** sch_path: /foss/designs/sg13cmos5l_spma_ip__instramp/xschem/coarse_gain/tb/tb_cg_ota/tb_cg_ota.sch
**.subckt tb_cg_ota
I0 VDD I_B {ib}
V2 VDD 0 {vdd}
V5 VINP3 VSS {vicm}
C2 OUT3 VSS {cl}
V3 VSS 0 0
x3 VDD VINP3 OUT3 OUT3 I_B VSS cg_ota
**** begin user architecture code

.param temp=27
.param cl=2p
.param ib=1u
.param vdd=1.2
.param vicm=vdd/2
.param vid=0

.subckt loopgainprobe a b
Ii 0 x DC 0 AC 0
Vi x a DC 0 AC 1
Vnodebuffer b x 0
.ends loopgainprobe

.func tian_loop() {1/(1/(2*(ac1.i(v.x999.Vi)*ac2.v(x999.x)-ac1.v(x999.x)*ac2.i(v.x999.Vi))+ac1.v(x999.x)+ac2.i(v.x999.Vi))-1)}

* ===============================================================
* MONTE CARLO MISMATCH & PROCESS SIMULATION
* Topology: Closed-Loop Unity-Gain Follower (x3)
* PDK     : IHP SG13CMOSL (PSP103 via OSDI)
* ===============================================================

* Critical IHP PDK parameter switches to activate statistical variations
.param mm_ok=1
.param mc_ok=1
.param temp=27

.control
* 1. Clear previous session datasets and prepare output directory
destroy all
save all
shell mkdir -p result

echo "======================================================="
echo "   STARTING MONTE CARLO SIMULATION (OTA FOLLOWER)      "
echo "======================================================="

* 2. Initialize iteration counter and dedicated scratch plot
let mc_runs = 100
let run = 0

* Create a dedicated container plot to safely aggregate all run results
set curplot = new
set scratch = $curplot
setplot $scratch

* Pre-allocate vectors in the scratch plot
let vos_vec = unitvec(mc_runs)
let iq_vec  = unitvec(mc_runs)

* Initialize summary text file header
echo "Run_ID  Vos_mV      Iq_uA" >> ./result/tb_cg_ota_mc.txt

* ===============================================================
* 3. MONTE CARLO EXECUTION LOOP
* ===============================================================
dowhile run < mc_runs
  set rnd_seed=$&run
  * Execute DC operating point (evaluates new statistical sample)
  op

  * Capture current loop index and temporary plot pointer
  set run_idx = $&run
  set dt = $curplot

  * Calculate parameters inside the active op dataset ($dt)
  setplot $dt
  let cur_vos = (v(vinp3) - v(out3)) * 1000
  let cur_iq  = -i(v2) * 1e6

  * Lock values to shell variables while still in $dt plot context
  set s_vos = "$&cur_vos"
  set s_iq  = "$&cur_iq"

  * Switch context to scratch plot and store scalar values into arrays
  setplot $scratch
  let vos_vec[run] = {$dt}.cur_vos
  let iq_vec[run]  = {$dt}.cur_iq

  * Append individual iteration data to text log
  set s_idx = "$&run"
  echo "$s_idx   $s_vos   $s_iq" >> ./result/tb_cg_ota_mc.txt

  * Return to run plot and clear circuit state for next sample
  setplot $dt
  reset

  let run = run + 1
end

* ===============================================================
* 4. STATISTICAL POST-PROCESSING (IN SCRATCH PLOT)
* ===============================================================
setplot $scratch

* A. Mean calculation (mu)
let sum_vos = 0
let sum_iq  = 0
let i = 0
dowhile i < mc_runs
  let sum_vos = sum_vos + vos_vec[i]
  let sum_iq  = sum_iq  + iq_vec[i]
  let i = i + 1
end
let mean_vos = sum_vos / mc_runs
let mean_iq  = sum_iq  / mc_runs

* B. Sample standard deviation calculation (sigma)
let sum_sq_vos = 0
let sum_sq_iq  = 0
let i = 0
dowhile i < mc_runs
  let diff_vos = vos_vec[i] - mean_vos
  let diff_iq  = iq_vec[i]  - mean_iq
  let sum_sq_vos = sum_sq_vos + (diff_vos * diff_vos)
  let sum_sq_iq  = sum_sq_iq  + (diff_iq  * diff_iq)
  let i = i + 1
end
let sigma_vos = sqrt(sum_sq_vos / (mc_runs - 1))
let sigma_iq  = sqrt(sum_sq_iq  / (mc_runs - 1))
let span_6sigma_vos = 6 * sigma_vos

* C. Extreme values search across the allocated array
let min_vos = vos_vec[0]
let max_vos = vos_vec[0]
let k = 1
dowhile k < mc_runs
  if vos_vec[k] < min_vos
    let min_vos = vos_vec[k]
  end
  if vos_vec[k] > max_vos
    let max_vos = vos_vec[k]
  end
  let k = k + 1
end

* ===============================================================
* 5. STATISTICAL SUMMARY REPORT
* ===============================================================
echo "======================================================="
echo "       MONTE CARLO STATISTICAL ANALYSIS RESULTS        "
echo "======================================================="
echo " Total Iterations (Runs)     : " $&mc_runs
echo "-------------------------------------------------------"
echo " INPUT OFFSET VOLTAGE (Vos) DISTRIBUTION:"
echo "   - Mean / Systematic (mu)  : " $&mean_vos " mV"
echo "   - Std Deviation (sigma)   : " $&sigma_vos " mV"
echo "   - Full Spread (6*sigma)   : " $&span_6sigma_vos " mV"
echo "   - Minimum Measured Offset : " $&min_vos " mV"
echo "   - Maximum Measured Offset : " $&max_vos " mV"
echo "-------------------------------------------------------"
echo " TOTAL QUIESCENT CURRENT (Iq) DISTRIBUTION:"
echo "   - Mean Quiescent Current  : " $&mean_iq " uA"
echo "   - Std Deviation (sigma)   : " $&sigma_iq " uA"
echo "======================================================="
echo " Numerical dataset exported to: ./result/tb_cg_ota_mc.txt"
echo "======================================================="

* Save aggregated scratch vectors into rawfile and CSV format
write ./result/tb_cg_ota_mc.raw {$scratch}.vos_vec {$scratch}.iq_vec
wrdata ./result/tb_cg_ota_mc.csv {$scratch}.vos_vec {$scratch}.iq_vec

.endc

.lib /foss/designs/IHP-Open-PDK/ihp-sg13cmos5l/libs.tech/ngspice/models/cornerMOSlv.lib mos_tt
.lib /foss/designs/IHP-Open-PDK/ihp-sg13cmos5l/libs.tech/ngspice/models/cornerMOShv.lib mos_tt
.lib /foss/designs/IHP-Open-PDK/ihp-sg13cmos5l/libs.tech/ngspice/models/cornerRES.lib res_typ_mismatch
.lib /foss/designs/IHP-Open-PDK/ihp-sg13cmos5l/libs.tech/ngspice/models/cornerRES.lib res_stat
.lib /foss/designs/IHP-Open-PDK/ihp-sg13cmos5l/libs.tech/ngspice/models/cornerDIO.lib dio_tt
.lib /foss/designs/IHP-Open-PDK/ihp-sg13cmos5l/libs.tech/ngspice/models/cornerCAP.lib cap_typ
.lib /foss/designs/IHP-Open-PDK/ihp-sg13cmos5l/libs.tech/ngspice/models/cornerMOSCAP.lib moscap_tt_mismatch
.lib /foss/designs/IHP-Open-PDK/ihp-sg13cmos5l/libs.tech/ngspice/models/cornerMOSCAP.lib moscap_tt_stat

**** end user architecture code
**.ends

* expanding   symbol:  /foss/designs/sg13cmos5l_spma_ip__instramp/xschem/coarse_gain/cg_ota.sym # of pins=6
** sym_path: /foss/designs/sg13cmos5l_spma_ip__instramp/xschem/coarse_gain/cg_ota.sym
** sch_path: /foss/designs/sg13cmos5l_spma_ip__instramp/xschem/coarse_gain/cg_ota.sch
.subckt cg_ota VDD V_inp V_inn V_out I_bias VSS
*.ipin V_inn
*.ipin VDD
*.ipin VSS
*.opin V_out
*.ipin I_bias
*.ipin V_inp
XM1 F1 V_inn net6 VDD sg13_lv_pmos w=26.56u l=2u ng=4 m=1 mm_ok=1
XM2 F2 V_inp net6 VDD sg13_lv_pmos w=26.56u l=2u ng=4 m=1 mm_ok=1
XM3 net5 net5 VDD VDD sg13_lv_pmos w=7.33u l=2u ng=1 m=1 mm_ok=1
XM4 N_A net5 VDD VDD sg13_lv_pmos w=7.33u l=2u ng=1 m=1 mm_ok=1
XM7 F1 V_bn2 VSS VSS sg13_lv_nmos w=9.21u l=2u ng=1 m=1 mm_ok=1
XM8 F2 V_bn2 VSS VSS sg13_lv_nmos w=9.21u l=2u ng=1 m=1 mm_ok=1
XM_tail net6 V_btail VDD VDD sg13_lv_pmos w=7.46u l=2u ng=1 m=8 mm_ok=1
XM_ctrlp N_B V_ctrlp N_A VDD sg13_lv_pmos w=2.20u l=0.50u ng=1 m=1 mm_ok=1
XM_outp V_out N_A VDD VDD sg13_lv_pmos w=22.20u l=0.5u ng=4 m=1 mm_ok=1
XM_ctrln N_A V_ctrln N_B VSS sg13_lv_nmos w=0.84u l=0.5u ng=1 m=1 mm_ok=1
XM_outn V_out N_B VSS VSS sg13_lv_nmos w=8.4u l=0.5u ng=1 m=1 mm_ok=1
XM5 net5 V_bn1 F1 VSS sg13_lv_nmos w=6.41u l=2u ng=1 m=1 mm_ok=1
XM6 N_A V_bn1 F2 VSS sg13_lv_nmos w=6.41u l=2u ng=1 m=1 mm_ok=1
XM_mp1 net1 net1 VDD VDD sg13_lv_pmos w=2.30u l=2u ng=1 m=1 mm_ok=1
XM_mn1 net1 I_bias VSS VSS sg13_lv_nmos w=0.87u l=2u ng=1 m=1 mm_ok=1
XM_refn I_bias I_bias VSS VSS sg13_lv_nmos w=0.87u l=2u ng=1 m=1 mm_ok=1
XM_mp2 V_bn1 net1 VDD VDD sg13_lv_pmos w=11.50u l=2u ng=2 m=1 mm_ok=1
XM_mp3 V_bn2 net1 VDD VDD sg13_lv_pmos w=23u l=2u ng=4 m=1 mm_ok=1
XM_bn1 V_bn1 V_bn1 net2 VSS sg13_lv_nmos w=1.60u l=2u ng=1 m=1 mm_ok=1
XM_bn2 V_bn2 V_bn2 VSS VSS sg13_lv_nmos w=9.21u l=2u ng=1 m=1 mm_ok=1
XM_mn2 V_btail I_bias VSS VSS sg13_lv_nmos w=6u l=2u ng=1 m=1 mm_ok=1
XM_rep_tail V_btail V_btail VDD VDD sg13_lv_pmos w=7.46u l=2u ng=1 m=8 mm_ok=1
XM_mn4 N_B I_bias VSS VSS sg13_lv_nmos w=3.2u l=2u ng=1 m=1 mm_ok=1
XR1 net2 VSS VSS rhigh w=0.5e-6 l=15e-6 m=1 b=0 mm_ok=1
XM_mp4 V_ctrln net1 VDD VDD sg13_lv_pmos w=4.60u l=2u ng=1 m=1 mm_ok=1
XM_rep_ctrln V_ctrln V_ctrln net3 VSS sg13_lv_nmos w=0.84u l=0.5u ng=1 m=1 mm_ok=1
XM_rep_outn net3 net3 VSS VSS sg13_lv_nmos w=2.10u l=0.5u ng=1 m=1 mm_ok=1
XM_mn3 V_ctrlp I_bias VSS VSS sg13_lv_nmos w=1.74u l=2u ng=1 m=1 mm_ok=1
XM_rep_outp net4 net4 VDD VDD sg13_lv_pmos w=5.55u l=0.5u ng=1 m=1 mm_ok=1
XM_rep_ctrlp V_ctrlp V_ctrlp net4 VDD sg13_lv_pmos w=2.20u l=0.50u ng=1 m=1 mm_ok=1
XM_mp5 N_A net1 VDD VDD sg13_lv_pmos w=9.21u l=2u ng=1 m=1 mm_ok=1
XR2 N_A net7 VSS rhigh w=0.5e-6 l=4e-6 m=1 b=0 mm_ok=1
XC3 F2 V_out cap_cmomi w=12.5e-6 l=12.5e-6 mmin=1 mmax=4 feed=double subblock=0 m=4 mm_ok=1
XC4 net7 V_out cap_cmomi w=8.5e-6 l=8.5e-6 mmin=1 mmax=4 feed=double subblock=0 m=4 mm_ok=1
.ends

.GLOBAL VDD
.end
