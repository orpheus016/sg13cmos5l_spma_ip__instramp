** sch_path: /foss/designs/sg13cmos5l_spma_ip__instramp/xschem/coarse_gain/tb/tb_cg_network/tb_cg_network.sch
**.subckt tb_cg_network
I0 VDD I_B {ib}
V2 VDD 0 {vdd}
V3 VSS 0 0
V1 VCM VSS {vicm}
C1 OUT2 VSS {cl}
VS1 S0 VSS 0
VS2 S1 VSS 0
VS3 S2 VSS 0
VS4 S3 VSS 0
VS5 S4 VSS 0
VS6 S5 VSS 0
V4 IN2 VSS DC 0.6 AC 1
x1 S4 S5 S0 S2 S1 S3 VDD VCM IN2 OUT2 I_B VSS cg_network
**** begin user architecture code

.param temp=27
.param cl=2p
.param ib=1u
.param vdd=1.2
.param vicm=vdd/2
.param vid=0

.lib /foss/designs/IHP-Open-PDK/ihp-sg13cmos5l/libs.tech/ngspice/models/cornerMOSlv.lib mos_tt
.lib /foss/designs/IHP-Open-PDK/ihp-sg13cmos5l/libs.tech/ngspice/models/cornerMOShv.lib mos_tt
.lib /foss/designs/IHP-Open-PDK/ihp-sg13cmos5l/libs.tech/ngspice/models/cornerRES.lib res_typ
.lib /foss/designs/IHP-Open-PDK/ihp-sg13cmos5l/libs.tech/ngspice/models/cornerDIO.lib dio_tt
.lib /foss/designs/IHP-Open-PDK/ihp-sg13cmos5l/libs.tech/ngspice/models/cornerCAP.lib cap_typ
.lib /foss/designs/IHP-Open-PDK/ihp-sg13cmos5l/libs.tech/ngspice/models/cornerMOSCAP.lib moscap_tt

* ==============================================================================
* BINARY GAIN-STAGE NETWORK (PGA) 6-TAP AC & DC TELEMETRY CHARACTERIZATION
* Topology  : Inverting Switched-Resistor Feedback Ladder (R to 32R)
* Step Size : Pure Binary Stepping (+6.0206 dB / 2x Gain per Step)
* Technology: IHP SG13CMOS5L (130nm BiCMOS)
* ==============================================================================

.control
destroy all
save all
shell mkdir -p result
shell rm -f ./result/tb_cg_network_summary.txt

* Initialize summary report table header
echo "==================================================================================================================================" >> ./result/tb_cg_network_summary.txt
echo " Tap   Code   Target(dB)   Meas(dB)   Err(dB)    Err(Step)   Acc_FS(%)   -3dB BW(kHz)   Vos_out(mV)   V_vg_err(mV)   P_dc(uW) " >> ./result/tb_cg_network_summary.txt
echo "==================================================================================================================================" >> ./result/tb_cg_network_summary.txt

echo "=================================================================================================================================="
echo " STARTING BINARY GAIN-STAGE AC & DC CHARACTERIZATION (R TO 32R, S0 TO S5)                                                        "
echo "=================================================================================================================================="

* ------------------------------------------------------------------------------
* STEP 0: DC OFFSET PRE-CALIBRATION (NOMINAL TAP S0 AT 0 dB)
* ------------------------------------------------------------------------------
alter @vs1[dc] = 1.2
alter @vs2[dc] = 0
alter @vs3[dc] = 0
alter @vs4[dc] = 0
alter @vs5[dc] = 0
alter @vs6[dc] = 0

op
let v_vg_nominal = v(x1.net7)
echo " Calibrated Input DC Bias to Virtual Ground: " $&v_vg_nominal " V"

alter @v4[dc] = $&v_vg_nominal

set appendwrite

* ------------------------------------------------------------------------------
* STEP 1: SEQUENTIAL 6-TAP BINARY EVALUATION LOOP (S0 TO S5)
* ------------------------------------------------------------------------------
foreach tap 0 1 2 3 4 5

  * 1. Reset all 6 control switch gate voltages to 0V (OFF state)
  alter @vs1[dc] = 0
  alter @vs2[dc] = 0
  alter @vs3[dc] = 0
  alter @vs4[dc] = 0
  alter @vs5[dc] = 0
  alter @vs6[dc] = 0

  * 2. Assert active binary tap
  if ($tap = 0)
    alter @vs1[dc] = 1.2
  end
  if ($tap = 1)
    alter @vs2[dc] = 1.2
  end
  if ($tap = 2)
    alter @vs3[dc] = 1.2
  end
  if ($tap = 3)
    alter @vs4[dc] = 1.2
  end
  if ($tap = 4)
    alter @vs5[dc] = 1.2
  end
  if ($tap = 5)
    alter @vs6[dc] = 1.2
  end

  * 3. DC Operating Point Analysis
  op
  let cur_vos_mv = (v(out2) - v(vcm)) * 1e3
  let cur_vvg_mv = (v(x1.net7) - v(vcm)) * 1e3
  let cur_pdc_uw = -i(v2) * 1.2 * 1e6

  * Lock DC variables to shell environment BEFORE plot context switches to AC
  set s_vos = "$&cur_vos_mv"
  set s_vvg = "$&cur_vvg_mv"
  set s_pdc = "$&cur_pdc_uw"

  * 4. Small-Signal AC Frequency Response Analysis
  ac dec 30 10 100MEG

  let gain_db = db(v(out2))
  let ph_deg  = cph(v(out2)) * 180 / pi

  * Measure midband flatband gain at 1 kHz
  meas ac g_meas_db find gain_db at=1k

  * Measure -3 dB cutoff bandwidth
  let target_3db = g_meas_db - 3
  meas ac f_3db when gain_db=target_3db
  let f_3db_khz = f_3db / 1e3

  * 5. Binary Gain Metrics & dB-Based Error Computation
  let ideal_lin = 2^($tap)
  let ideal_db  = db(ideal_lin)
  let err_db    = g_meas_db - ideal_db
  let err_step  = err_db / 6.0206
  let acc_fs    = 100 - (abs(err_db) / 30.103 * 100)

  * Save curves into consolidated multi-run rawfile
  write ./result/tb_cg_network_all_taps.raw gain_db ph_deg

  * Lock remaining AC variables to shell environment
  set s_ideal = "$&ideal_db"
  set s_meas  = "$&g_meas_db"
  set s_err   = "$&err_db"
  set s_step  = "$&err_step"
  set s_acc   = "$&acc_fs"
  set s_f3db  = "$&f_3db_khz"

  * Print progress to terminal
  echo " S$tap | Target: $s_ideal dB | Meas: $s_meas dB | Err: $s_err dB ($s_step LSB) | BW: $s_f3db kHz | Vos: $s_vos mV"

  * Append telemetry row to text report
  echo " S$tap   | $tap    | $s_ideal       | $s_meas       | $s_err     | $s_step     | $s_acc    | $s_f3db        | $s_vos       | $s_vvg       | $s_pdc" >> ./result/tb_cg_network_summary.txt

end

unset appendwrite
echo "=================================================================================================================================="
echo " CHARACTERIZATION COMPLETED! Full telemetry log is exported to:                                                                 "
echo " ./result/tb_cg_network_summary.txt                                                                                             "
echo " Frequency response waveforms saved to: ./result/tb_cg_network_all_taps.raw                                                     "
echo "=================================================================================================================================="
.endc

.include $PDK_ROOT/$PDK/libs.ref/sg13cmos5l_stdcell/spice/sg13cmos5l_stdcell.spice

**** end user architecture code
**.ends

* expanding   symbol:  /foss/designs/sg13cmos5l_spma_ip__instramp/xschem/coarse_gain/cg_network.sym # of pins=12
** sym_path: /foss/designs/sg13cmos5l_spma_ip__instramp/xschem/coarse_gain/cg_network.sym
** sch_path: /foss/designs/sg13cmos5l_spma_ip__instramp/xschem/coarse_gain/cg_network.sch
.subckt cg_network S4 S5 S0 S2 S1 S3 AVDD V_CM V_IN2 V_OUT2 I_BIAS AVSS
*.ipin I_BIAS
*.ipin V_IN2
*.ipin V_CM
*.ipin AVSS
*.ipin AVDD
*.opin V_OUT2
*.ipin S5
*.ipin S4
*.ipin S3
*.ipin S2
*.ipin S1
*.ipin S0
XR7 net6 net5 AVSS rhigh w=0.5e-6 l=10.72e-6 m=1 b=0 mm_ok=1
XR3 net2 net1 AVSS rppd w=2e-6 l=15.16e-6 m=1 b=0 mm_ok=1
XR2 net1 V_OUT2 AVSS rppd w=2e-6 l=7e-6 m=1 b=0 mm_ok=1
XR1 net7 V_IN2 AVSS rppd w=2e-6 l=15.16e-6 m=1 b=0 mm_ok=1
x13 net8 S5 AVDD AVSS sg13cmos5l_inv_1
x12 net9 S4 AVDD AVSS sg13cmos5l_inv_1
x11 net10 S3 AVDD AVSS sg13cmos5l_inv_1
x10 net11 S2 AVDD AVSS sg13cmos5l_inv_1
x9 net12 S1 AVDD AVSS sg13cmos5l_inv_1
x8 net13 S0 AVDD AVSS sg13cmos5l_inv_1
x7 net7 AVSS AVDD S5 net8 net6 tgate l=0.13e-6 wn=0.9e-6 wp=2.7e-6
x6 net7 AVSS AVDD S4 net9 net5 tgate l=0.13e-6 wn=1.5e-6 wp=4.5e-6
x5 net7 AVSS AVDD S3 net10 net4 tgate l=0.13e-6 wn=2.2e-6 wp=6.6e-6
x4 net7 AVSS AVDD S2 net11 net3 tgate l=0.13e-6 wn=2.6e-6 wp=7.8e-6
x3 net7 AVSS AVDD S1 net12 net2 tgate l=0.13e-6 wn=2.9e-6 wp=8.7e-6
x2 net7 AVSS AVDD S0 net13 net1 tgate l=0.13e-6 wn=3e-6 wp=9e-6
XR6 net5 net4 AVSS rhigh w=0.5e-6 l=5.3e-6 m=1 b=0 mm_ok=1
XR5 net4 net3 AVSS rhigh w=0.5e-6 l=2.6e-6 m=1 b=0 mm_ok=1
XR4 net3 net2 AVSS rhigh w=0.5e-6 l=1.25e-6 m=1 b=0 mm_ok=1
x1 AVDD V_CM net7 V_OUT2 I_BIAS AVSS cg_ota
.ends

* expanding   symbol:  /foss/designs/sg13cmos5l_spma_ip__instramp/xschem/tgate/tgate.sym # of pins=6
** sym_path: /foss/designs/sg13cmos5l_spma_ip__instramp/xschem/tgate/tgate.sym
** sch_path: /foss/designs/sg13cmos5l_spma_ip__instramp/xschem/tgate/tgate.sch
.subckt tgate IN AVSS AVDD EN ENB OUT  l=0.13e-6 wn=1e-6 wp=3e-6
*.iopin AVDD
*.iopin AVSS
*.iopin IN
*.iopin OUT
*.ipin EN
*.ipin ENB
XM1 IN EN OUT AVSS sg13_lv_nmos w=wn l=l ng=1 m=1 mm_ok=1
XM2 OUT ENB IN AVDD sg13_lv_pmos w=wp l=l ng=1 m=1 mm_ok=1
.ends

* expanding   symbol:  /foss/designs/sg13cmos5l_spma_ip__instramp/xschem/coarse_gain/cg_ota.sym # of pins=6
** sym_path: /foss/designs/sg13cmos5l_spma_ip__instramp/xschem/coarse_gain/cg_ota.sym
** sch_path: /foss/designs/sg13cmos5l_spma_ip__instramp/xschem/coarse_gain/cg_ota.sch
.subckt cg_ota VDD V_inp V_inn V_out I_bias VSS
*.ipin V_inn
*.ipin VDD
*.ipin VSS
*.opin V_out
*.ipin I_bias
*.ipin V_inp
XM1 F1 V_inn net6 VDD sg13_lv_pmos w=26.56u l=2u ng=4 m=1 mm_ok=1
XM2 F2 V_inp net6 VDD sg13_lv_pmos w=26.56u l=2u ng=4 m=1 mm_ok=1
XM3 net5 net5 VDD VDD sg13_lv_pmos w=7.33u l=2u ng=1 m=1 mm_ok=1
XM4 N_A net5 VDD VDD sg13_lv_pmos w=7.33u l=2u ng=1 m=1 mm_ok=1
XM7 F1 V_bn2 VSS VSS sg13_lv_nmos w=9.21u l=2u ng=1 m=1 mm_ok=1
XM8 F2 V_bn2 VSS VSS sg13_lv_nmos w=9.21u l=2u ng=1 m=1 mm_ok=1
XM_tail net6 V_btail VDD VDD sg13_lv_pmos w=7.46u l=2u ng=1 m=8 mm_ok=1
XM_ctrlp N_B V_ctrlp N_A VDD sg13_lv_pmos w=2.20u l=0.50u ng=1 m=1 mm_ok=1
XM_outp V_out N_A VDD VDD sg13_lv_pmos w=22.20u l=0.5u ng=4 m=1 mm_ok=1
XM_ctrln N_A V_ctrln N_B VSS sg13_lv_nmos w=0.84u l=0.5u ng=1 m=1 mm_ok=1
XM_outn V_out N_B VSS VSS sg13_lv_nmos w=8.4u l=0.5u ng=1 m=1 mm_ok=1
XM5 net5 V_bn1 F1 VSS sg13_lv_nmos w=6.41u l=2u ng=1 m=1 mm_ok=1
XM6 N_A V_bn1 F2 VSS sg13_lv_nmos w=6.41u l=2u ng=1 m=1 mm_ok=1
XM_mp1 net1 net1 VDD VDD sg13_lv_pmos w=2.30u l=2u ng=1 m=1 mm_ok=1
XM_mn1 net1 I_bias VSS VSS sg13_lv_nmos w=0.87u l=2u ng=1 m=1 mm_ok=1
XM_refn I_bias I_bias VSS VSS sg13_lv_nmos w=0.87u l=2u ng=1 m=1 mm_ok=1
XM_mp2 V_bn1 net1 VDD VDD sg13_lv_pmos w=11.50u l=2u ng=2 m=1 mm_ok=1
XM_mp3 V_bn2 net1 VDD VDD sg13_lv_pmos w=23u l=2u ng=4 m=1 mm_ok=1
XM_bn1 V_bn1 V_bn1 net2 VSS sg13_lv_nmos w=1.60u l=2u ng=1 m=1 mm_ok=1
XM_bn2 V_bn2 V_bn2 VSS VSS sg13_lv_nmos w=9.21u l=2u ng=1 m=1 mm_ok=1
XM_mn2 V_btail I_bias VSS VSS sg13_lv_nmos w=6u l=2u ng=1 m=1 mm_ok=1
XM_rep_tail V_btail V_btail VDD VDD sg13_lv_pmos w=7.46u l=2u ng=1 m=8 mm_ok=1
XM_mn4 N_B I_bias VSS VSS sg13_lv_nmos w=3.2u l=2u ng=1 m=1 mm_ok=1
XC1 F2 V_out cap_cmomf w=22e-6 l=22e-6 mmin=1 mmax=4 subblock=0 m=1 mm_ok=1
XC2 net7 V_out cap_cmomf w=15.44e-6 l=15.44e-6 mmin=1 mmax=4 subblock=0 m=1 mm_ok=1
XR1 net2 VSS VSS rhigh w=0.5e-6 l=15e-6 m=1 b=0 mm_ok=1
XM_mp4 V_ctrln net1 VDD VDD sg13_lv_pmos w=4.60u l=2u ng=1 m=1 mm_ok=1
XM_rep_ctrln V_ctrln V_ctrln net3 VSS sg13_lv_nmos w=0.84u l=0.5u ng=1 m=1 mm_ok=1
XM_rep_outn net3 net3 VSS VSS sg13_lv_nmos w=2.10u l=0.5u ng=1 m=1 mm_ok=1
XM_mn3 V_ctrlp I_bias VSS VSS sg13_lv_nmos w=1.74u l=2u ng=1 m=1 mm_ok=1
XM_rep_outp net4 net4 VDD VDD sg13_lv_pmos w=5.55u l=0.5u ng=1 m=1 mm_ok=1
XM_rep_ctrlp V_ctrlp V_ctrlp net4 VDD sg13_lv_pmos w=2.20u l=0.50u ng=1 m=1 mm_ok=1
XM_mp5 N_A net1 VDD VDD sg13_lv_pmos w=9.21u l=2u ng=1 m=1 mm_ok=1
XR2 N_A net7 VSS rhigh w=0.5e-6 l=4e-6 m=1 b=0 mm_ok=1
.ends

.GLOBAL VDD
.end
