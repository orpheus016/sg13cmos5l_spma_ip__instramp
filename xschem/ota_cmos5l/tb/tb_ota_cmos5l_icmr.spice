** sch_path: /foss/designs/sg13cmos5l_spma_ip__instramp/xschem/instramp_cmos5l/tb/tb_instramp_cmos5l_icmr/tb_ota_cmos5l_icmr.sch
**.subckt tb_ota_cmos5l_icmr
C1 OUT3 0 3p
I0 I_B VSS 4.2u
V1 VDD VSS 1.2
V2 VSS 0 0
V3 VINP3 VSS 0.6
x2 VSS VDD I_B VINN3 OUT3 VINP3 VCM instramp_cmos5l
V4 VINN3 VSS 0.6
V5 VCM VSS 0.6
**** begin user architecture code

.lib cornerMOSlv.lib mos_tt
.lib cornerMOShv.lib mos_tt
.lib cornerRES.lib res_typ
.lib cornerDIO.lib dio_tt
.lib cornerCAP.lib cap_typ
.lib cornerMOSCAP.lib moscap_tt

.param temp=27
.param cl=3p
.param ib=1.4u
.param vdd=1.2
.param vicm=vdd/2
.param vid=0

.param temp=27

.control
destroy all
save all
shell mkdir -p result

alter @v3[acmag] = 0

dc v3 0 1.2 2m

let v_in  = v(vinp3)
let v_out = v(out3)

let track_error_mv = abs(v_out - v_in) * 1000

let buffer_gain = deriv(v_out)

* Extract linear ICMR boundary points
* Threshold set at buffer gain > 0.98 (2% gain error margin)
meas dc icmr_min when buffer_gain=0.98 rise=1
meas dc icmr_max when buffer_gain=0.98 fall=1
let icmr_span = icmr_max - icmr_min

write ./result/tb_cg_ota_icmr.raw v_in v_out buffer_gain track_error_mv

* Print summary report to ngspice terminal console
echo "======================================================="
echo "       INPUT COMMON-MODE RANGE (ICMR) RESULTS          "
echo "======================================================="
echo "  Lower ICMR Bound (Vmin, Gain > 0.98) : " $&icmr_min " V"
echo "  Upper ICMR Bound (Vmax, Gain > 0.98) : " $&icmr_max " V"
echo "  Total Linear ICMR Span               : " $&icmr_span " V"
echo "======================================================="

* Display transfer characteristics and tracking performance curves
plot v_out vs v_in
plot buffer_gain vs v_in
plot track_error_mv vs v_in

.endc

**** end user architecture code
**.ends

* expanding   symbol:  /foss/designs/sg13cmos5l_spma_ip__instramp/xschem/instramp_cmos5l/instramp_cmos5l.sym # of pins=7
** sym_path: /foss/designs/sg13cmos5l_spma_ip__instramp/xschem/instramp_cmos5l/instramp_cmos5l.sym
** sch_path: /foss/designs/sg13cmos5l_spma_ip__instramp/xschem/instramp_cmos5l/instramp_cmos5l.sch
.subckt instramp_cmos5l VSS VDD IBIAS VINN VOUT VINP CM
*.iopin VDD
*.iopin IBIAS
*.iopin VSS
*.iopin CM
*.iopin VOUT
*.iopin VINN
*.iopin VINP
x1 VSS IBIAS VDD net3 VINP net4 ota_cmos5l
x2 VSS IBIAS VDD net1 VINN net2 ota_cmos5l
x3 VSS IBIAS VDD net5 net6 VOUT ota_cmos5l
XR1 net4 net6 VSS rhigh w=0.5e-6 l=2e-6 m=1 b=0 mm_ok=1
XR2 net2 net5 VSS rhigh w=0.5e-6 l=2e-6 m=1 b=0 mm_ok=1
XR3 net6 CM VSS rhigh w=0.5e-6 l=8*2.23e-6 m=1 b=0 mm_ok=1
XR4 net5 VOUT VSS rhigh w=0.5e-6 l=8*2.23e-6 m=1 b=0 mm_ok=1
R5 VINN CM 10MEG
R6 CM VINP 10MEG
XR7 net2 net1 VSS rhigh w=0.5e-6 l=2e-6 m=1 b=0 mm_ok=1
XR8 net4 net3 VSS rhigh w=0.5e-6 l=2e-6 m=1 b=0 mm_ok=1
.ends

* expanding   symbol:  /foss/designs/sg13cmos5l_spma_ip__instramp/xschem/ota_cmos5l/ota_cmos5l.sym # of pins=6
** sym_path: /foss/designs/sg13cmos5l_spma_ip__instramp/xschem/ota_cmos5l/ota_cmos5l.sym
** sch_path: /foss/designs/sg13cmos5l_spma_ip__instramp/xschem/ota_cmos5l/ota_cmos5l.sch
.subckt ota_cmos5l VSS IBIAS VDD VINN VINP VOUT
*.iopin IBIAS
*.iopin VDD
*.iopin VSS
*.iopin VOUT
*.iopin VINP
*.iopin VINN
XM6 IBIAS IBIAS VDD VDD sg13_lv_pmos w={wbias} l={lbias} ng=1 m={m6} mm_ok=1
XM7 net1 IBIAS VDD VDD sg13_lv_pmos w={wbias} l={lbias} ng=1 m={m7} mm_ok=1
XM8 VOUT IBIAS VDD VDD sg13_lv_pmos w={wbias} l={lbias} ng=1 m={m8} mm_ok=1
XM1 net2 VINN net1 VDD sg13_lv_pmos w={winpair} l={linpair} ng=1 m=1 mm_ok=1
XM2 net3 VINP net1 VDD sg13_lv_pmos w={winpair} l={linpair} ng=1 m=1 mm_ok=1
XM3 net2 net2 VSS VSS sg13_lv_nmos w={wload} l={lload} ng=1 m=1 mm_ok=1
XM4 net3 net2 VSS VSS sg13_lv_nmos w={wload} l={lload} ng=1 m=1 mm_ok=1
XM5 VOUT net3 VSS VSS sg13_lv_nmos w={wcs} l={lcs} ng=1 m=1 mm_ok=1
XR1 net3 net4 VSS rhigh w=0.5e-6 l=1.95e-6 m=1 b=0 mm_ok=1
.save v(vinp)
.save v(vinn)
.save v(vout)
XC2 VOUT net4 cap_cmomi w=15e-6 l=15e-6 mmin=1 mmax=4 feed=double subblock=0 m=5 mm_ok=1
**** begin user architecture code

.param temp=27
.param lbias=0.15u wbias=0.15u
.param m6=1 m7=4 m8=8
.param linpair=3u winpair=20u
.param lload=5u wload=10u
.param lcs=3u wcs=20u
.param Cc=2p

**** end user architecture code
XC1 VOUT net4 cap_cmomi w=15e-6 l=15e-6 mmin=1 mmax=4 feed=double subblock=0 m=4 mm_ok=1
.ends

.GLOBAL VDD
.end
