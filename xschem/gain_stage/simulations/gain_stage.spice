** sch_path: /foss/designs/Chipalooza/Programmable-Instrumentation-Amplifier-IP/xschem/gain_stage/gain_stage.sch
**.subckt gain_stage AVDD AVSS IBIAS VIN VCM VOUT s[0] s[1] s[2] s[3] s[4]
*.iopin AVDD
*.iopin AVSS
*.ipin IBIAS
*.ipin VIN
*.ipin VCM
*.opin VOUT
*.ipin s[0]
*.ipin s[1]
*.ipin s[2]
*.ipin s[3]
*.ipin s[4]
x_nor3 nor3_out s[0] s[1] s[2] AVDD AVSS sg13cmos5l_nor3_1
x_nor2 nor2_out s[3] s[4] AVDD AVSS sg13cmos5l_nor2_1
x_and2 S0 nor3_out nor2_out AVDD AVSS sg13cmos5l_and2_1
x_core s[3] s[4] S0 s[1] s[0] s[2] AVDD VCM VIN VOUT IBIAS AVSS gain_network
**.ends

* expanding   symbol:  gain_network.sym # of pins=12
** sym_path: /foss/designs/Chipalooza/Programmable-Instrumentation-Amplifier-IP/xschem/gain_stage/gain_network.sym
** sch_path: /foss/designs/Chipalooza/Programmable-Instrumentation-Amplifier-IP/xschem/gain_stage/gain_network.sch
.subckt gain_network S4 S5 S0 S2 S1 S3 AVDD V_CM V_IN2 V_OUT2 I_BIAS AVSS
*.ipin I_BIAS
*.ipin V_IN2
*.ipin V_CM
*.ipin AVSS
*.ipin AVDD
*.opin V_OUT2
*.ipin S5
*.ipin S4
*.ipin S3
*.ipin S2
*.ipin S1
*.ipin S0
XR7 net6 net5 AVSS rhigh w=0.5e-6 l=10.72e-6 m=1 b=0 mm_ok=1
XR3 net2 net1 AVSS rppd w=2e-6 l=15.16e-6 m=1 b=0 mm_ok=1
XR2 net1 V_OUT2 AVSS rppd w=2e-6 l=7e-6 m=1 b=0 mm_ok=1
XR1 net7 V_IN2 AVSS rppd w=2e-6 l=15.16e-6 m=1 b=0 mm_ok=1
x13 net8 S5 AVDD AVSS sg13cmos5l_inv_1
x12 net9 S4 AVDD AVSS sg13cmos5l_inv_1
x11 net10 S3 AVDD AVSS sg13cmos5l_inv_1
x10 net11 S2 AVDD AVSS sg13cmos5l_inv_1
x9 net12 S1 AVDD AVSS sg13cmos5l_inv_1
x8 net13 S0 AVDD AVSS sg13cmos5l_inv_1
x7 net7 AVSS AVDD S5 net8 net6 tgate l=0.13e-6 wn=0.9e-6 wp=2.7e-6
x6 net7 AVSS AVDD S4 net9 net5 tgate l=0.13e-6 wn=1.5e-6 wp=4.5e-6
x5 net7 AVSS AVDD S3 net10 net4 tgate l=0.13e-6 wn=2.2e-6 wp=6.6e-6
x4 net7 AVSS AVDD S2 net11 net3 tgate l=0.13e-6 wn=2.6e-6 wp=7.8e-6
x3 net7 AVSS AVDD S1 net12 net2 tgate l=0.13e-6 wn=2.9e-6 wp=8.7e-6
x2 net7 AVSS AVDD S0 net13 net1 tgate l=0.13e-6 wn=3e-6 wp=9e-6
XR6 net5 net4 AVSS rhigh w=0.5e-6 l=5.3e-6 m=1 b=0 mm_ok=1
XR5 net4 net3 AVSS rhigh w=0.5e-6 l=2.6e-6 m=1 b=0 mm_ok=1
XR4 net3 net2 AVSS rhigh w=0.5e-6 l=1.25e-6 m=1 b=0 mm_ok=1
x1 AVDD V_CM net7 V_OUT2 I_BIAS AVSS gain_ota
.ends

* expanding   symbol:  tgate.sym # of pins=6
** sym_path: /foss/designs/Chipalooza/Programmable-Instrumentation-Amplifier-IP/xschem/tgate/tgate.sym
** sch_path: /foss/designs/Chipalooza/Programmable-Instrumentation-Amplifier-IP/xschem/tgate/tgate.sch
.subckt tgate IN AVSS AVDD EN ENB OUT  l=0.13e-6 wn=1e-6 wp=3e-6
*.iopin AVDD
*.iopin AVSS
*.iopin IN
*.iopin OUT
*.ipin EN
*.ipin ENB
XM1 IN EN OUT AVSS sg13_lv_nmos w=wn l=l ng=1 m=1 mm_ok=1
XM2 OUT ENB IN AVDD sg13_lv_pmos w=wp l=l ng=1 m=1 mm_ok=1
.ends

* expanding   symbol:  gain_ota.sym # of pins=6
** sym_path: /foss/designs/Chipalooza/Programmable-Instrumentation-Amplifier-IP/xschem/gain_stage/gain_ota.sym
** sch_path: /foss/designs/Chipalooza/Programmable-Instrumentation-Amplifier-IP/xschem/gain_stage/gain_ota.sch
.subckt gain_ota VDD V_inp V_inn V_out I_bias VSS
*.ipin V_inn
*.ipin VDD
*.ipin VSS
*.opin V_out
*.ipin I_bias
*.ipin V_inp
XM1 F1 V_inn net6 VDD sg13_lv_pmos w=26.56u l=2u ng=4 m=1 mm_ok=1
XM2 F2 V_inp net6 VDD sg13_lv_pmos w=26.56u l=2u ng=4 m=1 mm_ok=1
XM3 net5 net5 VDD VDD sg13_lv_pmos w=7.33u l=2u ng=1 m=1 mm_ok=1
XM4 N_A net5 VDD VDD sg13_lv_pmos w=7.33u l=2u ng=1 m=1 mm_ok=1
XM7 F1 V_bn2 VSS VSS sg13_lv_nmos w=9.21u l=2u ng=1 m=1 mm_ok=1
XM8 F2 V_bn2 VSS VSS sg13_lv_nmos w=9.21u l=2u ng=1 m=1 mm_ok=1
XM_tail net6 V_btail VDD VDD sg13_lv_pmos w=7.46u l=2u ng=1 m=8 mm_ok=1
XM_ctrlp N_B V_ctrlp N_A VDD sg13_lv_pmos w=2.20u l=0.50u ng=1 m=1 mm_ok=1
XM_outp V_out N_A VDD VDD sg13_lv_pmos w=22.20u l=0.5u ng=4 m=1 mm_ok=1
XM_ctrln N_A V_ctrln N_B VSS sg13_lv_nmos w=0.84u l=0.5u ng=1 m=1 mm_ok=1
XM_outn V_out N_B VSS VSS sg13_lv_nmos w=8.4u l=0.5u ng=1 m=1 mm_ok=1
XM5 net5 V_bn1 F1 VSS sg13_lv_nmos w=6.41u l=2u ng=1 m=1 mm_ok=1
XM6 N_A V_bn1 F2 VSS sg13_lv_nmos w=6.41u l=2u ng=1 m=1 mm_ok=1
XM_mp1 net1 net1 VDD VDD sg13_lv_pmos w=2.30u l=2u ng=1 m=1 mm_ok=1
XM_mn1 net1 I_bias VSS VSS sg13_lv_nmos w=0.87u l=2u ng=1 m=1 mm_ok=1
XM_refn I_bias I_bias VSS VSS sg13_lv_nmos w=0.87u l=2u ng=1 m=1 mm_ok=1
XM_mp2 V_bn1 net1 VDD VDD sg13_lv_pmos w=11.50u l=2u ng=2 m=1 mm_ok=1
XM_mp3 V_bn2 net1 VDD VDD sg13_lv_pmos w=23u l=2u ng=4 m=1 mm_ok=1
XM_bn1 V_bn1 V_bn1 net2 VSS sg13_lv_nmos w=1.60u l=2u ng=1 m=1 mm_ok=1
XM_bn2 V_bn2 V_bn2 VSS VSS sg13_lv_nmos w=9.21u l=2u ng=1 m=1 mm_ok=1
XM_mn2 V_btail I_bias VSS VSS sg13_lv_nmos w=6u l=2u ng=1 m=1 mm_ok=1
XM_rep_tail V_btail V_btail VDD VDD sg13_lv_pmos w=7.46u l=2u ng=1 m=8 mm_ok=1
XM_mn4 N_B I_bias VSS VSS sg13_lv_nmos w=3.2u l=2u ng=1 m=1 mm_ok=1
XR1 net2 VSS VSS rhigh w=0.5e-6 l=15e-6 m=1 b=0 mm_ok=1
XM_mp4 V_ctrln net1 VDD VDD sg13_lv_pmos w=4.60u l=2u ng=1 m=1 mm_ok=1
XM_rep_ctrln V_ctrln V_ctrln net3 VSS sg13_lv_nmos w=0.84u l=0.5u ng=1 m=1 mm_ok=1
XM_rep_outn net3 net3 VSS VSS sg13_lv_nmos w=2.10u l=0.5u ng=1 m=1 mm_ok=1
XM_mn3 V_ctrlp I_bias VSS VSS sg13_lv_nmos w=1.74u l=2u ng=1 m=1 mm_ok=1
XM_rep_outp net4 net4 VDD VDD sg13_lv_pmos w=5.55u l=0.5u ng=1 m=1 mm_ok=1
XM_rep_ctrlp V_ctrlp V_ctrlp net4 VDD sg13_lv_pmos w=2.20u l=0.50u ng=1 m=1 mm_ok=1
XM_mp5 N_A net1 VDD VDD sg13_lv_pmos w=9.21u l=2u ng=1 m=1 mm_ok=1
XR2 N_A net7 VSS rhigh w=0.5e-6 l=4e-6 m=1 b=0 mm_ok=1
XC3 F2 V_out cap_cmomi w=25e-6 l=25e-6 mmin=1 mmax=4 feed=double subblock=0 m=1 mm_ok=1
XC4 net7 V_out cap_cmomi w=8.5e-6 l=8.5e-6 mmin=1 mmax=4 feed=double subblock=0 m=1 mm_ok=1
XC1 net7 V_out cap_cmomi w=8.5e-6 l=8.5e-6 mmin=1 mmax=4 feed=double subblock=0 m=1 mm_ok=1
XC2 net7 V_out cap_cmomi w=8.5e-6 l=8.5e-6 mmin=1 mmax=4 feed=double subblock=0 m=1 mm_ok=1
XC5 net7 V_out cap_cmomi w=8.5e-6 l=8.5e-6 mmin=1 mmax=4 feed=double subblock=0 m=1 mm_ok=1
.ends

.end
