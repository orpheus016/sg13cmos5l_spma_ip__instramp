** sch_path: /foss/designs/sg13cmos5l_spma_ip__instramp/xschem/ota_cmos5l/tb/tb_ota_cmos5l_psrr/tb_ota_cmos5l_psrr.sch
**.subckt tb_ota_cmos5l_psrr
x1 vss ibias VDD out vinp out ota_cmos5l
C1 out 0 3p
I0 ibias vss 1.4u
V1 VDD vss 1.2
V2 vss 0 0
V3 vinp vss 0.6
**** begin user architecture code

.param temp=27
.param lbias=0.15u wbias=0.15u
.param m6=1 m7=4 m8=8
.param linpair=3u winpair=20u
.param lload=5u wload=10u
.param lcs=3u wcs=20u
.param Cc=2p
.ac dec

.control
save all

** Set sources
alter @V1[AC] = 1

** Simulations
ac dec 100 1 10G

** Plots
setplot ac1
let psrr_db = -db(v(out))
plot psrr_db

** Measurements
meas ac PSRR_gain FIND psrr_db AT=10Hz
let psrr_3db = PSRR_gain + 3
meas ac f_3db WHEN psrr_db=$&psrr_3db

write tb_ota_cmos5l_psrr.raw

.endc
* ngspice commands

.lib cornerMOSlv.lib mos_tt
.lib cornerMOShv.lib mos_tt
.lib cornerRES.lib res_typ
.lib cornerDIO.lib dio_tt
.lib cornerCAP.lib cap_typ
.lib cornerMOSCAP.lib moscap_tt

**** end user architecture code
**.ends

* expanding   symbol:  /foss/designs/sg13cmos5l_spma_ip__instramp/xschem/ota_cmos5l/ota_cmos5l.sym # of pins=6
** sym_path: /foss/designs/sg13cmos5l_spma_ip__instramp/xschem/ota_cmos5l/ota_cmos5l.sym
** sch_path: /foss/designs/sg13cmos5l_spma_ip__instramp/xschem/ota_cmos5l/ota_cmos5l.sch
.subckt ota_cmos5l VSS IBIAS VDD VINN VINP VOUT
*.iopin IBIAS
*.iopin VDD
*.iopin VSS
*.iopin VOUT
*.iopin VINP
*.iopin VINN
XM6 net1 net1 vdd vdd sg13_lv_pmos w={wbias} l={lbias} ng=1 m={m6} mm_ok=1
XM7 net5 net1 vdd vdd sg13_lv_pmos w={wbias} l={lbias} ng=1 m={m7} mm_ok=1
XM8 net6 net1 vdd vdd sg13_lv_pmos w={wbias} l={lbias} ng=1 m={m8} mm_ok=1
XM1 net7 VINN net2 vdd sg13_lv_pmos w={winpair} l={linpair} ng=1 m=1 mm_ok=1
XM2 net8 VINP net2 vdd sg13_lv_pmos w={winpair} l={linpair} ng=1 m=1 mm_ok=1
XM3 net3 net3 VSS VSS sg13_lv_nmos w={wload} l={lload} ng=1 m=1 mm_ok=1
XM4 net4 net3 VSS VSS sg13_lv_nmos w={wload} l={lload} ng=1 m=1 mm_ok=1
XM5 net9 net4 VSS VSS sg13_lv_nmos w={wcs} l={lcs} ng=1 m=1 mm_ok=1
XR1 net4 net10 vss rhigh w=0.5e-6 l=1.95e-6 m=1 b=0 mm_ok=1
VIBIAS net1 IBIAS 0
.save i(vibias)
VID7 net5 net2 0
.save i(vid7)
VID8 net6 VOUT 0
.save i(vid8)
.save v(vinp)
.save v(vinn)
.save v(vout)
VID1 net7 net3 0
.save i(vid1)
VID2 net8 net4 0
.save i(vid2)
VID5 VOUT net9 0
.save i(vid5)
XC2 net9 net10 cap_cmomi w=15e-6 l=15e-6 mmin=1 mmax=4 feed=double subblock=0 m=9 mm_ok=1
.ends

.GLOBAL VDD
.end
