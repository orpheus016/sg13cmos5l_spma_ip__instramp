** sch_path: /foss/designs/sg13cmos5l_spma_ip__instramp/xschem/instramp_cmos5l/tb/tb_instramp_cmos5l_noise/tb_instramp_cmos5l_noise.sch
**.subckt tb_instramp_cmos5l_noise
C1 out 0 3p
I0 ibias vss 4.2u
V1 VDD vss 1.2
V2 vss 0 0
V3 vinp vss 0.6
V4 vinn vss 0.6
x1 vss VDD ibias vinn out vinp vcm instramp_cmos5l
V5 vcm vss 0.6
**** begin user architecture code

.lib cornerMOSlv.lib mos_tt
.lib cornerMOShv.lib mos_tt
.lib cornerRES.lib res_typ
.lib cornerDIO.lib dio_tt
.lib cornerCAP.lib cap_typ
.lib cornerMOSCAP.lib moscap_tt

.param temp=27
.param cl=3p
.param ib=1.4u
.param vdd=1.2
.param vicm=vdd/2
.param vid=0

.param temp=27

.control
save all
destroy all
shell mkdir -p result

* Noise referred to V3 (VINP): gain VINP->OUT = Adm, so inoise = differential-input noise.
* VINN / VCM are held at DC.
alter @v3[acmag]=1
noise v(out) v3 dec 20 10 100MEG
alter @v3[acmag]=0

setplot noise1

* Parameters #1
let inoise_total_uv = noise2.inoise_total * 1e6
let onoise_total_uv = noise2.onoise_total * 1e6
let irn_nv = noise1.inoise_spectrum * 1e9
let orn_nv = noise1.onoise_spectrum * 1e9

* inoise_total integrates out to 100 MHz where the closed-loop gain has rolled off, so it is
* inflated. In-band equivalent = output noise / low-frequency gain (gain = onoise/inoise @ 10 Hz).
let gain_lf = noise1.onoise_spectrum[0] / noise1.inoise_spectrum[0]
let inoise_eq_uv = onoise_total_uv / gain_lf

* IRN extraction at certain frequencies (20 pts/dec from 10 Hz)
let irn_10 = irn_nv[0]
let irn_100 = irn_nv[20]
let irn_1k = irn_nv[40]
let irn_10k = irn_nv[60]
let irn_100k = irn_nv[80]
let irn_1meg = irn_nv[100]

write ./result/tb_instramp_cmos5l_noise.raw irn_nv orn_nv inoise_spectrum onoise_spectrum

echo "======================================================="
echo " Total Output Noise (10 Hz - 100 MHz): " $&onoise_total_uv " uV_rms"
echo " Total Input Noise (10 Hz - 100 MHz): " $&inoise_total_uv " uV_rms (inflated, see above)"
echo " In-band Input-Referred (Vout_n/Gain): " $&inoise_eq_uv " uV_rms"
echo "-------------------------------------------------------"
echo " IRN @ 10 Hz (Flicker Noise): " $&irn_10 " nV/sqrt(Hz)"
echo " IRN @ 100 Hz: " $&irn_100 " nV/sqrt(Hz)"
echo " IRN @ 1 kHz: " $&irn_1k " nV/sqrt(Hz)"
echo " IRN @ 10 kHz: " $&irn_10k " nV/sqrt(Hz)"
echo " IRN @ 100 kHz: " $&irn_100k " nV/sqrt(Hz)"
echo " IRN @ 1 MHz (Thermal Noise Floor): " $&irn_1meg " nV/sqrt(Hz)"
echo "======================================================="

plot irn_nv orn_nv loglog
.endc

**** end user architecture code
**.ends

* expanding   symbol:  /foss/designs/sg13cmos5l_spma_ip__instramp/xschem/instramp_cmos5l/instramp_cmos5l.sym # of pins=7
** sym_path: /foss/designs/sg13cmos5l_spma_ip__instramp/xschem/instramp_cmos5l/instramp_cmos5l.sym
** sch_path: /foss/designs/sg13cmos5l_spma_ip__instramp/xschem/instramp_cmos5l/instramp_cmos5l.sch
.subckt instramp_cmos5l VSS VDD IBIAS VINN VOUT VINP CM
*.iopin VDD
*.iopin IBIAS
*.iopin VSS
*.iopin CM
*.iopin VOUT
*.iopin VINN
*.iopin VINP
x1 VSS IBIAS VDD net3 VINP net4 ota_cmos5l
x2 VSS IBIAS VDD net1 VINN net2 ota_cmos5l
x3 VSS IBIAS VDD net5 net6 VOUT ota_cmos5l
XR1 net4 net6 VSS rhigh w=0.5e-6 l=2e-6 m=1 b=0 mm_ok=1
XR2 net2 net5 VSS rhigh w=0.5e-6 l=2e-6 m=1 b=0 mm_ok=1
XR3 net6 CM VSS rhigh w=0.5e-6 l=8*2.23e-6 m=1 b=0 mm_ok=1
XR4 net5 VOUT VSS rhigh w=0.5e-6 l=8*2.23e-6 m=1 b=0 mm_ok=1
R5 VINN CM 10MEG
R6 CM VINP 10MEG
XR7 net2 net1 VSS rhigh w=0.5e-6 l=2e-6 m=1 b=0 mm_ok=1
XR8 net4 net3 VSS rhigh w=0.5e-6 l=2e-6 m=1 b=0 mm_ok=1
.ends

* expanding   symbol:  /foss/designs/sg13cmos5l_spma_ip__instramp/xschem/ota_cmos5l/ota_cmos5l.sym # of pins=6
** sym_path: /foss/designs/sg13cmos5l_spma_ip__instramp/xschem/ota_cmos5l/ota_cmos5l.sym
** sch_path: /foss/designs/sg13cmos5l_spma_ip__instramp/xschem/ota_cmos5l/ota_cmos5l.sch
.subckt ota_cmos5l VSS IBIAS VDD VINN VINP VOUT
*.iopin IBIAS
*.iopin VDD
*.iopin VSS
*.iopin VOUT
*.iopin VINP
*.iopin VINN
XM6 IBIAS IBIAS VDD VDD sg13_lv_pmos w={wbias} l={lbias} ng=1 m={m6} mm_ok=1
XM7 net1 IBIAS VDD VDD sg13_lv_pmos w={wbias} l={lbias} ng=1 m={m7} mm_ok=1
XM8 VOUT IBIAS VDD VDD sg13_lv_pmos w={wbias} l={lbias} ng=1 m={m8} mm_ok=1
XM1 net2 VINN net1 VDD sg13_lv_pmos w={winpair} l={linpair} ng=1 m=1 mm_ok=1
XM2 net3 VINP net1 VDD sg13_lv_pmos w={winpair} l={linpair} ng=1 m=1 mm_ok=1
XM3 net2 net2 VSS VSS sg13_lv_nmos w={wload} l={lload} ng=1 m=1 mm_ok=1
XM4 net3 net2 VSS VSS sg13_lv_nmos w={wload} l={lload} ng=1 m=1 mm_ok=1
XM5 VOUT net3 VSS VSS sg13_lv_nmos w={wcs} l={lcs} ng=1 m=1 mm_ok=1
XR1 net3 net4 VSS rhigh w=0.5e-6 l=1.95e-6 m=1 b=0 mm_ok=1
.save v(vinp)
.save v(vinn)
.save v(vout)
XC2 VOUT net4 cap_cmomi w=15e-6 l=15e-6 mmin=1 mmax=4 feed=double subblock=0 m=5 mm_ok=1
**** begin user architecture code

.param temp=27
.param lbias=0.15u wbias=0.15u
.param m6=1 m7=4 m8=8
.param linpair=3u winpair=20u
.param lload=5u wload=10u
.param lcs=3u wcs=20u
.param Cc=2p

**** end user architecture code
XC1 VOUT net4 cap_cmomi w=15e-6 l=15e-6 mmin=1 mmax=4 feed=double subblock=0 m=4 mm_ok=1
.ends

.GLOBAL VDD
.end
